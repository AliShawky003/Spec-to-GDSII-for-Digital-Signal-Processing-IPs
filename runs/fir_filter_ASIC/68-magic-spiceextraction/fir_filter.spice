* NGSPICE file created from fir_filter.ext - technology: sky130A

* Black-box entry subcircuit for sky130_fd_sc_hd__fill_1 abstract view
.subckt sky130_fd_sc_hd__fill_1 VGND VNB VPB VPWR
.ends

* Black-box entry subcircuit for sky130_fd_sc_hd__fill_2 abstract view
.subckt sky130_fd_sc_hd__fill_2 VGND VNB VPB VPWR
.ends

* Black-box entry subcircuit for sky130_fd_sc_hd__decap_3 abstract view
.subckt sky130_fd_sc_hd__decap_3 VGND VNB VPB VPWR
.ends

* Black-box entry subcircuit for sky130_fd_sc_hd__xnor2_2 abstract view
.subckt sky130_fd_sc_hd__xnor2_2 A B VGND VNB VPB VPWR Y
.ends

* Black-box entry subcircuit for sky130_fd_sc_hd__a21o_2 abstract view
.subckt sky130_fd_sc_hd__a21o_2 A1 A2 B1 VGND VNB VPB VPWR X
.ends

* Black-box entry subcircuit for sky130_fd_sc_hd__xor2_2 abstract view
.subckt sky130_fd_sc_hd__xor2_2 A B VGND VNB VPB VPWR X
.ends

* Black-box entry subcircuit for sky130_fd_sc_hd__tapvpwrvgnd_1 abstract view
.subckt sky130_fd_sc_hd__tapvpwrvgnd_1 VGND VPWR
.ends

* Black-box entry subcircuit for sky130_fd_sc_hd__nor2_2 abstract view
.subckt sky130_fd_sc_hd__nor2_2 A B VGND VNB VPB VPWR Y
.ends

* Black-box entry subcircuit for sky130_fd_sc_hd__and2_2 abstract view
.subckt sky130_fd_sc_hd__and2_2 A B VGND VNB VPB VPWR X
.ends

* Black-box entry subcircuit for sky130_fd_sc_hd__or2_2 abstract view
.subckt sky130_fd_sc_hd__or2_2 A B VGND VNB VPB VPWR X
.ends

* Black-box entry subcircuit for sky130_fd_sc_hd__nand2_2 abstract view
.subckt sky130_fd_sc_hd__nand2_2 A B VGND VNB VPB VPWR Y
.ends

* Black-box entry subcircuit for sky130_fd_sc_hd__mux2_2 abstract view
.subckt sky130_fd_sc_hd__mux2_2 A0 A1 S VGND VNB VPB VPWR X
.ends

* Black-box entry subcircuit for sky130_fd_sc_hd__buf_1 abstract view
.subckt sky130_fd_sc_hd__buf_1 A VGND VNB VPB VPWR X
.ends

* Black-box entry subcircuit for sky130_fd_sc_hd__a31oi_2 abstract view
.subckt sky130_fd_sc_hd__a31oi_2 A1 A2 A3 B1 VGND VNB VPB VPWR Y
.ends

* Black-box entry subcircuit for sky130_fd_sc_hd__clkbuf_2 abstract view
.subckt sky130_fd_sc_hd__clkbuf_2 A VGND VNB VPB VPWR X
.ends

* Black-box entry subcircuit for sky130_fd_sc_hd__a22o_2 abstract view
.subckt sky130_fd_sc_hd__a22o_2 A1 A2 B1 B2 VGND VNB VPB VPWR X
.ends

* Black-box entry subcircuit for sky130_fd_sc_hd__or2b_2 abstract view
.subckt sky130_fd_sc_hd__or2b_2 A B_N VGND VNB VPB VPWR X
.ends

* Black-box entry subcircuit for sky130_fd_sc_hd__dlygate4sd3_1 abstract view
.subckt sky130_fd_sc_hd__dlygate4sd3_1 A VGND VNB VPB VPWR X
.ends

* Black-box entry subcircuit for sky130_fd_sc_hd__buf_2 abstract view
.subckt sky130_fd_sc_hd__buf_2 A VGND VNB VPB VPWR X
.ends

* Black-box entry subcircuit for sky130_fd_sc_hd__and3_2 abstract view
.subckt sky130_fd_sc_hd__and3_2 A B C VGND VNB VPB VPWR X
.ends

* Black-box entry subcircuit for sky130_fd_sc_hd__a21oi_2 abstract view
.subckt sky130_fd_sc_hd__a21oi_2 A1 A2 B1 VGND VNB VPB VPWR Y
.ends

* Black-box entry subcircuit for sky130_fd_sc_hd__dfrtp_2 abstract view
.subckt sky130_fd_sc_hd__dfrtp_2 CLK D RESET_B VGND VNB VPB VPWR Q
.ends

* Black-box entry subcircuit for sky130_fd_sc_hd__a2111oi_4 abstract view
.subckt sky130_fd_sc_hd__a2111oi_4 A1 A2 B1 C1 D1 VGND VNB VPB VPWR Y
.ends

* Black-box entry subcircuit for sky130_fd_sc_hd__o21ai_2 abstract view
.subckt sky130_fd_sc_hd__o21ai_2 A1 A2 B1 VGND VNB VPB VPWR Y
.ends

* Black-box entry subcircuit for sky130_fd_sc_hd__a21oi_4 abstract view
.subckt sky130_fd_sc_hd__a21oi_4 A1 A2 B1 VGND VNB VPB VPWR Y
.ends

* Black-box entry subcircuit for sky130_fd_sc_hd__a2111o_2 abstract view
.subckt sky130_fd_sc_hd__a2111o_2 A1 A2 B1 C1 D1 VGND VNB VPB VPWR X
.ends

* Black-box entry subcircuit for sky130_fd_sc_hd__or4_2 abstract view
.subckt sky130_fd_sc_hd__or4_2 A B C D VGND VNB VPB VPWR X
.ends

* Black-box entry subcircuit for sky130_fd_sc_hd__and3b_2 abstract view
.subckt sky130_fd_sc_hd__and3b_2 A_N B C VGND VNB VPB VPWR X
.ends

* Black-box entry subcircuit for sky130_fd_sc_hd__a31o_2 abstract view
.subckt sky130_fd_sc_hd__a31o_2 A1 A2 A3 B1 VGND VNB VPB VPWR X
.ends

* Black-box entry subcircuit for sky130_fd_sc_hd__clkbuf_1 abstract view
.subckt sky130_fd_sc_hd__clkbuf_1 A VGND VNB VPB VPWR X
.ends

* Black-box entry subcircuit for sky130_fd_sc_hd__o21ba_2 abstract view
.subckt sky130_fd_sc_hd__o21ba_2 A1 A2 B1_N VGND VNB VPB VPWR X
.ends

* Black-box entry subcircuit for sky130_fd_sc_hd__o21a_2 abstract view
.subckt sky130_fd_sc_hd__o21a_2 A1 A2 B1 VGND VNB VPB VPWR X
.ends

* Black-box entry subcircuit for sky130_fd_sc_hd__clkbuf_4 abstract view
.subckt sky130_fd_sc_hd__clkbuf_4 A VGND VNB VPB VPWR X
.ends

* Black-box entry subcircuit for sky130_fd_sc_hd__buf_4 abstract view
.subckt sky130_fd_sc_hd__buf_4 A VGND VNB VPB VPWR X
.ends

* Black-box entry subcircuit for sky130_fd_sc_hd__nand3_2 abstract view
.subckt sky130_fd_sc_hd__nand3_2 A B C VGND VNB VPB VPWR Y
.ends

* Black-box entry subcircuit for sky130_fd_sc_hd__nor2b_2 abstract view
.subckt sky130_fd_sc_hd__nor2b_2 A B_N VGND VNB VPB VPWR Y
.ends

* Black-box entry subcircuit for sky130_fd_sc_hd__o31ai_2 abstract view
.subckt sky130_fd_sc_hd__o31ai_2 A1 A2 A3 B1 VGND VNB VPB VPWR Y
.ends

* Black-box entry subcircuit for sky130_fd_sc_hd__buf_8 abstract view
.subckt sky130_fd_sc_hd__buf_8 A VGND VNB VPB VPWR X
.ends

* Black-box entry subcircuit for sky130_fd_sc_hd__a211o_2 abstract view
.subckt sky130_fd_sc_hd__a211o_2 A1 A2 B1 C1 VGND VNB VPB VPWR X
.ends

* Black-box entry subcircuit for sky130_fd_sc_hd__or4_4 abstract view
.subckt sky130_fd_sc_hd__or4_4 A B C D VGND VNB VPB VPWR X
.ends

* Black-box entry subcircuit for sky130_fd_sc_hd__nand2_8 abstract view
.subckt sky130_fd_sc_hd__nand2_8 A B VGND VNB VPB VPWR Y
.ends

* Black-box entry subcircuit for sky130_fd_sc_hd__o31a_2 abstract view
.subckt sky130_fd_sc_hd__o31a_2 A1 A2 A3 B1 VGND VNB VPB VPWR X
.ends

* Black-box entry subcircuit for sky130_fd_sc_hd__a21o_4 abstract view
.subckt sky130_fd_sc_hd__a21o_4 A1 A2 B1 VGND VNB VPB VPWR X
.ends

* Black-box entry subcircuit for sky130_fd_sc_hd__diode_2 abstract view
.subckt sky130_fd_sc_hd__diode_2 DIODE VGND VNB VPB VPWR
.ends

* Black-box entry subcircuit for sky130_fd_sc_hd__nor2_4 abstract view
.subckt sky130_fd_sc_hd__nor2_4 A B VGND VNB VPB VPWR Y
.ends

* Black-box entry subcircuit for sky130_fd_sc_hd__inv_2 abstract view
.subckt sky130_fd_sc_hd__inv_2 A VGND VNB VPB VPWR Y
.ends

* Black-box entry subcircuit for sky130_fd_sc_hd__or3b_2 abstract view
.subckt sky130_fd_sc_hd__or3b_2 A B C_N VGND VNB VPB VPWR X
.ends

* Black-box entry subcircuit for sky130_fd_sc_hd__a211o_4 abstract view
.subckt sky130_fd_sc_hd__a211o_4 A1 A2 B1 C1 VGND VNB VPB VPWR X
.ends

* Black-box entry subcircuit for sky130_fd_sc_hd__o22a_2 abstract view
.subckt sky130_fd_sc_hd__o22a_2 A1 A2 B1 B2 VGND VNB VPB VPWR X
.ends

* Black-box entry subcircuit for sky130_fd_sc_hd__a211oi_4 abstract view
.subckt sky130_fd_sc_hd__a211oi_4 A1 A2 B1 C1 VGND VNB VPB VPWR Y
.ends

* Black-box entry subcircuit for sky130_fd_sc_hd__o21ai_4 abstract view
.subckt sky130_fd_sc_hd__o21ai_4 A1 A2 B1 VGND VNB VPB VPWR Y
.ends

* Black-box entry subcircuit for sky130_fd_sc_hd__a311o_2 abstract view
.subckt sky130_fd_sc_hd__a311o_2 A1 A2 A3 B1 C1 VGND VNB VPB VPWR X
.ends

* Black-box entry subcircuit for sky130_fd_sc_hd__xnor2_4 abstract view
.subckt sky130_fd_sc_hd__xnor2_4 A B VGND VNB VPB VPWR Y
.ends

* Black-box entry subcircuit for sky130_fd_sc_hd__nor3_4 abstract view
.subckt sky130_fd_sc_hd__nor3_4 A B C VGND VNB VPB VPWR Y
.ends

* Black-box entry subcircuit for sky130_fd_sc_hd__a2111oi_2 abstract view
.subckt sky130_fd_sc_hd__a2111oi_2 A1 A2 B1 C1 D1 VGND VNB VPB VPWR Y
.ends

* Black-box entry subcircuit for sky130_fd_sc_hd__a2bb2o_2 abstract view
.subckt sky130_fd_sc_hd__a2bb2o_2 A1_N A2_N B1 B2 VGND VNB VPB VPWR X
.ends

* Black-box entry subcircuit for sky130_fd_sc_hd__a21bo_2 abstract view
.subckt sky130_fd_sc_hd__a21bo_2 A1 A2 B1_N VGND VNB VPB VPWR X
.ends

* Black-box entry subcircuit for sky130_fd_sc_hd__a221o_2 abstract view
.subckt sky130_fd_sc_hd__a221o_2 A1 A2 B1 B2 C1 VGND VNB VPB VPWR X
.ends

* Black-box entry subcircuit for sky130_fd_sc_hd__nor3b_2 abstract view
.subckt sky130_fd_sc_hd__nor3b_2 A B C_N VGND VNB VPB VPWR Y
.ends

* Black-box entry subcircuit for sky130_fd_sc_hd__and4_2 abstract view
.subckt sky130_fd_sc_hd__and4_2 A B C D VGND VNB VPB VPWR X
.ends

* Black-box entry subcircuit for sky130_fd_sc_hd__nor4_4 abstract view
.subckt sky130_fd_sc_hd__nor4_4 A B C D VGND VNB VPB VPWR Y
.ends

* Black-box entry subcircuit for sky130_fd_sc_hd__a21boi_2 abstract view
.subckt sky130_fd_sc_hd__a21boi_2 A1 A2 B1_N VGND VNB VPB VPWR Y
.ends

* Black-box entry subcircuit for sky130_fd_sc_hd__nand2_4 abstract view
.subckt sky130_fd_sc_hd__nand2_4 A B VGND VNB VPB VPWR Y
.ends

* Black-box entry subcircuit for sky130_fd_sc_hd__a211oi_2 abstract view
.subckt sky130_fd_sc_hd__a211oi_2 A1 A2 B1 C1 VGND VNB VPB VPWR Y
.ends

* Black-box entry subcircuit for sky130_fd_sc_hd__o311a_2 abstract view
.subckt sky130_fd_sc_hd__o311a_2 A1 A2 A3 B1 C1 VGND VNB VPB VPWR X
.ends

* Black-box entry subcircuit for sky130_fd_sc_hd__xor2_4 abstract view
.subckt sky130_fd_sc_hd__xor2_4 A B VGND VNB VPB VPWR X
.ends

* Black-box entry subcircuit for sky130_fd_sc_hd__buf_6 abstract view
.subckt sky130_fd_sc_hd__buf_6 A VGND VNB VPB VPWR X
.ends

* Black-box entry subcircuit for sky130_fd_sc_hd__and2_4 abstract view
.subckt sky130_fd_sc_hd__and2_4 A B VGND VNB VPB VPWR X
.ends

* Black-box entry subcircuit for sky130_fd_sc_hd__o211a_4 abstract view
.subckt sky130_fd_sc_hd__o211a_4 A1 A2 B1 C1 VGND VNB VPB VPWR X
.ends

* Black-box entry subcircuit for sky130_fd_sc_hd__and2b_2 abstract view
.subckt sky130_fd_sc_hd__and2b_2 A_N B VGND VNB VPB VPWR X
.ends

* Black-box entry subcircuit for sky130_fd_sc_hd__o211a_2 abstract view
.subckt sky130_fd_sc_hd__o211a_2 A1 A2 B1 C1 VGND VNB VPB VPWR X
.ends

* Black-box entry subcircuit for sky130_fd_sc_hd__nand4_2 abstract view
.subckt sky130_fd_sc_hd__nand4_2 A B C D VGND VNB VPB VPWR Y
.ends

* Black-box entry subcircuit for sky130_fd_sc_hd__or2_4 abstract view
.subckt sky130_fd_sc_hd__or2_4 A B VGND VNB VPB VPWR X
.ends

* Black-box entry subcircuit for sky130_fd_sc_hd__or3_2 abstract view
.subckt sky130_fd_sc_hd__or3_2 A B C VGND VNB VPB VPWR X
.ends

* Black-box entry subcircuit for sky130_fd_sc_hd__o221a_4 abstract view
.subckt sky130_fd_sc_hd__o221a_4 A1 A2 B1 B2 C1 VGND VNB VPB VPWR X
.ends

* Black-box entry subcircuit for sky130_fd_sc_hd__inv_8 abstract view
.subckt sky130_fd_sc_hd__inv_8 A VGND VNB VPB VPWR Y
.ends

* Black-box entry subcircuit for sky130_fd_sc_hd__nor3_2 abstract view
.subckt sky130_fd_sc_hd__nor3_2 A B C VGND VNB VPB VPWR Y
.ends

* Black-box entry subcircuit for sky130_fd_sc_hd__clkdlybuf4s25_1 abstract view
.subckt sky130_fd_sc_hd__clkdlybuf4s25_1 A VGND VNB VPB VPWR X
.ends

* Black-box entry subcircuit for sky130_fd_sc_hd__and3_4 abstract view
.subckt sky130_fd_sc_hd__and3_4 A B C VGND VNB VPB VPWR X
.ends

* Black-box entry subcircuit for sky130_fd_sc_hd__nor4_2 abstract view
.subckt sky130_fd_sc_hd__nor4_2 A B C D VGND VNB VPB VPWR Y
.ends

* Black-box entry subcircuit for sky130_fd_sc_hd__o2bb2a_2 abstract view
.subckt sky130_fd_sc_hd__o2bb2a_2 A1_N A2_N B1 B2 VGND VNB VPB VPWR X
.ends

* Black-box entry subcircuit for sky130_fd_sc_hd__or3b_4 abstract view
.subckt sky130_fd_sc_hd__or3b_4 A B C_N VGND VNB VPB VPWR X
.ends

* Black-box entry subcircuit for sky130_fd_sc_hd__o41a_2 abstract view
.subckt sky130_fd_sc_hd__o41a_2 A1 A2 A3 A4 B1 VGND VNB VPB VPWR X
.ends

* Black-box entry subcircuit for sky130_fd_sc_hd__a32o_2 abstract view
.subckt sky130_fd_sc_hd__a32o_2 A1 A2 A3 B1 B2 VGND VNB VPB VPWR X
.ends

* Black-box entry subcircuit for sky130_fd_sc_hd__and4b_2 abstract view
.subckt sky130_fd_sc_hd__and4b_2 A_N B C D VGND VNB VPB VPWR X
.ends

* Black-box entry subcircuit for sky130_fd_sc_hd__or4bb_4 abstract view
.subckt sky130_fd_sc_hd__or4bb_4 A B C_N D_N VGND VNB VPB VPWR X
.ends

* Black-box entry subcircuit for sky130_fd_sc_hd__and4bb_2 abstract view
.subckt sky130_fd_sc_hd__and4bb_2 A_N B_N C D VGND VNB VPB VPWR X
.ends

* Black-box entry subcircuit for sky130_fd_sc_hd__nand3b_2 abstract view
.subckt sky130_fd_sc_hd__nand3b_2 A_N B C VGND VNB VPB VPWR Y
.ends

* Black-box entry subcircuit for sky130_fd_sc_hd__o21bai_2 abstract view
.subckt sky130_fd_sc_hd__o21bai_2 A1 A2 B1_N VGND VNB VPB VPWR Y
.ends

* Black-box entry subcircuit for sky130_fd_sc_hd__o211ai_2 abstract view
.subckt sky130_fd_sc_hd__o211ai_2 A1 A2 B1 C1 VGND VNB VPB VPWR Y
.ends

* Black-box entry subcircuit for sky130_fd_sc_hd__buf_12 abstract view
.subckt sky130_fd_sc_hd__buf_12 A VGND VNB VPB VPWR X
.ends

* Black-box entry subcircuit for sky130_fd_sc_hd__clkbuf_8 abstract view
.subckt sky130_fd_sc_hd__clkbuf_8 A VGND VNB VPB VPWR X
.ends

* Black-box entry subcircuit for sky130_fd_sc_hd__nand2b_2 abstract view
.subckt sky130_fd_sc_hd__nand2b_2 A_N B VGND VNB VPB VPWR Y
.ends

* Black-box entry subcircuit for sky130_fd_sc_hd__or3_4 abstract view
.subckt sky130_fd_sc_hd__or3_4 A B C VGND VNB VPB VPWR X
.ends

* Black-box entry subcircuit for sky130_fd_sc_hd__clkinvlp_4 abstract view
.subckt sky130_fd_sc_hd__clkinvlp_4 A VGND VNB VPB VPWR Y
.ends

* Black-box entry subcircuit for sky130_fd_sc_hd__dlymetal6s4s_1 abstract view
.subckt sky130_fd_sc_hd__dlymetal6s4s_1 A VGND VNB VPB VPWR X
.ends

* Black-box entry subcircuit for sky130_fd_sc_hd__o21ba_4 abstract view
.subckt sky130_fd_sc_hd__o21ba_4 A1 A2 B1_N VGND VNB VPB VPWR X
.ends

* Black-box entry subcircuit for sky130_fd_sc_hd__a22oi_2 abstract view
.subckt sky130_fd_sc_hd__a22oi_2 A1 A2 B1 B2 VGND VNB VPB VPWR Y
.ends

* Black-box entry subcircuit for sky130_fd_sc_hd__o32a_2 abstract view
.subckt sky130_fd_sc_hd__o32a_2 A1 A2 A3 B1 B2 VGND VNB VPB VPWR X
.ends

* Black-box entry subcircuit for sky130_fd_sc_hd__a31o_4 abstract view
.subckt sky130_fd_sc_hd__a31o_4 A1 A2 A3 B1 VGND VNB VPB VPWR X
.ends

* Black-box entry subcircuit for sky130_fd_sc_hd__o22ai_2 abstract view
.subckt sky130_fd_sc_hd__o22ai_2 A1 A2 B1 B2 VGND VNB VPB VPWR Y
.ends

* Black-box entry subcircuit for sky130_fd_sc_hd__o221ai_4 abstract view
.subckt sky130_fd_sc_hd__o221ai_4 A1 A2 B1 B2 C1 VGND VNB VPB VPWR Y
.ends

* Black-box entry subcircuit for sky130_fd_sc_hd__nand3_4 abstract view
.subckt sky130_fd_sc_hd__nand3_4 A B C VGND VNB VPB VPWR Y
.ends

* Black-box entry subcircuit for sky130_fd_sc_hd__mux2_1 abstract view
.subckt sky130_fd_sc_hd__mux2_1 A0 A1 S VGND VNB VPB VPWR X
.ends

* Black-box entry subcircuit for sky130_fd_sc_hd__clkinv_2 abstract view
.subckt sky130_fd_sc_hd__clkinv_2 A VGND VNB VPB VPWR Y
.ends

* Black-box entry subcircuit for sky130_fd_sc_hd__inv_12 abstract view
.subckt sky130_fd_sc_hd__inv_12 A VGND VNB VPB VPWR Y
.ends

* Black-box entry subcircuit for sky130_fd_sc_hd__clkbuf_16 abstract view
.subckt sky130_fd_sc_hd__clkbuf_16 A VGND VNB VPB VPWR X
.ends

* Black-box entry subcircuit for sky130_fd_sc_hd__o32a_4 abstract view
.subckt sky130_fd_sc_hd__o32a_4 A1 A2 A3 B1 B2 VGND VNB VPB VPWR X
.ends

* Black-box entry subcircuit for sky130_fd_sc_hd__o221a_2 abstract view
.subckt sky130_fd_sc_hd__o221a_2 A1 A2 B1 B2 C1 VGND VNB VPB VPWR X
.ends

* Black-box entry subcircuit for sky130_fd_sc_hd__o2111a_2 abstract view
.subckt sky130_fd_sc_hd__o2111a_2 A1 A2 B1 C1 D1 VGND VNB VPB VPWR X
.ends

* Black-box entry subcircuit for sky130_fd_sc_hd__a31oi_4 abstract view
.subckt sky130_fd_sc_hd__a31oi_4 A1 A2 A3 B1 VGND VNB VPB VPWR Y
.ends

* Black-box entry subcircuit for sky130_fd_sc_hd__a22o_4 abstract view
.subckt sky130_fd_sc_hd__a22o_4 A1 A2 B1 B2 VGND VNB VPB VPWR X
.ends

* Black-box entry subcircuit for sky130_fd_sc_hd__a41o_2 abstract view
.subckt sky130_fd_sc_hd__a41o_2 A1 A2 A3 A4 B1 VGND VNB VPB VPWR X
.ends

* Black-box entry subcircuit for sky130_fd_sc_hd__bufinv_16 abstract view
.subckt sky130_fd_sc_hd__bufinv_16 A VGND VNB VPB VPWR Y
.ends

* Black-box entry subcircuit for sky130_fd_sc_hd__dlymetal6s2s_1 abstract view
.subckt sky130_fd_sc_hd__dlymetal6s2s_1 A VGND VNB VPB VPWR X
.ends

* Black-box entry subcircuit for sky130_fd_sc_hd__mux2_4 abstract view
.subckt sky130_fd_sc_hd__mux2_4 A0 A1 S VGND VNB VPB VPWR X
.ends

* Black-box entry subcircuit for sky130_fd_sc_hd__a221oi_2 abstract view
.subckt sky130_fd_sc_hd__a221oi_2 A1 A2 B1 B2 C1 VGND VNB VPB VPWR Y
.ends

* Black-box entry subcircuit for sky130_fd_sc_hd__and4_4 abstract view
.subckt sky130_fd_sc_hd__and4_4 A B C D VGND VNB VPB VPWR X
.ends

* Black-box entry subcircuit for sky130_fd_sc_hd__nor2_1 abstract view
.subckt sky130_fd_sc_hd__nor2_1 A B VGND VNB VPB VPWR Y
.ends

* Black-box entry subcircuit for sky130_fd_sc_hd__a2bb2o_4 abstract view
.subckt sky130_fd_sc_hd__a2bb2o_4 A1_N A2_N B1 B2 VGND VNB VPB VPWR X
.ends

* Black-box entry subcircuit for sky130_fd_sc_hd__inv_4 abstract view
.subckt sky130_fd_sc_hd__inv_4 A VGND VNB VPB VPWR Y
.ends

* Black-box entry subcircuit for sky130_fd_sc_hd__or4b_4 abstract view
.subckt sky130_fd_sc_hd__or4b_4 A B C D_N VGND VNB VPB VPWR X
.ends

* Black-box entry subcircuit for sky130_fd_sc_hd__or4b_2 abstract view
.subckt sky130_fd_sc_hd__or4b_2 A B C D_N VGND VNB VPB VPWR X
.ends

* Black-box entry subcircuit for sky130_fd_sc_hd__o32ai_4 abstract view
.subckt sky130_fd_sc_hd__o32ai_4 A1 A2 A3 B1 B2 VGND VNB VPB VPWR Y
.ends

* Black-box entry subcircuit for sky130_fd_sc_hd__and3b_4 abstract view
.subckt sky130_fd_sc_hd__and3b_4 A_N B C VGND VNB VPB VPWR X
.ends

* Black-box entry subcircuit for sky130_fd_sc_hd__clkinv_4 abstract view
.subckt sky130_fd_sc_hd__clkinv_4 A VGND VNB VPB VPWR Y
.ends

* Black-box entry subcircuit for sky130_fd_sc_hd__inv_6 abstract view
.subckt sky130_fd_sc_hd__inv_6 A VGND VNB VPB VPWR Y
.ends

* Black-box entry subcircuit for sky130_fd_sc_hd__nor3b_4 abstract view
.subckt sky130_fd_sc_hd__nor3b_4 A B C_N VGND VNB VPB VPWR Y
.ends

* Black-box entry subcircuit for sky130_fd_sc_hd__o211ai_4 abstract view
.subckt sky130_fd_sc_hd__o211ai_4 A1 A2 B1 C1 VGND VNB VPB VPWR Y
.ends

* Black-box entry subcircuit for sky130_fd_sc_hd__a221oi_4 abstract view
.subckt sky130_fd_sc_hd__a221oi_4 A1 A2 B1 B2 C1 VGND VNB VPB VPWR Y
.ends

* Black-box entry subcircuit for sky130_fd_sc_hd__o21a_4 abstract view
.subckt sky130_fd_sc_hd__o21a_4 A1 A2 B1 VGND VNB VPB VPWR X
.ends

* Black-box entry subcircuit for sky130_fd_sc_hd__o21bai_4 abstract view
.subckt sky130_fd_sc_hd__o21bai_4 A1 A2 B1_N VGND VNB VPB VPWR Y
.ends

* Black-box entry subcircuit for sky130_fd_sc_hd__or2b_4 abstract view
.subckt sky130_fd_sc_hd__or2b_4 A B_N VGND VNB VPB VPWR X
.ends

* Black-box entry subcircuit for sky130_fd_sc_hd__nor4b_4 abstract view
.subckt sky130_fd_sc_hd__nor4b_4 A B C D_N VGND VNB VPB VPWR Y
.ends

* Black-box entry subcircuit for sky130_fd_sc_hd__a311oi_4 abstract view
.subckt sky130_fd_sc_hd__a311oi_4 A1 A2 A3 B1 C1 VGND VNB VPB VPWR Y
.ends

* Black-box entry subcircuit for sky130_fd_sc_hd__o31a_4 abstract view
.subckt sky130_fd_sc_hd__o31a_4 A1 A2 A3 B1 VGND VNB VPB VPWR X
.ends

* Black-box entry subcircuit for sky130_fd_sc_hd__nand2b_4 abstract view
.subckt sky130_fd_sc_hd__nand2b_4 A_N B VGND VNB VPB VPWR Y
.ends

* Black-box entry subcircuit for sky130_fd_sc_hd__a21boi_4 abstract view
.subckt sky130_fd_sc_hd__a21boi_4 A1 A2 B1_N VGND VNB VPB VPWR Y
.ends

* Black-box entry subcircuit for sky130_fd_sc_hd__a41o_4 abstract view
.subckt sky130_fd_sc_hd__a41o_4 A1 A2 A3 A4 B1 VGND VNB VPB VPWR X
.ends

* Black-box entry subcircuit for sky130_fd_sc_hd__a32oi_2 abstract view
.subckt sky130_fd_sc_hd__a32oi_2 A1 A2 A3 B1 B2 VGND VNB VPB VPWR Y
.ends

* Black-box entry subcircuit for sky130_fd_sc_hd__nor4b_2 abstract view
.subckt sky130_fd_sc_hd__nor4b_2 A B C D_N VGND VNB VPB VPWR Y
.ends

* Black-box entry subcircuit for sky130_fd_sc_hd__o2bb2ai_4 abstract view
.subckt sky130_fd_sc_hd__o2bb2ai_4 A1_N A2_N B1 B2 VGND VNB VPB VPWR Y
.ends

* Black-box entry subcircuit for sky130_fd_sc_hd__o221ai_2 abstract view
.subckt sky130_fd_sc_hd__o221ai_2 A1 A2 B1 B2 C1 VGND VNB VPB VPWR Y
.ends

* Black-box entry subcircuit for sky130_fd_sc_hd__o2111ai_2 abstract view
.subckt sky130_fd_sc_hd__o2111ai_2 A1 A2 B1 C1 D1 VGND VNB VPB VPWR Y
.ends

* Black-box entry subcircuit for sky130_fd_sc_hd__dlygate4sd1_1 abstract view
.subckt sky130_fd_sc_hd__dlygate4sd1_1 A VGND VNB VPB VPWR X
.ends

* Black-box entry subcircuit for sky130_fd_sc_hd__o311a_4 abstract view
.subckt sky130_fd_sc_hd__o311a_4 A1 A2 A3 B1 C1 VGND VNB VPB VPWR X
.ends

* Black-box entry subcircuit for sky130_fd_sc_hd__a41oi_4 abstract view
.subckt sky130_fd_sc_hd__a41oi_4 A1 A2 A3 A4 B1 VGND VNB VPB VPWR Y
.ends

.subckt fir_filter VGND VPWR clk ready result_out[0] result_out[10] result_out[11]
+ result_out[12] result_out[13] result_out[14] result_out[15] result_out[1] result_out[2]
+ result_out[3] result_out[4] result_out[5] result_out[6] result_out[7] result_out[8]
+ result_out[9] result_valid rst_n sample_in[0] sample_in[10] sample_in[11] sample_in[12]
+ sample_in[13] sample_in[14] sample_in[15] sample_in[1] sample_in[2] sample_in[3]
+ sample_in[4] sample_in[5] sample_in[6] sample_in[7] sample_in[8] sample_in[9] sample_valid
XFILLER_79_380 VGND VGND VPWR VPWR sky130_fd_sc_hd__fill_1
XFILLER_100_138 VGND VGND VPWR VPWR sky130_fd_sc_hd__fill_2
XFILLER_67_531 VGND VGND VPWR VPWR sky130_fd_sc_hd__decap_3
XFILLER_67_564 VGND VGND VPWR VPWR sky130_fd_sc_hd__decap_3
XFILLER_55_715 VGND VGND VPWR VPWR sky130_fd_sc_hd__fill_1
XFILLER_27_406 VGND VGND VPWR VPWR sky130_fd_sc_hd__decap_3
XFILLER_67_586 VGND VGND VPWR VPWR sky130_fd_sc_hd__decap_3
XFILLER_94_383 VGND VGND VPWR VPWR sky130_fd_sc_hd__decap_3
XFILLER_54_214 VGND VGND VPWR VPWR sky130_fd_sc_hd__fill_1
X_7963_ _7963_/A _7963_/B VGND VGND VPWR VPWR _7964_/B sky130_fd_sc_hd__xnor2_2
XFILLER_82_545 VGND VGND VPWR VPWR sky130_fd_sc_hd__fill_1
X_6914_ _6908_/X _6909_/X _6907_/Y VGND VGND VPWR VPWR _6915_/B sky130_fd_sc_hd__a21o_2
X_7894_ _7894_/A _7894_/B VGND VGND VPWR VPWR _7895_/B sky130_fd_sc_hd__xor2_2
XTAP_TAPCELL_ROW_25_618 VGND VPWR sky130_fd_sc_hd__tapvpwrvgnd_1
XFILLER_23_623 VGND VGND VPWR VPWR sky130_fd_sc_hd__decap_3
XFILLER_22_100 VGND VGND VPWR VPWR sky130_fd_sc_hd__decap_3
X_6845_ _6845_/A _6845_/B VGND VGND VPWR VPWR _6845_/Y sky130_fd_sc_hd__nor2_2
XFILLER_52_18 VGND VGND VPWR VPWR sky130_fd_sc_hd__decap_3
XFILLER_62_291 VGND VGND VPWR VPWR sky130_fd_sc_hd__fill_1
XFILLER_52_29 VGND VGND VPWR VPWR sky130_fd_sc_hd__decap_3
XFILLER_22_144 VGND VGND VPWR VPWR sky130_fd_sc_hd__fill_1
XFILLER_50_464 VGND VGND VPWR VPWR sky130_fd_sc_hd__decap_3
X_6776_ _6777_/B _6777_/C _6777_/A VGND VGND VPWR VPWR _6778_/B sky130_fd_sc_hd__a21o_2
X_8515_ _8547_/B _8515_/B VGND VGND VPWR VPWR _8515_/X sky130_fd_sc_hd__and2_2
X_5727_ _5727_/A _5727_/B VGND VGND VPWR VPWR _5729_/A sky130_fd_sc_hd__or2_2
XFILLER_109_717 VGND VGND VPWR VPWR sky130_fd_sc_hd__decap_3
X_8446_ _8446_/A _8446_/B VGND VGND VPWR VPWR _8446_/Y sky130_fd_sc_hd__nand2_2
X_5658_ _5656_/Y _5657_/X _6436_/A VGND VGND VPWR VPWR _5658_/X sky130_fd_sc_hd__mux2_2
X_4609_ _4609_/A VGND VGND VPWR VPWR _9055_/D sky130_fd_sc_hd__buf_1
XFILLER_117_750 VGND VGND VPWR VPWR sky130_fd_sc_hd__decap_3
X_8377_ wire45/X _8379_/B _8375_/X _8376_/Y VGND VGND VPWR VPWR _8377_/Y sky130_fd_sc_hd__a31oi_2
X_5589_ _6196_/B VGND VGND VPWR VPWR _7952_/A sky130_fd_sc_hd__clkbuf_2
XFILLER_123_208 VGND VGND VPWR VPWR sky130_fd_sc_hd__decap_3
X_7328_ _7416_/A _7329_/C _7417_/B _7413_/A VGND VGND VPWR VPWR _7328_/X sky130_fd_sc_hd__a22o_2
XFILLER_2_527 VGND VGND VPWR VPWR sky130_fd_sc_hd__decap_3
XFILLER_117_33 VGND VGND VPWR VPWR sky130_fd_sc_hd__decap_3
XFILLER_89_133 VGND VGND VPWR VPWR sky130_fd_sc_hd__fill_1
XFILLER_77_15 VGND VGND VPWR VPWR sky130_fd_sc_hd__fill_2
XFILLER_117_66 VGND VGND VPWR VPWR sky130_fd_sc_hd__decap_3
XFILLER_77_26 VGND VGND VPWR VPWR sky130_fd_sc_hd__decap_3
X_7259_ _7259_/A _7264_/B VGND VGND VPWR VPWR _7259_/X sky130_fd_sc_hd__or2b_2
XFILLER_104_477 VGND VGND VPWR VPWR sky130_fd_sc_hd__decap_3
XFILLER_117_99 VGND VGND VPWR VPWR sky130_fd_sc_hd__decap_3
XFILLER_104_488 VGND VGND VPWR VPWR sky130_fd_sc_hd__fill_2
XTAP_TAPCELL_ROW_5_343 VGND VPWR sky130_fd_sc_hd__tapvpwrvgnd_1
XTAP_TAPCELL_ROW_5_354 VGND VPWR sky130_fd_sc_hd__tapvpwrvgnd_1
XFILLER_58_542 VGND VGND VPWR VPWR sky130_fd_sc_hd__decap_3
XFILLER_58_564 VGND VGND VPWR VPWR sky130_fd_sc_hd__decap_3
XFILLER_100_661 VGND VGND VPWR VPWR sky130_fd_sc_hd__decap_3
Xhold1040 _9301_/Q VGND VGND VPWR VPWR _8951_/A1 sky130_fd_sc_hd__dlygate4sd3_1
XFILLER_18_406 VGND VGND VPWR VPWR sky130_fd_sc_hd__decap_3
Xhold1051 _9051_/Q VGND VGND VPWR VPWR _4634_/A1 sky130_fd_sc_hd__dlygate4sd3_1
XFILLER_46_726 VGND VGND VPWR VPWR sky130_fd_sc_hd__decap_3
Xhold1062 _4752_/X VGND VGND VPWR VPWR _4753_/A sky130_fd_sc_hd__dlygate4sd3_1
XFILLER_45_203 VGND VGND VPWR VPWR sky130_fd_sc_hd__decap_3
XFILLER_18_428 VGND VGND VPWR VPWR sky130_fd_sc_hd__decap_3
Xhold1073 _9050_/Q VGND VGND VPWR VPWR _4632_/A1 sky130_fd_sc_hd__dlygate4sd3_1
Xhold1084 _4813_/X VGND VGND VPWR VPWR _4814_/A sky130_fd_sc_hd__dlygate4sd3_1
XFILLER_45_236 VGND VGND VPWR VPWR sky130_fd_sc_hd__decap_3
Xhold1095 _9125_/Q VGND VGND VPWR VPWR _4790_/A1 sky130_fd_sc_hd__dlygate4sd3_1
XFILLER_73_556 VGND VGND VPWR VPWR sky130_fd_sc_hd__decap_3
XFILLER_73_567 VGND VGND VPWR VPWR sky130_fd_sc_hd__decap_3
XFILLER_61_729 VGND VGND VPWR VPWR sky130_fd_sc_hd__decap_3
XFILLER_26_450 VGND VGND VPWR VPWR sky130_fd_sc_hd__decap_3
XFILLER_54_770 VGND VGND VPWR VPWR sky130_fd_sc_hd__decap_3
XFILLER_26_483 VGND VGND VPWR VPWR sky130_fd_sc_hd__decap_3
XFILLER_13_100 VGND VGND VPWR VPWR sky130_fd_sc_hd__decap_3
XFILLER_14_634 VGND VGND VPWR VPWR sky130_fd_sc_hd__decap_3
XFILLER_41_420 VGND VGND VPWR VPWR sky130_fd_sc_hd__fill_2
XFILLER_14_645 VGND VGND VPWR VPWR sky130_fd_sc_hd__fill_1
XFILLER_41_442 VGND VGND VPWR VPWR sky130_fd_sc_hd__decap_3
XFILLER_13_133 VGND VGND VPWR VPWR sky130_fd_sc_hd__fill_1
XFILLER_41_453 VGND VGND VPWR VPWR sky130_fd_sc_hd__decap_3
XFILLER_13_144 VGND VGND VPWR VPWR sky130_fd_sc_hd__decap_3
XFILLER_13_166 VGND VGND VPWR VPWR sky130_fd_sc_hd__fill_2
XTAP_TAPCELL_ROW_52_982 VGND VPWR sky130_fd_sc_hd__tapvpwrvgnd_1
XFILLER_41_486 VGND VGND VPWR VPWR sky130_fd_sc_hd__fill_2
Xrebuffer470 _4513_/Y VGND VGND VPWR VPWR _4956_/B sky130_fd_sc_hd__buf_2
Xrebuffer481 _6733_/X VGND VGND VPWR VPWR _6736_/B sky130_fd_sc_hd__buf_2
XFILLER_5_343 VGND VGND VPWR VPWR sky130_fd_sc_hd__decap_3
Xrebuffer492 _6924_/C VGND VGND VPWR VPWR _6770_/B sky130_fd_sc_hd__buf_2
XTAP_TAPCELL_ROW_114_1823 VGND VPWR sky130_fd_sc_hd__tapvpwrvgnd_1
XFILLER_107_293 VGND VGND VPWR VPWR sky130_fd_sc_hd__fill_2
XFILLER_123_753 VGND VGND VPWR VPWR sky130_fd_sc_hd__decap_3
XFILLER_3_12 VGND VGND VPWR VPWR sky130_fd_sc_hd__decap_3
XFILLER_3_45 VGND VGND VPWR VPWR sky130_fd_sc_hd__decap_3
XFILLER_96_648 VGND VGND VPWR VPWR sky130_fd_sc_hd__decap_3
XFILLER_95_125 VGND VGND VPWR VPWR sky130_fd_sc_hd__decap_3
XFILLER_49_520 VGND VGND VPWR VPWR sky130_fd_sc_hd__decap_3
XFILLER_110_436 VGND VGND VPWR VPWR sky130_fd_sc_hd__decap_3
XFILLER_3_78 VGND VGND VPWR VPWR sky130_fd_sc_hd__decap_3
XFILLER_110_458 VGND VGND VPWR VPWR sky130_fd_sc_hd__decap_3
XFILLER_67_70 VGND VGND VPWR VPWR sky130_fd_sc_hd__fill_2
XFILLER_83_309 VGND VGND VPWR VPWR sky130_fd_sc_hd__fill_2
XFILLER_49_564 VGND VGND VPWR VPWR sky130_fd_sc_hd__fill_1
XFILLER_37_715 VGND VGND VPWR VPWR sky130_fd_sc_hd__decap_3
XFILLER_64_501 VGND VGND VPWR VPWR sky130_fd_sc_hd__decap_3
XFILLER_37_737 VGND VGND VPWR VPWR sky130_fd_sc_hd__fill_2
XFILLER_37_759 VGND VGND VPWR VPWR sky130_fd_sc_hd__fill_1
XFILLER_64_545 VGND VGND VPWR VPWR sky130_fd_sc_hd__decap_3
XFILLER_36_247 VGND VGND VPWR VPWR sky130_fd_sc_hd__decap_3
XFILLER_52_707 VGND VGND VPWR VPWR sky130_fd_sc_hd__decap_3
XFILLER_24_409 VGND VGND VPWR VPWR sky130_fd_sc_hd__decap_3
X_4960_ _9334_/Q _6756_/B _6758_/C VGND VGND VPWR VPWR _4960_/X sky130_fd_sc_hd__and3_2
XFILLER_64_589 VGND VGND VPWR VPWR sky130_fd_sc_hd__decap_3
XTAP_TAPCELL_ROW_125_1963 VGND VPWR sky130_fd_sc_hd__tapvpwrvgnd_1
XFILLER_17_461 VGND VGND VPWR VPWR sky130_fd_sc_hd__decap_3
XTAP_TAPCELL_ROW_125_1974 VGND VPWR sky130_fd_sc_hd__tapvpwrvgnd_1
XFILLER_17_483 VGND VGND VPWR VPWR sky130_fd_sc_hd__decap_3
XFILLER_51_239 VGND VGND VPWR VPWR sky130_fd_sc_hd__decap_3
XFILLER_44_280 VGND VGND VPWR VPWR sky130_fd_sc_hd__decap_3
X_4891_ _9217_/Q _4899_/B VGND VGND VPWR VPWR _4891_/Y sky130_fd_sc_hd__nor2_2
XFILLER_60_751 VGND VGND VPWR VPWR sky130_fd_sc_hd__decap_3
XFILLER_32_442 VGND VGND VPWR VPWR sky130_fd_sc_hd__decap_3
X_6630_ _6351_/B _6628_/Y _6629_/Y VGND VGND VPWR VPWR _6632_/A sky130_fd_sc_hd__a21oi_2
XFILLER_60_773 VGND VGND VPWR VPWR sky130_fd_sc_hd__decap_3
XFILLER_32_486 VGND VGND VPWR VPWR sky130_fd_sc_hd__decap_3
XFILLER_20_648 VGND VGND VPWR VPWR sky130_fd_sc_hd__decap_3
X_6561_ _6287_/A _6559_/X _6560_/X VGND VGND VPWR VPWR _6669_/B sky130_fd_sc_hd__a21o_2
X_8300_ _8298_/Y _8299_/Y _8286_/S VGND VGND VPWR VPWR _8300_/Y sky130_fd_sc_hd__a21oi_2
X_5512_ _5925_/A VGND VGND VPWR VPWR _6817_/A sky130_fd_sc_hd__clkbuf_2
X_9280_ _9296_/CLK _9280_/D fanout379/A VGND VGND VPWR VPWR _9280_/Q sky130_fd_sc_hd__dfrtp_2
X_6492_ _6492_/A _6492_/B VGND VGND VPWR VPWR _6493_/A sky130_fd_sc_hd__xnor2_2
XTAP_TAPCELL_ROW_30_687 VGND VPWR sky130_fd_sc_hd__tapvpwrvgnd_1
XFILLER_118_547 VGND VGND VPWR VPWR sky130_fd_sc_hd__decap_3
XTAP_TAPCELL_ROW_76_1306 VGND VPWR sky130_fd_sc_hd__tapvpwrvgnd_1
XFILLER_8_181 VGND VGND VPWR VPWR sky130_fd_sc_hd__decap_3
X_8231_ _8231_/A _8231_/B VGND VGND VPWR VPWR _8231_/Y sky130_fd_sc_hd__nand2_2
X_5443_ _5443_/A _5443_/B VGND VGND VPWR VPWR _5443_/X sky130_fd_sc_hd__or2_2
X_8162_ _8162_/A _8162_/B VGND VGND VPWR VPWR _8163_/B sky130_fd_sc_hd__xor2_2
X_5374_ _9168_/Q _5374_/A2 _5371_/X _5372_/X _5373_/X VGND VGND VPWR VPWR _5689_/A
+ sky130_fd_sc_hd__a2111oi_4
X_7113_ _8410_/S _8161_/B VGND VGND VPWR VPWR _8309_/B sky130_fd_sc_hd__nor2_2
XFILLER_114_753 VGND VGND VPWR VPWR sky130_fd_sc_hd__decap_3
X_8093_ _7977_/A _7977_/B _8092_/X VGND VGND VPWR VPWR _8094_/B sky130_fd_sc_hd__o21ai_2
XFILLER_87_626 VGND VGND VPWR VPWR sky130_fd_sc_hd__fill_1
XFILLER_86_103 VGND VGND VPWR VPWR sky130_fd_sc_hd__decap_3
XFILLER_99_497 VGND VGND VPWR VPWR sky130_fd_sc_hd__decap_3
X_7044_ _6346_/B _6346_/A _5201_/A VGND VGND VPWR VPWR _7046_/B sky130_fd_sc_hd__a21oi_4
XFILLER_47_29 VGND VGND VPWR VPWR sky130_fd_sc_hd__decap_3
XFILLER_74_309 VGND VGND VPWR VPWR sky130_fd_sc_hd__decap_3
XTAP_TAPCELL_ROW_2_302 VGND VPWR sky130_fd_sc_hd__tapvpwrvgnd_1
XTAP_TAPCELL_ROW_2_313 VGND VPWR sky130_fd_sc_hd__tapvpwrvgnd_1
XFILLER_55_501 VGND VGND VPWR VPWR sky130_fd_sc_hd__decap_3
XFILLER_67_372 VGND VGND VPWR VPWR sky130_fd_sc_hd__fill_1
XFILLER_28_726 VGND VGND VPWR VPWR sky130_fd_sc_hd__decap_3
XFILLER_27_203 VGND VGND VPWR VPWR sky130_fd_sc_hd__decap_3
XFILLER_55_534 VGND VGND VPWR VPWR sky130_fd_sc_hd__decap_3
X_8995_ _9338_/Q _8995_/A1 _9009_/S VGND VGND VPWR VPWR _8995_/X sky130_fd_sc_hd__mux2_2
XTAP_TAPCELL_ROW_87_1457 VGND VPWR sky130_fd_sc_hd__tapvpwrvgnd_1
XFILLER_55_567 VGND VGND VPWR VPWR sky130_fd_sc_hd__decap_3
XFILLER_103_57 VGND VGND VPWR VPWR sky130_fd_sc_hd__decap_3
X_7946_ _7946_/A _7946_/B _7946_/C VGND VGND VPWR VPWR _7948_/B sky130_fd_sc_hd__and3_2
XFILLER_82_375 VGND VGND VPWR VPWR sky130_fd_sc_hd__fill_2
XTAP_TAPCELL_ROW_38_798 VGND VPWR sky130_fd_sc_hd__tapvpwrvgnd_1
XFILLER_82_397 VGND VGND VPWR VPWR sky130_fd_sc_hd__fill_1
XFILLER_42_239 VGND VGND VPWR VPWR sky130_fd_sc_hd__decap_3
X_7877_ _7877_/A _8011_/C VGND VGND VPWR VPWR _7877_/X sky130_fd_sc_hd__or2_2
XFILLER_51_751 VGND VGND VPWR VPWR sky130_fd_sc_hd__decap_3
X_6828_ _7869_/A _5656_/B _5659_/Y VGND VGND VPWR VPWR _7520_/A sky130_fd_sc_hd__a21oi_2
XFILLER_23_497 VGND VGND VPWR VPWR sky130_fd_sc_hd__decap_3
X_6759_ _9269_/Q _5062_/X _6756_/X _6757_/X _6758_/X VGND VGND VPWR VPWR _6759_/X
+ sky130_fd_sc_hd__a2111o_2
XFILLER_10_147 VGND VGND VPWR VPWR sky130_fd_sc_hd__decap_3
XFILLER_12_21 VGND VGND VPWR VPWR sky130_fd_sc_hd__decap_3
XFILLER_10_169 VGND VGND VPWR VPWR sky130_fd_sc_hd__decap_3
XFILLER_6_129 VGND VGND VPWR VPWR sky130_fd_sc_hd__fill_2
XFILLER_12_32 VGND VGND VPWR VPWR sky130_fd_sc_hd__decap_3
XFILLER_128_21 VGND VGND VPWR VPWR sky130_fd_sc_hd__decap_3
XFILLER_128_32 VGND VGND VPWR VPWR sky130_fd_sc_hd__decap_3
X_8429_ _9223_/Q _8430_/B VGND VGND VPWR VPWR _8431_/A sky130_fd_sc_hd__nor2_2
XFILLER_128_65 VGND VGND VPWR VPWR sky130_fd_sc_hd__decap_3
XFILLER_2_324 VGND VGND VPWR VPWR sky130_fd_sc_hd__decap_3
XFILLER_2_346 VGND VGND VPWR VPWR sky130_fd_sc_hd__decap_3
XFILLER_2_368 VGND VGND VPWR VPWR sky130_fd_sc_hd__decap_3
XFILLER_120_701 VGND VGND VPWR VPWR sky130_fd_sc_hd__decap_3
XFILLER_104_274 VGND VGND VPWR VPWR sky130_fd_sc_hd__decap_3
XFILLER_78_648 VGND VGND VPWR VPWR sky130_fd_sc_hd__decap_3
XFILLER_120_734 VGND VGND VPWR VPWR sky130_fd_sc_hd__decap_3
XFILLER_77_125 VGND VGND VPWR VPWR sky130_fd_sc_hd__fill_2
XFILLER_78_659 VGND VGND VPWR VPWR sky130_fd_sc_hd__decap_3
XFILLER_77_169 VGND VGND VPWR VPWR sky130_fd_sc_hd__fill_1
XFILLER_58_350 VGND VGND VPWR VPWR sky130_fd_sc_hd__decap_3
XFILLER_19_704 VGND VGND VPWR VPWR sky130_fd_sc_hd__decap_3
XFILLER_86_681 VGND VGND VPWR VPWR sky130_fd_sc_hd__decap_3
XFILLER_18_203 VGND VGND VPWR VPWR sky130_fd_sc_hd__decap_3
XFILLER_58_383 VGND VGND VPWR VPWR sky130_fd_sc_hd__decap_3
XFILLER_100_480 VGND VGND VPWR VPWR sky130_fd_sc_hd__decap_3
XFILLER_19_759 VGND VGND VPWR VPWR sky130_fd_sc_hd__decap_3
XFILLER_34_707 VGND VGND VPWR VPWR sky130_fd_sc_hd__decap_3
XFILLER_46_567 VGND VGND VPWR VPWR sky130_fd_sc_hd__fill_1
XFILLER_37_84 VGND VGND VPWR VPWR sky130_fd_sc_hd__decap_3
XFILLER_73_375 VGND VGND VPWR VPWR sky130_fd_sc_hd__decap_3
XFILLER_33_206 VGND VGND VPWR VPWR sky130_fd_sc_hd__fill_1
XFILLER_61_526 VGND VGND VPWR VPWR sky130_fd_sc_hd__decap_3
XFILLER_27_770 VGND VGND VPWR VPWR sky130_fd_sc_hd__decap_3
XFILLER_33_228 VGND VGND VPWR VPWR sky130_fd_sc_hd__decap_3
XFILLER_42_751 VGND VGND VPWR VPWR sky130_fd_sc_hd__decap_3
XFILLER_14_453 VGND VGND VPWR VPWR sky130_fd_sc_hd__decap_3
XFILLER_41_250 VGND VGND VPWR VPWR sky130_fd_sc_hd__decap_3
XFILLER_14_497 VGND VGND VPWR VPWR sky130_fd_sc_hd__fill_2
XFILLER_127_322 VGND VGND VPWR VPWR sky130_fd_sc_hd__decap_3
XFILLER_127_355 VGND VGND VPWR VPWR sky130_fd_sc_hd__decap_3
XFILLER_10_692 VGND VGND VPWR VPWR sky130_fd_sc_hd__decap_3
XFILLER_6_663 VGND VGND VPWR VPWR sky130_fd_sc_hd__decap_3
XFILLER_5_140 VGND VGND VPWR VPWR sky130_fd_sc_hd__decap_3
XFILLER_52_6 VGND VGND VPWR VPWR sky130_fd_sc_hd__decap_3
XFILLER_127_388 VGND VGND VPWR VPWR sky130_fd_sc_hd__decap_3
XFILLER_115_528 VGND VGND VPWR VPWR sky130_fd_sc_hd__decap_3
XFILLER_127_399 VGND VGND VPWR VPWR sky130_fd_sc_hd__decap_3
XTAP_TAPCELL_ROW_58_1058 VGND VPWR sky130_fd_sc_hd__tapvpwrvgnd_1
XFILLER_6_696 VGND VGND VPWR VPWR sky130_fd_sc_hd__decap_3
XTAP_TAPCELL_ROW_58_1069 VGND VPWR sky130_fd_sc_hd__tapvpwrvgnd_1
XFILLER_69_615 VGND VGND VPWR VPWR sky130_fd_sc_hd__fill_1
XFILLER_69_626 VGND VGND VPWR VPWR sky130_fd_sc_hd__decap_3
XFILLER_123_572 VGND VGND VPWR VPWR sky130_fd_sc_hd__decap_3
XFILLER_111_712 VGND VGND VPWR VPWR sky130_fd_sc_hd__decap_3
XTAP_TAPCELL_ROW_71_1236 VGND VPWR sky130_fd_sc_hd__tapvpwrvgnd_1
XFILLER_123_594 VGND VGND VPWR VPWR sky130_fd_sc_hd__decap_3
XFILLER_110_211 VGND VGND VPWR VPWR sky130_fd_sc_hd__decap_3
X_5090_ _8688_/S VGND VGND VPWR VPWR _8291_/S sky130_fd_sc_hd__clkbuf_2
XFILLER_56_309 VGND VGND VPWR VPWR sky130_fd_sc_hd__decap_3
XFILLER_83_106 VGND VGND VPWR VPWR sky130_fd_sc_hd__decap_3
XFILLER_77_670 VGND VGND VPWR VPWR sky130_fd_sc_hd__fill_2
XFILLER_37_501 VGND VGND VPWR VPWR sky130_fd_sc_hd__decap_3
XFILLER_49_383 VGND VGND VPWR VPWR sky130_fd_sc_hd__decap_3
XFILLER_64_320 VGND VGND VPWR VPWR sky130_fd_sc_hd__decap_3
XFILLER_92_651 VGND VGND VPWR VPWR sky130_fd_sc_hd__decap_3
XFILLER_37_556 VGND VGND VPWR VPWR sky130_fd_sc_hd__decap_3
XFILLER_37_567 VGND VGND VPWR VPWR sky130_fd_sc_hd__decap_3
X_7800_ _8080_/A _8411_/A _7799_/X VGND VGND VPWR VPWR _7800_/Y sky130_fd_sc_hd__o21ai_2
X_8780_ _8780_/A _8780_/B _8780_/C _8780_/D VGND VGND VPWR VPWR _8783_/A sky130_fd_sc_hd__or4_2
X_5992_ _9077_/Q _5456_/B _5002_/X _9345_/Q VGND VGND VPWR VPWR _5992_/X sky130_fd_sc_hd__a22o_2
XFILLER_24_206 VGND VGND VPWR VPWR sky130_fd_sc_hd__fill_1
X_7731_ _7731_/A _7731_/B VGND VGND VPWR VPWR _8006_/A sky130_fd_sc_hd__nand2_2
X_4943_ _5738_/S _6239_/A _9098_/Q VGND VGND VPWR VPWR _4943_/X sky130_fd_sc_hd__and3b_2
XTAP_TAPCELL_ROW_35_757 VGND VPWR sky130_fd_sc_hd__tapvpwrvgnd_1
X_7662_ _7659_/A _7659_/B _7549_/B _7661_/X VGND VGND VPWR VPWR _7662_/X sky130_fd_sc_hd__a22o_2
XFILLER_33_773 VGND VGND VPWR VPWR sky130_fd_sc_hd__decap_3
XFILLER_32_250 VGND VGND VPWR VPWR sky130_fd_sc_hd__fill_2
X_4874_ _9229_/Q _9230_/Q _4873_/X _4870_/Y VGND VGND VPWR VPWR _4875_/B sky130_fd_sc_hd__a31o_2
XTAP_TAPCELL_ROW_82_1387 VGND VPWR sky130_fd_sc_hd__tapvpwrvgnd_1
X_6613_ _9348_/Q _5002_/X _5066_/X _9160_/Q VGND VGND VPWR VPWR _6613_/X sky130_fd_sc_hd__a22o_2
XTAP_TAPCELL_ROW_15_481 VGND VPWR sky130_fd_sc_hd__tapvpwrvgnd_1
XFILLER_32_294 VGND VGND VPWR VPWR sky130_fd_sc_hd__decap_3
X_7593_ _8239_/A VGND VGND VPWR VPWR _7593_/X sky130_fd_sc_hd__clkbuf_1
X_6544_ _7445_/A _6544_/B VGND VGND VPWR VPWR _6548_/A sky130_fd_sc_hd__nand2_2
X_9332_ _9348_/CLK _9332_/D load_slew390/X VGND VGND VPWR VPWR _9332_/Q sky130_fd_sc_hd__dfrtp_2
XFILLER_118_344 VGND VGND VPWR VPWR sky130_fd_sc_hd__decap_3
X_9263_ clkload6/A _9263_/D wire372/A VGND VGND VPWR VPWR _9263_/Q sky130_fd_sc_hd__dfrtp_2
X_6475_ _6422_/A _6422_/B _6423_/A VGND VGND VPWR VPWR _6475_/X sky130_fd_sc_hd__o21ba_2
XFILLER_118_377 VGND VGND VPWR VPWR sky130_fd_sc_hd__decap_3
XFILLER_106_539 VGND VGND VPWR VPWR sky130_fd_sc_hd__decap_3
X_8214_ _8214_/A VGND VGND VPWR VPWR _9220_/D sky130_fd_sc_hd__buf_1
X_5426_ _5426_/A _5426_/B VGND VGND VPWR VPWR _5576_/A sky130_fd_sc_hd__xnor2_2
X_9194_ _9227_/CLK _9194_/D load_slew416/X VGND VGND VPWR VPWR _9194_/Q sky130_fd_sc_hd__dfrtp_2
X_8145_ _8072_/A _8072_/B _8073_/A VGND VGND VPWR VPWR _8145_/X sky130_fd_sc_hd__o21ba_2
XFILLER_114_550 VGND VGND VPWR VPWR sky130_fd_sc_hd__decap_3
XFILLER_102_701 VGND VGND VPWR VPWR sky130_fd_sc_hd__fill_1
X_5357_ _5137_/X _5138_/X _5201_/A VGND VGND VPWR VPWR _5357_/X sky130_fd_sc_hd__a21o_2
XFILLER_99_261 VGND VGND VPWR VPWR sky130_fd_sc_hd__decap_3
XFILLER_87_401 VGND VGND VPWR VPWR sky130_fd_sc_hd__decap_3
XFILLER_102_734 VGND VGND VPWR VPWR sky130_fd_sc_hd__decap_3
X_8076_ _7964_/A _7964_/B _7965_/A VGND VGND VPWR VPWR _8076_/X sky130_fd_sc_hd__o21a_2
X_5288_ _6279_/A VGND VGND VPWR VPWR _6992_/A sky130_fd_sc_hd__clkbuf_1
XFILLER_114_12 VGND VGND VPWR VPWR sky130_fd_sc_hd__decap_3
X_7027_ _7027_/A VGND VGND VPWR VPWR _9212_/D sky130_fd_sc_hd__buf_1
XFILLER_101_277 VGND VGND VPWR VPWR sky130_fd_sc_hd__decap_3
XFILLER_114_56 VGND VGND VPWR VPWR sky130_fd_sc_hd__decap_3
XFILLER_67_180 VGND VGND VPWR VPWR sky130_fd_sc_hd__fill_2
XFILLER_55_331 VGND VGND VPWR VPWR sky130_fd_sc_hd__decap_3
XFILLER_28_567 VGND VGND VPWR VPWR sky130_fd_sc_hd__decap_3
XFILLER_16_707 VGND VGND VPWR VPWR sky130_fd_sc_hd__decap_3
XFILLER_55_364 VGND VGND VPWR VPWR sky130_fd_sc_hd__decap_3
XFILLER_28_589 VGND VGND VPWR VPWR sky130_fd_sc_hd__decap_3
X_8978_ _9011_/A1 _9314_/Q _8988_/S VGND VGND VPWR VPWR _8978_/X sky130_fd_sc_hd__mux2_2
XFILLER_70_312 VGND VGND VPWR VPWR sky130_fd_sc_hd__decap_3
XFILLER_82_183 VGND VGND VPWR VPWR sky130_fd_sc_hd__decap_3
XFILLER_130_44 VGND VGND VPWR VPWR sky130_fd_sc_hd__decap_3
X_7929_ _7791_/A _7791_/B _7792_/A VGND VGND VPWR VPWR _7929_/X sky130_fd_sc_hd__a21o_2
XFILLER_90_15 VGND VGND VPWR VPWR sky130_fd_sc_hd__fill_1
XFILLER_130_66 VGND VGND VPWR VPWR sky130_fd_sc_hd__decap_3
XFILLER_130_88 VGND VGND VPWR VPWR sky130_fd_sc_hd__decap_3
XFILLER_51_581 VGND VGND VPWR VPWR sky130_fd_sc_hd__decap_3
XFILLER_129_609 VGND VGND VPWR VPWR sky130_fd_sc_hd__decap_3
XFILLER_23_53 VGND VGND VPWR VPWR sky130_fd_sc_hd__decap_3
XFILLER_7_405 VGND VGND VPWR VPWR sky130_fd_sc_hd__decap_3
XFILLER_109_300 VGND VGND VPWR VPWR sky130_fd_sc_hd__decap_3
Xwire347 wire347/A VGND VGND VPWR VPWR _6116_/B sky130_fd_sc_hd__clkbuf_4
XFILLER_99_57 VGND VGND VPWR VPWR sky130_fd_sc_hd__decap_3
XFILLER_99_68 VGND VGND VPWR VPWR sky130_fd_sc_hd__fill_1
XFILLER_109_399 VGND VGND VPWR VPWR sky130_fd_sc_hd__decap_3
XFILLER_3_644 VGND VGND VPWR VPWR sky130_fd_sc_hd__decap_3
XFILLER_2_121 VGND VGND VPWR VPWR sky130_fd_sc_hd__decap_3
XFILLER_97_209 VGND VGND VPWR VPWR sky130_fd_sc_hd__fill_1
XFILLER_105_550 VGND VGND VPWR VPWR sky130_fd_sc_hd__fill_2
Xload_slew319 _6098_/A VGND VGND VPWR VPWR _7532_/B1 sky130_fd_sc_hd__buf_4
XFILLER_3_688 VGND VGND VPWR VPWR sky130_fd_sc_hd__decap_3
XFILLER_120_520 VGND VGND VPWR VPWR sky130_fd_sc_hd__decap_3
XFILLER_120_542 VGND VGND VPWR VPWR sky130_fd_sc_hd__fill_1
XFILLER_120_553 VGND VGND VPWR VPWR sky130_fd_sc_hd__decap_3
XFILLER_66_618 VGND VGND VPWR VPWR sky130_fd_sc_hd__decap_3
XFILLER_48_50 VGND VGND VPWR VPWR sky130_fd_sc_hd__decap_3
XFILLER_120_564 VGND VGND VPWR VPWR sky130_fd_sc_hd__decap_3
XFILLER_120_586 VGND VGND VPWR VPWR sky130_fd_sc_hd__fill_2
XFILLER_48_83 VGND VGND VPWR VPWR sky130_fd_sc_hd__fill_1
XFILLER_17_9 VGND VGND VPWR VPWR sky130_fd_sc_hd__decap_3
XFILLER_48_94 VGND VGND VPWR VPWR sky130_fd_sc_hd__decap_3
XFILLER_19_534 VGND VGND VPWR VPWR sky130_fd_sc_hd__decap_3
XFILLER_0_24 VGND VGND VPWR VPWR sky130_fd_sc_hd__decap_3
XFILLER_46_331 VGND VGND VPWR VPWR sky130_fd_sc_hd__decap_3
XFILLER_0_35 VGND VGND VPWR VPWR sky130_fd_sc_hd__decap_3
XTAP_TAPCELL_ROW_109_1755 VGND VPWR sky130_fd_sc_hd__tapvpwrvgnd_1
XFILLER_46_353 VGND VGND VPWR VPWR sky130_fd_sc_hd__decap_3
XFILLER_19_567 VGND VGND VPWR VPWR sky130_fd_sc_hd__decap_3
XFILLER_0_57 VGND VGND VPWR VPWR sky130_fd_sc_hd__decap_3
XFILLER_19_589 VGND VGND VPWR VPWR sky130_fd_sc_hd__decap_3
XFILLER_46_397 VGND VGND VPWR VPWR sky130_fd_sc_hd__decap_3
XTAP_TAPCELL_ROW_122_1922 VGND VPWR sky130_fd_sc_hd__tapvpwrvgnd_1
XFILLER_64_71 VGND VGND VPWR VPWR sky130_fd_sc_hd__decap_3
XFILLER_34_548 VGND VGND VPWR VPWR sky130_fd_sc_hd__decap_3
XTAP_TAPCELL_ROW_122_1933 VGND VPWR sky130_fd_sc_hd__tapvpwrvgnd_1
XFILLER_61_367 VGND VGND VPWR VPWR sky130_fd_sc_hd__decap_3
XFILLER_15_762 VGND VGND VPWR VPWR sky130_fd_sc_hd__decap_3
XTAP_TAPCELL_ROW_32_716 VGND VPWR sky130_fd_sc_hd__tapvpwrvgnd_1
XFILLER_9_33 VGND VGND VPWR VPWR sky130_fd_sc_hd__decap_3
XFILLER_42_581 VGND VGND VPWR VPWR sky130_fd_sc_hd__decap_3
XFILLER_14_272 VGND VGND VPWR VPWR sky130_fd_sc_hd__decap_3
XFILLER_42_592 VGND VGND VPWR VPWR sky130_fd_sc_hd__decap_3
XFILLER_9_77 VGND VGND VPWR VPWR sky130_fd_sc_hd__decap_3
XFILLER_119_108 VGND VGND VPWR VPWR sky130_fd_sc_hd__decap_3
XTAP_TAPCELL_ROW_12_440 VGND VPWR sky130_fd_sc_hd__tapvpwrvgnd_1
XFILLER_80_70 VGND VGND VPWR VPWR sky130_fd_sc_hd__decap_3
XFILLER_119_119 VGND VGND VPWR VPWR sky130_fd_sc_hd__decap_3
XPHY_EDGE_ROW_104_Right_104 VGND VGND VPWR VPWR sky130_fd_sc_hd__decap_3
X_4590_ hold989/X _9030_/Q _4608_/S VGND VGND VPWR VPWR _4590_/X sky130_fd_sc_hd__mux2_2
XFILLER_128_631 VGND VGND VPWR VPWR sky130_fd_sc_hd__decap_3
XFILLER_128_675 VGND VGND VPWR VPWR sky130_fd_sc_hd__decap_3
XFILLER_127_152 VGND VGND VPWR VPWR sky130_fd_sc_hd__decap_3
Xhold906 _9109_/Q VGND VGND VPWR VPWR hold906/X sky130_fd_sc_hd__dlygate4sd3_1
Xhold917 _8823_/X VGND VGND VPWR VPWR _8824_/A sky130_fd_sc_hd__dlygate4sd3_1
Xhold928 _9117_/Q VGND VGND VPWR VPWR hold928/X sky130_fd_sc_hd__dlygate4sd3_1
X_6260_ _6260_/A _6260_/B _6260_/C VGND VGND VPWR VPWR _6261_/B sky130_fd_sc_hd__nand3_2
Xhold939 _9065_/Q VGND VGND VPWR VPWR hold939/X sky130_fd_sc_hd__dlygate4sd3_1
XFILLER_50_3 VGND VGND VPWR VPWR sky130_fd_sc_hd__decap_3
XFILLER_127_196 VGND VGND VPWR VPWR sky130_fd_sc_hd__decap_3
X_5211_ _5211_/A _5211_/B VGND VGND VPWR VPWR _5236_/B sky130_fd_sc_hd__xnor2_2
XFILLER_115_369 VGND VGND VPWR VPWR sky130_fd_sc_hd__decap_3
X_6191_ _6023_/B _6189_/Y _6190_/Y VGND VGND VPWR VPWR _6193_/A sky130_fd_sc_hd__o21a_2
XFILLER_97_710 VGND VGND VPWR VPWR sky130_fd_sc_hd__fill_1
XFILLER_130_306 VGND VGND VPWR VPWR sky130_fd_sc_hd__fill_2
XFILLER_97_732 VGND VGND VPWR VPWR sky130_fd_sc_hd__fill_2
X_5142_ _5348_/S _6756_/B _5143_/B VGND VGND VPWR VPWR _5142_/Y sky130_fd_sc_hd__o21ai_2
XFILLER_97_743 VGND VGND VPWR VPWR sky130_fd_sc_hd__decap_3
XFILLER_69_434 VGND VGND VPWR VPWR sky130_fd_sc_hd__decap_3
XFILLER_111_520 VGND VGND VPWR VPWR sky130_fd_sc_hd__decap_3
XFILLER_123_391 VGND VGND VPWR VPWR sky130_fd_sc_hd__fill_1
XFILLER_96_253 VGND VGND VPWR VPWR sky130_fd_sc_hd__decap_3
X_5073_ _7098_/C VGND VGND VPWR VPWR _5167_/B sky130_fd_sc_hd__clkbuf_1
XFILLER_111_597 VGND VGND VPWR VPWR sky130_fd_sc_hd__decap_3
XFILLER_84_437 VGND VGND VPWR VPWR sky130_fd_sc_hd__decap_3
X_8901_ _8901_/A VGND VGND VPWR VPWR _9293_/D sky130_fd_sc_hd__buf_1
XFILLER_56_139 VGND VGND VPWR VPWR sky130_fd_sc_hd__fill_1
XFILLER_49_180 VGND VGND VPWR VPWR sky130_fd_sc_hd__decap_3
XFILLER_37_331 VGND VGND VPWR VPWR sky130_fd_sc_hd__decap_3
XFILLER_65_662 VGND VGND VPWR VPWR sky130_fd_sc_hd__decap_3
XFILLER_65_673 VGND VGND VPWR VPWR sky130_fd_sc_hd__decap_3
X_8832_ _8832_/A VGND VGND VPWR VPWR _9260_/D sky130_fd_sc_hd__buf_1
XTAP_TAPCELL_ROW_84_1416 VGND VPWR sky130_fd_sc_hd__tapvpwrvgnd_1
XFILLER_52_301 VGND VGND VPWR VPWR sky130_fd_sc_hd__decap_3
XFILLER_80_621 VGND VGND VPWR VPWR sky130_fd_sc_hd__decap_3
XFILLER_65_695 VGND VGND VPWR VPWR sky130_fd_sc_hd__decap_3
XFILLER_25_526 VGND VGND VPWR VPWR sky130_fd_sc_hd__fill_2
XFILLER_64_194 VGND VGND VPWR VPWR sky130_fd_sc_hd__fill_2
X_5975_ _5975_/A _5975_/B VGND VGND VPWR VPWR _6992_/B sky130_fd_sc_hd__and2_2
X_8763_ _8770_/B _8770_/C _8770_/A VGND VGND VPWR VPWR _8763_/X sky130_fd_sc_hd__a21o_2
XFILLER_80_687 VGND VGND VPWR VPWR sky130_fd_sc_hd__decap_3
X_4926_ _4926_/A _6342_/B VGND VGND VPWR VPWR _5624_/C sky130_fd_sc_hd__nor2b_2
X_7714_ _6873_/Y _7176_/B _7713_/X VGND VGND VPWR VPWR _7722_/A sky130_fd_sc_hd__o21a_2
XFILLER_40_529 VGND VGND VPWR VPWR sky130_fd_sc_hd__decap_3
XFILLER_33_570 VGND VGND VPWR VPWR sky130_fd_sc_hd__decap_3
X_8694_ _8753_/A _8694_/B VGND VGND VPWR VPWR _8737_/B sky130_fd_sc_hd__xnor2_2
XFILLER_21_732 VGND VGND VPWR VPWR sky130_fd_sc_hd__decap_3
X_4857_ hold942/X _9157_/Q _4861_/S VGND VGND VPWR VPWR _4857_/X sky130_fd_sc_hd__mux2_2
X_7645_ _7643_/Y _7644_/X _9214_/Q VGND VGND VPWR VPWR _7645_/X sky130_fd_sc_hd__o21ba_2
XFILLER_60_18 VGND VGND VPWR VPWR sky130_fd_sc_hd__decap_3
XFILLER_20_231 VGND VGND VPWR VPWR sky130_fd_sc_hd__decap_3
XFILLER_21_765 VGND VGND VPWR VPWR sky130_fd_sc_hd__decap_3
XFILLER_60_29 VGND VGND VPWR VPWR sky130_fd_sc_hd__decap_3
XFILLER_20_253 VGND VGND VPWR VPWR sky130_fd_sc_hd__decap_3
XFILLER_119_620 VGND VGND VPWR VPWR sky130_fd_sc_hd__fill_1
X_7576_ _7576_/A _7576_/B VGND VGND VPWR VPWR _7576_/X sky130_fd_sc_hd__and2_2
X_4788_ _9140_/Q _4788_/A1 _4798_/S VGND VGND VPWR VPWR _4788_/X sky130_fd_sc_hd__mux2_2
XFILLER_121_9 VGND VGND VPWR VPWR sky130_fd_sc_hd__decap_3
XFILLER_119_653 VGND VGND VPWR VPWR sky130_fd_sc_hd__decap_3
XFILLER_109_12 VGND VGND VPWR VPWR sky130_fd_sc_hd__decap_3
XFILLER_118_130 VGND VGND VPWR VPWR sky130_fd_sc_hd__decap_3
X_6527_ _6533_/A1 _6363_/B _6526_/Y VGND VGND VPWR VPWR _6527_/X sky130_fd_sc_hd__a21o_2
X_9315_ _9331_/CLK _9315_/D fanout389/X VGND VGND VPWR VPWR _9315_/Q sky130_fd_sc_hd__dfrtp_2
XFILLER_118_141 VGND VGND VPWR VPWR sky130_fd_sc_hd__fill_1
XFILLER_4_419 VGND VGND VPWR VPWR sky130_fd_sc_hd__fill_1
XFILLER_109_45 VGND VGND VPWR VPWR sky130_fd_sc_hd__decap_3
XFILLER_118_174 VGND VGND VPWR VPWR sky130_fd_sc_hd__fill_1
XFILLER_106_325 VGND VGND VPWR VPWR sky130_fd_sc_hd__decap_3
XTAP_TAPCELL_ROW_95_1567 VGND VPWR sky130_fd_sc_hd__tapvpwrvgnd_1
X_6458_ _6458_/A _6458_/B VGND VGND VPWR VPWR _6459_/B sky130_fd_sc_hd__xnor2_2
X_9246_ _9308_/CLK _9246_/D load_slew370/X VGND VGND VPWR VPWR _9246_/Q sky130_fd_sc_hd__dfrtp_2
XFILLER_69_27 VGND VGND VPWR VPWR sky130_fd_sc_hd__fill_1
XFILLER_69_49 VGND VGND VPWR VPWR sky130_fd_sc_hd__decap_3
X_5409_ _5410_/A _5412_/B _5307_/B _5408_/X VGND VGND VPWR VPWR _5409_/Y sky130_fd_sc_hd__o31ai_2
X_9177_ _9317_/CLK _9177_/D wire406/X VGND VGND VPWR VPWR _9177_/Q sky130_fd_sc_hd__dfrtp_2
X_6389_ _6266_/A _6266_/B _6388_/X VGND VGND VPWR VPWR _6390_/B sky130_fd_sc_hd__a21oi_2
XFILLER_88_732 VGND VGND VPWR VPWR sky130_fd_sc_hd__decap_3
X_8128_ _8350_/A _8248_/B VGND VGND VPWR VPWR _8129_/A sky130_fd_sc_hd__or2_2
XFILLER_125_33 VGND VGND VPWR VPWR sky130_fd_sc_hd__decap_3
XFILLER_114_380 VGND VGND VPWR VPWR sky130_fd_sc_hd__decap_3
XFILLER_0_669 VGND VGND VPWR VPWR sky130_fd_sc_hd__decap_3
XFILLER_125_66 VGND VGND VPWR VPWR sky130_fd_sc_hd__decap_3
X_8059_ _8050_/B _8047_/S _7945_/A VGND VGND VPWR VPWR _8059_/Y sky130_fd_sc_hd__a21oi_2
XFILLER_125_99 VGND VGND VPWR VPWR sky130_fd_sc_hd__decap_3
XFILLER_18_42 VGND VGND VPWR VPWR sky130_fd_sc_hd__decap_3
XFILLER_28_342 VGND VGND VPWR VPWR sky130_fd_sc_hd__fill_1
XFILLER_83_470 VGND VGND VPWR VPWR sky130_fd_sc_hd__decap_3
XFILLER_71_610 VGND VGND VPWR VPWR sky130_fd_sc_hd__decap_3
XFILLER_28_386 VGND VGND VPWR VPWR sky130_fd_sc_hd__decap_3
XFILLER_71_643 VGND VGND VPWR VPWR sky130_fd_sc_hd__fill_1
XFILLER_70_131 VGND VGND VPWR VPWR sky130_fd_sc_hd__decap_3
XFILLER_43_367 VGND VGND VPWR VPWR sky130_fd_sc_hd__decap_3
XFILLER_70_153 VGND VGND VPWR VPWR sky130_fd_sc_hd__decap_3
XFILLER_31_518 VGND VGND VPWR VPWR sky130_fd_sc_hd__fill_2
XFILLER_12_710 VGND VGND VPWR VPWR sky130_fd_sc_hd__decap_3
XFILLER_34_63 VGND VGND VPWR VPWR sky130_fd_sc_hd__decap_3
XTAP_TAPCELL_ROW_104_1685 VGND VPWR sky130_fd_sc_hd__tapvpwrvgnd_1
XFILLER_70_197 VGND VGND VPWR VPWR sky130_fd_sc_hd__decap_3
XFILLER_24_592 VGND VGND VPWR VPWR sky130_fd_sc_hd__fill_1
XFILLER_34_85 VGND VGND VPWR VPWR sky130_fd_sc_hd__decap_3
XFILLER_12_743 VGND VGND VPWR VPWR sky130_fd_sc_hd__decap_3
Xwire100 _5391_/Y VGND VGND VPWR VPWR _5392_/B sky130_fd_sc_hd__clkbuf_2
XFILLER_8_725 VGND VGND VPWR VPWR sky130_fd_sc_hd__decap_3
XFILLER_11_264 VGND VGND VPWR VPWR sky130_fd_sc_hd__decap_3
Xwire122 wire123/X VGND VGND VPWR VPWR wire122/X sky130_fd_sc_hd__clkbuf_2
Xwire144 _6332_/Y VGND VGND VPWR VPWR _6626_/A sky130_fd_sc_hd__buf_2
Xwire155 _5353_/X VGND VGND VPWR VPWR _6550_/B sky130_fd_sc_hd__buf_4
XFILLER_8_769 VGND VGND VPWR VPWR sky130_fd_sc_hd__decap_3
XFILLER_50_62 VGND VGND VPWR VPWR sky130_fd_sc_hd__fill_2
XFILLER_125_623 VGND VGND VPWR VPWR sky130_fd_sc_hd__decap_3
XFILLER_124_100 VGND VGND VPWR VPWR sky130_fd_sc_hd__decap_3
XFILLER_125_645 VGND VGND VPWR VPWR sky130_fd_sc_hd__decap_3
XFILLER_124_133 VGND VGND VPWR VPWR sky130_fd_sc_hd__decap_3
XFILLER_125_667 VGND VGND VPWR VPWR sky130_fd_sc_hd__decap_3
XFILLER_124_144 VGND VGND VPWR VPWR sky130_fd_sc_hd__decap_3
XTAP_TAPCELL_ROW_55_1028 VGND VPWR sky130_fd_sc_hd__tapvpwrvgnd_1
XFILLER_98_518 VGND VGND VPWR VPWR sky130_fd_sc_hd__decap_3
XFILLER_3_452 VGND VGND VPWR VPWR sky130_fd_sc_hd__fill_2
XFILLER_3_474 VGND VGND VPWR VPWR sky130_fd_sc_hd__decap_3
XFILLER_124_177 VGND VGND VPWR VPWR sky130_fd_sc_hd__decap_3
Xload_slew116 wire117/X VGND VGND VPWR VPWR _6346_/B sky130_fd_sc_hd__buf_8
XFILLER_78_253 VGND VGND VPWR VPWR sky130_fd_sc_hd__decap_3
XFILLER_39_629 VGND VGND VPWR VPWR sky130_fd_sc_hd__decap_3
XFILLER_120_361 VGND VGND VPWR VPWR sky130_fd_sc_hd__decap_3
XFILLER_94_735 VGND VGND VPWR VPWR sky130_fd_sc_hd__decap_3
XFILLER_38_128 VGND VGND VPWR VPWR sky130_fd_sc_hd__decap_3
XFILLER_15_6 VGND VGND VPWR VPWR sky130_fd_sc_hd__decap_3
XFILLER_19_320 VGND VGND VPWR VPWR sky130_fd_sc_hd__fill_2
XFILLER_94_768 VGND VGND VPWR VPWR sky130_fd_sc_hd__fill_1
XFILLER_47_640 VGND VGND VPWR VPWR sky130_fd_sc_hd__fill_1
XFILLER_47_662 VGND VGND VPWR VPWR sky130_fd_sc_hd__fill_1
XFILLER_93_278 VGND VGND VPWR VPWR sky130_fd_sc_hd__fill_2
XFILLER_47_673 VGND VGND VPWR VPWR sky130_fd_sc_hd__decap_3
XFILLER_81_429 VGND VGND VPWR VPWR sky130_fd_sc_hd__decap_3
XFILLER_74_470 VGND VGND VPWR VPWR sky130_fd_sc_hd__decap_3
XTAP_TAPCELL_ROW_17_510 VGND VPWR sky130_fd_sc_hd__tapvpwrvgnd_1
XFILLER_74_492 VGND VGND VPWR VPWR sky130_fd_sc_hd__decap_3
XFILLER_46_194 VGND VGND VPWR VPWR sky130_fd_sc_hd__fill_2
XTAP_TAPCELL_ROW_66_1168 VGND VPWR sky130_fd_sc_hd__tapvpwrvgnd_1
XFILLER_34_356 VGND VGND VPWR VPWR sky130_fd_sc_hd__decap_3
XFILLER_62_676 VGND VGND VPWR VPWR sky130_fd_sc_hd__decap_3
XTAP_TAPCELL_ROW_66_1179 VGND VPWR sky130_fd_sc_hd__tapvpwrvgnd_1
X_5760_ _5760_/A _5760_/B _5760_/C VGND VGND VPWR VPWR _5760_/Y sky130_fd_sc_hd__nand3_2
XTAP_TAPCELL_ROW_45_885 VGND VPWR sky130_fd_sc_hd__tapvpwrvgnd_1
XFILLER_34_389 VGND VGND VPWR VPWR sky130_fd_sc_hd__decap_3
XFILLER_98_3 VGND VGND VPWR VPWR sky130_fd_sc_hd__decap_3
XFILLER_15_581 VGND VGND VPWR VPWR sky130_fd_sc_hd__decap_3
X_4711_ _4711_/A VGND VGND VPWR VPWR _9103_/D sky130_fd_sc_hd__buf_1
X_5691_ _6177_/A _7071_/A _7430_/B _5014_/A VGND VGND VPWR VPWR _5694_/A sky130_fd_sc_hd__a211o_2
XFILLER_30_540 VGND VGND VPWR VPWR sky130_fd_sc_hd__decap_3
X_7430_ _7430_/A _7430_/B _7430_/C _8405_/B VGND VGND VPWR VPWR _7430_/X sky130_fd_sc_hd__or4_4
X_4642_ _4677_/A1 _4642_/A1 _4650_/S VGND VGND VPWR VPWR _4643_/A sky130_fd_sc_hd__mux2_2
X_7361_ _5014_/X _5041_/B _7360_/X VGND VGND VPWR VPWR _7481_/S sky130_fd_sc_hd__a21o_2
X_4573_ _9038_/Q hold837/X _4587_/S VGND VGND VPWR VPWR _4573_/X sky130_fd_sc_hd__mux2_2
XFILLER_128_483 VGND VGND VPWR VPWR sky130_fd_sc_hd__decap_3
XFILLER_116_623 VGND VGND VPWR VPWR sky130_fd_sc_hd__decap_3
X_6312_ _8050_/A _7065_/A VGND VGND VPWR VPWR _6579_/A sky130_fd_sc_hd__nor2_2
X_9100_ _9171_/CLK _9100_/D load_slew393/X VGND VGND VPWR VPWR _9100_/Q sky130_fd_sc_hd__dfrtp_2
X_7292_ _7450_/A _7450_/B VGND VGND VPWR VPWR _7293_/B sky130_fd_sc_hd__xnor2_2
XFILLER_115_122 VGND VGND VPWR VPWR sky130_fd_sc_hd__decap_3
XFILLER_115_133 VGND VGND VPWR VPWR sky130_fd_sc_hd__decap_3
Xhold758 _8785_/X VGND VGND VPWR VPWR _8786_/A sky130_fd_sc_hd__dlygate4sd3_1
X_9031_ _9348_/CLK _9031_/D load_slew390/X VGND VGND VPWR VPWR _9031_/Q sky130_fd_sc_hd__dfrtp_2
X_6243_ _6354_/A _6354_/B VGND VGND VPWR VPWR _6352_/A sky130_fd_sc_hd__nand2_8
Xhold769 _5102_/X VGND VGND VPWR VPWR hold769/X sky130_fd_sc_hd__dlygate4sd3_1
XFILLER_115_155 VGND VGND VPWR VPWR sky130_fd_sc_hd__decap_3
XFILLER_130_103 VGND VGND VPWR VPWR sky130_fd_sc_hd__decap_3
XFILLER_130_125 VGND VGND VPWR VPWR sky130_fd_sc_hd__decap_3
X_6174_ _6174_/A _6174_/B VGND VGND VPWR VPWR _6174_/X sky130_fd_sc_hd__or2_2
XFILLER_130_147 VGND VGND VPWR VPWR sky130_fd_sc_hd__decap_3
XFILLER_69_242 VGND VGND VPWR VPWR sky130_fd_sc_hd__decap_3
XFILLER_130_169 VGND VGND VPWR VPWR sky130_fd_sc_hd__decap_3
X_5125_ _5879_/B _5875_/C VGND VGND VPWR VPWR _5126_/A sky130_fd_sc_hd__and2_2
XFILLER_97_573 VGND VGND VPWR VPWR sky130_fd_sc_hd__decap_3
XTAP_TAPCELL_ROW_90_1497 VGND VPWR sky130_fd_sc_hd__tapvpwrvgnd_1
XFILLER_85_724 VGND VGND VPWR VPWR sky130_fd_sc_hd__decap_3
XFILLER_85_735 VGND VGND VPWR VPWR sky130_fd_sc_hd__decap_3
XFILLER_57_437 VGND VGND VPWR VPWR sky130_fd_sc_hd__decap_3
XFILLER_29_139 VGND VGND VPWR VPWR sky130_fd_sc_hd__decap_3
X_5056_ _5875_/B _5879_/C VGND VGND VPWR VPWR _5056_/X sky130_fd_sc_hd__and2_2
XFILLER_38_640 VGND VGND VPWR VPWR sky130_fd_sc_hd__decap_3
XFILLER_38_673 VGND VGND VPWR VPWR sky130_fd_sc_hd__decap_3
XFILLER_37_150 VGND VGND VPWR VPWR sky130_fd_sc_hd__decap_3
XFILLER_65_492 VGND VGND VPWR VPWR sky130_fd_sc_hd__decap_3
X_8815_ _8815_/A VGND VGND VPWR VPWR _9252_/D sky130_fd_sc_hd__buf_1
XFILLER_37_194 VGND VGND VPWR VPWR sky130_fd_sc_hd__decap_3
XFILLER_111_24 VGND VGND VPWR VPWR sky130_fd_sc_hd__decap_3
XFILLER_53_654 VGND VGND VPWR VPWR sky130_fd_sc_hd__decap_3
XFILLER_13_529 VGND VGND VPWR VPWR sky130_fd_sc_hd__decap_3
X_8746_ _8746_/A _8746_/B VGND VGND VPWR VPWR _8746_/Y sky130_fd_sc_hd__xnor2_2
XFILLER_52_175 VGND VGND VPWR VPWR sky130_fd_sc_hd__decap_3
X_5958_ _5033_/A _6096_/B _5795_/B _5957_/X VGND VGND VPWR VPWR _5958_/X sky130_fd_sc_hd__o31a_2
XFILLER_71_39 VGND VGND VPWR VPWR sky130_fd_sc_hd__decap_3
XFILLER_40_348 VGND VGND VPWR VPWR sky130_fd_sc_hd__fill_1
X_4909_ hold952/X _9232_/Q _9178_/D VGND VGND VPWR VPWR _4909_/X sky130_fd_sc_hd__mux2_2
X_5889_ _9172_/Q _4516_/X _5888_/X _5887_/X _5886_/X VGND VGND VPWR VPWR _5890_/A
+ sky130_fd_sc_hd__a2111o_2
X_8677_ _8674_/A _8673_/Y _8676_/X _8681_/A VGND VGND VPWR VPWR _8677_/X sky130_fd_sc_hd__a211o_2
XFILLER_21_551 VGND VGND VPWR VPWR sky130_fd_sc_hd__decap_3
X_7628_ _7626_/X _7465_/A _7627_/X VGND VGND VPWR VPWR _7633_/B sky130_fd_sc_hd__a21o_4
XFILLER_126_409 VGND VGND VPWR VPWR sky130_fd_sc_hd__decap_3
XFILLER_5_706 VGND VGND VPWR VPWR sky130_fd_sc_hd__decap_3
X_7559_ _7559_/A _7559_/B VGND VGND VPWR VPWR _7559_/Y sky130_fd_sc_hd__xnor2_2
XFILLER_107_623 VGND VGND VPWR VPWR sky130_fd_sc_hd__decap_3
XFILLER_4_227 VGND VGND VPWR VPWR sky130_fd_sc_hd__fill_2
XFILLER_20_21 VGND VGND VPWR VPWR sky130_fd_sc_hd__decap_3
XFILLER_107_645 VGND VGND VPWR VPWR sky130_fd_sc_hd__fill_2
XFILLER_4_238 VGND VGND VPWR VPWR sky130_fd_sc_hd__fill_1
XFILLER_106_144 VGND VGND VPWR VPWR sky130_fd_sc_hd__decap_3
XFILLER_122_604 VGND VGND VPWR VPWR sky130_fd_sc_hd__decap_3
X_9229_ _9232_/CLK _9229_/D load_slew408/X VGND VGND VPWR VPWR _9229_/Q sky130_fd_sc_hd__dfrtp_2
XFILLER_122_626 VGND VGND VPWR VPWR sky130_fd_sc_hd__fill_1
XFILLER_0_411 VGND VGND VPWR VPWR sky130_fd_sc_hd__decap_3
XFILLER_121_125 VGND VGND VPWR VPWR sky130_fd_sc_hd__decap_3
XFILLER_0_433 VGND VGND VPWR VPWR sky130_fd_sc_hd__decap_3
XFILLER_88_540 VGND VGND VPWR VPWR sky130_fd_sc_hd__decap_3
XFILLER_0_455 VGND VGND VPWR VPWR sky130_fd_sc_hd__decap_3
XFILLER_88_562 VGND VGND VPWR VPWR sky130_fd_sc_hd__decap_3
XFILLER_121_158 VGND VGND VPWR VPWR sky130_fd_sc_hd__decap_3
XFILLER_121_169 VGND VGND VPWR VPWR sky130_fd_sc_hd__decap_3
XFILLER_0_477 VGND VGND VPWR VPWR sky130_fd_sc_hd__decap_3
XFILLER_29_52 VGND VGND VPWR VPWR sky130_fd_sc_hd__decap_3
XFILLER_29_63 VGND VGND VPWR VPWR sky130_fd_sc_hd__decap_3
XFILLER_76_757 VGND VGND VPWR VPWR sky130_fd_sc_hd__decap_3
XFILLER_48_459 VGND VGND VPWR VPWR sky130_fd_sc_hd__decap_3
XFILLER_75_245 VGND VGND VPWR VPWR sky130_fd_sc_hd__decap_3
XFILLER_91_716 VGND VGND VPWR VPWR sky130_fd_sc_hd__decap_3
XFILLER_63_418 VGND VGND VPWR VPWR sky130_fd_sc_hd__decap_3
XFILLER_29_662 VGND VGND VPWR VPWR sky130_fd_sc_hd__decap_3
XFILLER_75_278 VGND VGND VPWR VPWR sky130_fd_sc_hd__fill_2
XFILLER_29_673 VGND VGND VPWR VPWR sky130_fd_sc_hd__decap_3
XFILLER_28_150 VGND VGND VPWR VPWR sky130_fd_sc_hd__decap_3
XTAP_TAPCELL_ROW_106_1714 VGND VPWR sky130_fd_sc_hd__tapvpwrvgnd_1
XFILLER_16_312 VGND VGND VPWR VPWR sky130_fd_sc_hd__decap_3
XFILLER_28_183 VGND VGND VPWR VPWR sky130_fd_sc_hd__decap_3
XFILLER_90_248 VGND VGND VPWR VPWR sky130_fd_sc_hd__decap_3
XFILLER_45_95 VGND VGND VPWR VPWR sky130_fd_sc_hd__decap_3
XFILLER_43_164 VGND VGND VPWR VPWR sky130_fd_sc_hd__decap_3
XFILLER_31_337 VGND VGND VPWR VPWR sky130_fd_sc_hd__decap_3
XTAP_TAPCELL_ROW_42_844 VGND VPWR sky130_fd_sc_hd__tapvpwrvgnd_1
XTAP_TAPCELL_ROW_42_855 VGND VPWR sky130_fd_sc_hd__tapvpwrvgnd_1
XFILLER_101_90 VGND VGND VPWR VPWR sky130_fd_sc_hd__fill_1
XFILLER_8_500 VGND VGND VPWR VPWR sky130_fd_sc_hd__decap_3
XFILLER_12_551 VGND VGND VPWR VPWR sky130_fd_sc_hd__decap_3
XFILLER_8_511 VGND VGND VPWR VPWR sky130_fd_sc_hd__decap_3
XFILLER_129_214 VGND VGND VPWR VPWR sky130_fd_sc_hd__decap_3
XFILLER_129_225 VGND VGND VPWR VPWR sky130_fd_sc_hd__decap_3
XFILLER_8_533 VGND VGND VPWR VPWR sky130_fd_sc_hd__decap_3
XFILLER_12_584 VGND VGND VPWR VPWR sky130_fd_sc_hd__decap_3
XFILLER_61_94 VGND VGND VPWR VPWR sky130_fd_sc_hd__decap_3
XFILLER_117_409 VGND VGND VPWR VPWR sky130_fd_sc_hd__decap_3
XFILLER_129_269 VGND VGND VPWR VPWR sky130_fd_sc_hd__decap_3
XFILLER_8_577 VGND VGND VPWR VPWR sky130_fd_sc_hd__decap_3
XFILLER_6_12 VGND VGND VPWR VPWR sky130_fd_sc_hd__decap_3
XANTENNA_5 _6733_/X VGND VGND VPWR VPWR sky130_fd_sc_hd__diode_2
XTAP_TAPCELL_ROW_117_1865 VGND VPWR sky130_fd_sc_hd__tapvpwrvgnd_1
XFILLER_113_626 VGND VGND VPWR VPWR sky130_fd_sc_hd__decap_3
XFILLER_98_326 VGND VGND VPWR VPWR sky130_fd_sc_hd__decap_3
XFILLER_112_158 VGND VGND VPWR VPWR sky130_fd_sc_hd__fill_2
XFILLER_100_309 VGND VGND VPWR VPWR sky130_fd_sc_hd__fill_2
XFILLER_79_573 VGND VGND VPWR VPWR sky130_fd_sc_hd__decap_3
XFILLER_67_724 VGND VGND VPWR VPWR sky130_fd_sc_hd__decap_3
XFILLER_39_415 VGND VGND VPWR VPWR sky130_fd_sc_hd__decap_3
XFILLER_67_735 VGND VGND VPWR VPWR sky130_fd_sc_hd__decap_3
XFILLER_94_521 VGND VGND VPWR VPWR sky130_fd_sc_hd__decap_3
XFILLER_121_692 VGND VGND VPWR VPWR sky130_fd_sc_hd__decap_3
XFILLER_120_180 VGND VGND VPWR VPWR sky130_fd_sc_hd__decap_3
XFILLER_13_3 VGND VGND VPWR VPWR sky130_fd_sc_hd__decap_3
XFILLER_94_565 VGND VGND VPWR VPWR sky130_fd_sc_hd__decap_3
XFILLER_66_256 VGND VGND VPWR VPWR sky130_fd_sc_hd__decap_3
XFILLER_82_716 VGND VGND VPWR VPWR sky130_fd_sc_hd__decap_3
XFILLER_66_278 VGND VGND VPWR VPWR sky130_fd_sc_hd__decap_3
XFILLER_54_418 VGND VGND VPWR VPWR sky130_fd_sc_hd__fill_2
X_6930_ _6944_/B VGND VGND VPWR VPWR _8240_/B sky130_fd_sc_hd__clkbuf_1
XFILLER_94_598 VGND VGND VPWR VPWR sky130_fd_sc_hd__decap_3
XFILLER_81_215 VGND VGND VPWR VPWR sky130_fd_sc_hd__fill_1
XFILLER_54_429 VGND VGND VPWR VPWR sky130_fd_sc_hd__decap_3
XFILLER_81_248 VGND VGND VPWR VPWR sky130_fd_sc_hd__fill_2
XFILLER_19_194 VGND VGND VPWR VPWR sky130_fd_sc_hd__decap_3
X_6861_ _7256_/A _6861_/B VGND VGND VPWR VPWR _7153_/A sky130_fd_sc_hd__nor2_4
XFILLER_62_451 VGND VGND VPWR VPWR sky130_fd_sc_hd__decap_3
XFILLER_34_153 VGND VGND VPWR VPWR sky130_fd_sc_hd__decap_3
X_8600_ _8581_/Y _8739_/B _8599_/X VGND VGND VPWR VPWR _8626_/B sky130_fd_sc_hd__a21oi_2
X_5812_ _5812_/A VGND VGND VPWR VPWR _5813_/B sky130_fd_sc_hd__inv_2
XFILLER_22_315 VGND VGND VPWR VPWR sky130_fd_sc_hd__decap_3
X_6792_ _6789_/X _6791_/X _6793_/B VGND VGND VPWR VPWR _6792_/X sky130_fd_sc_hd__mux2_2
XFILLER_50_635 VGND VGND VPWR VPWR sky130_fd_sc_hd__decap_3
XFILLER_34_197 VGND VGND VPWR VPWR sky130_fd_sc_hd__decap_3
X_5743_ _9247_/Q _5743_/B VGND VGND VPWR VPWR _5743_/Y sky130_fd_sc_hd__nor2_2
X_8531_ _8177_/B _8496_/S _8530_/X VGND VGND VPWR VPWR _8557_/B sky130_fd_sc_hd__a21oi_2
XFILLER_50_679 VGND VGND VPWR VPWR sky130_fd_sc_hd__decap_3
X_5674_ _5674_/A _5674_/B VGND VGND VPWR VPWR _5674_/Y sky130_fd_sc_hd__nor2_2
X_8462_ _5093_/X _8458_/X _8459_/Y _8461_/X VGND VGND VPWR VPWR _9223_/D sky130_fd_sc_hd__a31oi_2
XFILLER_30_392 VGND VGND VPWR VPWR sky130_fd_sc_hd__decap_3
XTAP_TAPCELL_ROW_20_549 VGND VPWR sky130_fd_sc_hd__tapvpwrvgnd_1
X_4625_ _9063_/Q hold977/X _4629_/S VGND VGND VPWR VPWR _4625_/X sky130_fd_sc_hd__mux2_2
X_7413_ _7413_/A _7413_/B _7412_/X VGND VGND VPWR VPWR _7421_/A sky130_fd_sc_hd__or3b_2
X_8393_ _8296_/X _8122_/X _8301_/X _8386_/A VGND VGND VPWR VPWR _8393_/X sky130_fd_sc_hd__a211o_4
XTAP_TAPCELL_ROW_79_1348 VGND VPWR sky130_fd_sc_hd__tapvpwrvgnd_1
X_7344_ _8421_/A _7344_/B _7344_/C VGND VGND VPWR VPWR _7346_/D sky130_fd_sc_hd__nand3_2
X_4556_ _9030_/Q hold904/X _4566_/S VGND VGND VPWR VPWR _4556_/X sky130_fd_sc_hd__mux2_2
XFILLER_128_291 VGND VGND VPWR VPWR sky130_fd_sc_hd__decap_3
XFILLER_116_431 VGND VGND VPWR VPWR sky130_fd_sc_hd__decap_3
XTAP_TAPCELL_ROW_92_1526 VGND VPWR sky130_fd_sc_hd__tapvpwrvgnd_1
X_7275_ _7273_/A _7273_/B _7274_/X VGND VGND VPWR VPWR _7275_/Y sky130_fd_sc_hd__o21ai_2
XFILLER_116_475 VGND VGND VPWR VPWR sky130_fd_sc_hd__fill_1
XFILLER_103_103 VGND VGND VPWR VPWR sky130_fd_sc_hd__fill_1
XFILLER_89_337 VGND VGND VPWR VPWR sky130_fd_sc_hd__fill_1
XFILLER_103_125 VGND VGND VPWR VPWR sky130_fd_sc_hd__decap_3
X_6226_ _9330_/Q _6603_/B _6604_/C VGND VGND VPWR VPWR _6226_/X sky130_fd_sc_hd__and3_2
X_9014_ _9014_/A VGND VGND VPWR VPWR _9347_/D sky130_fd_sc_hd__buf_1
XFILLER_106_24 VGND VGND VPWR VPWR sky130_fd_sc_hd__decap_3
X_6157_ wire76/X _6157_/B VGND VGND VPWR VPWR _6158_/B sky130_fd_sc_hd__nor2_2
XFILLER_112_670 VGND VGND VPWR VPWR sky130_fd_sc_hd__decap_3
Xhold1200 _9288_/Q VGND VGND VPWR VPWR _8923_/A1 sky130_fd_sc_hd__dlygate4sd3_1
Xhold1211 _9145_/Q VGND VGND VPWR VPWR _4798_/A0 sky130_fd_sc_hd__dlygate4sd3_1
X_5108_ _5105_/Y _5345_/A _7114_/B VGND VGND VPWR VPWR _5109_/A sky130_fd_sc_hd__and3b_2
Xhold1222 _9238_/Q VGND VGND VPWR VPWR _8818_/A1 sky130_fd_sc_hd__dlygate4sd3_1
XFILLER_57_234 VGND VGND VPWR VPWR sky130_fd_sc_hd__fill_1
XFILLER_111_180 VGND VGND VPWR VPWR sky130_fd_sc_hd__decap_3
X_6088_ _5095_/X _5320_/Y _6087_/Y _6416_/A VGND VGND VPWR VPWR _6089_/B sky130_fd_sc_hd__o22a_2
Xhold1244 _9227_/Q VGND VGND VPWR VPWR _8597_/A sky130_fd_sc_hd__dlygate4sd3_1
Xhold1255 _9209_/Q VGND VGND VPWR VPWR _6460_/A0 sky130_fd_sc_hd__dlygate4sd3_1
XFILLER_73_705 VGND VGND VPWR VPWR sky130_fd_sc_hd__decap_3
XFILLER_122_12 VGND VGND VPWR VPWR sky130_fd_sc_hd__decap_3
XFILLER_73_727 VGND VGND VPWR VPWR sky130_fd_sc_hd__fill_1
XFILLER_45_418 VGND VGND VPWR VPWR sky130_fd_sc_hd__fill_1
X_5039_ _5106_/A1 _8174_/B _4916_/A _5283_/A VGND VGND VPWR VPWR _5040_/A sky130_fd_sc_hd__a211oi_4
XFILLER_57_289 VGND VGND VPWR VPWR sky130_fd_sc_hd__fill_1
XFILLER_122_56 VGND VGND VPWR VPWR sky130_fd_sc_hd__decap_3
XFILLER_82_16 VGND VGND VPWR VPWR sky130_fd_sc_hd__decap_3
XFILLER_72_259 VGND VGND VPWR VPWR sky130_fd_sc_hd__decap_3
XFILLER_26_654 VGND VGND VPWR VPWR sky130_fd_sc_hd__decap_3
XFILLER_25_131 VGND VGND VPWR VPWR sky130_fd_sc_hd__decap_3
XTAP_TAPCELL_ROW_0_263 VGND VPWR sky130_fd_sc_hd__tapvpwrvgnd_1
XTAP_TAPCELL_ROW_0_274 VGND VPWR sky130_fd_sc_hd__tapvpwrvgnd_1
XFILLER_82_49 VGND VGND VPWR VPWR sky130_fd_sc_hd__decap_3
XFILLER_53_462 VGND VGND VPWR VPWR sky130_fd_sc_hd__decap_3
XFILLER_25_153 VGND VGND VPWR VPWR sky130_fd_sc_hd__decap_3
XTAP_TAPCELL_ROW_0_285 VGND VPWR sky130_fd_sc_hd__tapvpwrvgnd_1
XFILLER_15_21 VGND VGND VPWR VPWR sky130_fd_sc_hd__decap_3
XFILLER_41_635 VGND VGND VPWR VPWR sky130_fd_sc_hd__decap_3
XFILLER_15_54 VGND VGND VPWR VPWR sky130_fd_sc_hd__fill_2
XFILLER_13_337 VGND VGND VPWR VPWR sky130_fd_sc_hd__decap_3
XFILLER_80_292 VGND VGND VPWR VPWR sky130_fd_sc_hd__decap_3
X_8729_ _6762_/D _8728_/X _8729_/S VGND VGND VPWR VPWR _8729_/X sky130_fd_sc_hd__mux2_2
XTAP_TAPCELL_ROW_101_1644 VGND VPWR sky130_fd_sc_hd__tapvpwrvgnd_1
XFILLER_15_87 VGND VGND VPWR VPWR sky130_fd_sc_hd__decap_3
XFILLER_40_178 VGND VGND VPWR VPWR sky130_fd_sc_hd__decap_3
XFILLER_21_370 VGND VGND VPWR VPWR sky130_fd_sc_hd__decap_3
XFILLER_31_20 VGND VGND VPWR VPWR sky130_fd_sc_hd__decap_3
XFILLER_127_718 VGND VGND VPWR VPWR sky130_fd_sc_hd__decap_3
XFILLER_127_729 VGND VGND VPWR VPWR sky130_fd_sc_hd__decap_3
XFILLER_5_503 VGND VGND VPWR VPWR sky130_fd_sc_hd__fill_1
XFILLER_126_206 VGND VGND VPWR VPWR sky130_fd_sc_hd__decap_3
Xrebuffer663 _6524_/X VGND VGND VPWR VPWR _6525_/A sky130_fd_sc_hd__buf_2
XFILLER_126_239 VGND VGND VPWR VPWR sky130_fd_sc_hd__decap_3
Xrebuffer685 _6117_/X VGND VGND VPWR VPWR _6120_/A sky130_fd_sc_hd__buf_4
XFILLER_107_475 VGND VGND VPWR VPWR sky130_fd_sc_hd__decap_3
Xoutput20 _9180_/Q VGND VGND VPWR VPWR wire234/A sky130_fd_sc_hd__buf_1
XFILLER_122_412 VGND VGND VPWR VPWR sky130_fd_sc_hd__decap_3
Xoutput31 _9185_/Q VGND VGND VPWR VPWR wire223/A sky130_fd_sc_hd__buf_1
XFILLER_1_753 VGND VGND VPWR VPWR sky130_fd_sc_hd__decap_3
XFILLER_110_607 VGND VGND VPWR VPWR sky130_fd_sc_hd__fill_2
XFILLER_49_702 VGND VGND VPWR VPWR sky130_fd_sc_hd__decap_3
XTAP_TAPCELL_ROW_8_385 VGND VPWR sky130_fd_sc_hd__tapvpwrvgnd_1
XFILLER_95_329 VGND VGND VPWR VPWR sky130_fd_sc_hd__fill_1
XFILLER_122_489 VGND VGND VPWR VPWR sky130_fd_sc_hd__fill_2
XTAP_TAPCELL_ROW_8_396 VGND VPWR sky130_fd_sc_hd__tapvpwrvgnd_1
XTAP_TAPCELL_ROW_112_1795 VGND VPWR sky130_fd_sc_hd__tapvpwrvgnd_1
XFILLER_48_212 VGND VGND VPWR VPWR sky130_fd_sc_hd__decap_3
XFILLER_103_692 VGND VGND VPWR VPWR sky130_fd_sc_hd__decap_3
XFILLER_0_296 VGND VGND VPWR VPWR sky130_fd_sc_hd__fill_1
XFILLER_49_757 VGND VGND VPWR VPWR sky130_fd_sc_hd__fill_2
XFILLER_48_245 VGND VGND VPWR VPWR sky130_fd_sc_hd__decap_3
XFILLER_76_565 VGND VGND VPWR VPWR sky130_fd_sc_hd__decap_3
XTAP_TAPCELL_ROW_47_914 VGND VPWR sky130_fd_sc_hd__tapvpwrvgnd_1
XFILLER_56_50 VGND VGND VPWR VPWR sky130_fd_sc_hd__decap_3
XFILLER_29_470 VGND VGND VPWR VPWR sky130_fd_sc_hd__decap_3
XFILLER_56_72 VGND VGND VPWR VPWR sky130_fd_sc_hd__decap_3
XFILLER_56_94 VGND VGND VPWR VPWR sky130_fd_sc_hd__decap_3
XFILLER_29_492 VGND VGND VPWR VPWR sky130_fd_sc_hd__decap_3
XFILLER_91_579 VGND VGND VPWR VPWR sky130_fd_sc_hd__decap_3
XFILLER_44_462 VGND VGND VPWR VPWR sky130_fd_sc_hd__decap_3
XFILLER_16_153 VGND VGND VPWR VPWR sky130_fd_sc_hd__decap_3
XFILLER_31_101 VGND VGND VPWR VPWR sky130_fd_sc_hd__decap_3
XFILLER_17_698 VGND VGND VPWR VPWR sky130_fd_sc_hd__decap_3
XTAP_TAPCELL_ROW_63_1127 VGND VPWR sky130_fd_sc_hd__tapvpwrvgnd_1
XFILLER_16_186 VGND VGND VPWR VPWR sky130_fd_sc_hd__decap_3
XTAP_TAPCELL_ROW_63_1138 VGND VPWR sky130_fd_sc_hd__tapvpwrvgnd_1
XFILLER_71_281 VGND VGND VPWR VPWR sky130_fd_sc_hd__fill_1
XFILLER_16_197 VGND VGND VPWR VPWR sky130_fd_sc_hd__decap_3
XFILLER_31_167 VGND VGND VPWR VPWR sky130_fd_sc_hd__fill_1
XFILLER_82_6 VGND VGND VPWR VPWR sky130_fd_sc_hd__decap_3
XFILLER_118_707 VGND VGND VPWR VPWR sky130_fd_sc_hd__decap_3
XFILLER_12_392 VGND VGND VPWR VPWR sky130_fd_sc_hd__fill_2
X_5390_ _7413_/A VGND VGND VPWR VPWR _7763_/A sky130_fd_sc_hd__clkbuf_2
XFILLER_126_740 VGND VGND VPWR VPWR sky130_fd_sc_hd__decap_3
XFILLER_125_261 VGND VGND VPWR VPWR sky130_fd_sc_hd__decap_3
XFILLER_98_112 VGND VGND VPWR VPWR sky130_fd_sc_hd__decap_3
XFILLER_113_434 VGND VGND VPWR VPWR sky130_fd_sc_hd__decap_3
X_7060_ _7058_/X _6969_/A _7059_/X VGND VGND VPWR VPWR _7062_/C sky130_fd_sc_hd__o21ai_4
XTAP_TAPCELL_ROW_74_1278 VGND VPWR sky130_fd_sc_hd__tapvpwrvgnd_1
XFILLER_113_467 VGND VGND VPWR VPWR sky130_fd_sc_hd__decap_3
X_6011_ _6011_/A _6174_/A VGND VGND VPWR VPWR _6013_/A sky130_fd_sc_hd__xnor2_2
XFILLER_113_478 VGND VGND VPWR VPWR sky130_fd_sc_hd__decap_3
XFILLER_101_629 VGND VGND VPWR VPWR sky130_fd_sc_hd__decap_3
XFILLER_86_329 VGND VGND VPWR VPWR sky130_fd_sc_hd__decap_3
XFILLER_82_502 VGND VGND VPWR VPWR sky130_fd_sc_hd__decap_3
XFILLER_67_576 VGND VGND VPWR VPWR sky130_fd_sc_hd__decap_3
XFILLER_27_418 VGND VGND VPWR VPWR sky130_fd_sc_hd__decap_3
XFILLER_55_738 VGND VGND VPWR VPWR sky130_fd_sc_hd__decap_3
X_7962_ _7962_/A _7962_/B VGND VGND VPWR VPWR _7963_/B sky130_fd_sc_hd__xnor2_2
X_6913_ _6907_/Y _6908_/X _6909_/X _6911_/Y _6912_/X VGND VGND VPWR VPWR _6915_/A
+ sky130_fd_sc_hd__a311o_2
X_7893_ _7893_/A _8034_/A _7893_/C VGND VGND VPWR VPWR _7894_/B sky130_fd_sc_hd__and3_2
XTAP_TAPCELL_ROW_25_619 VGND VPWR sky130_fd_sc_hd__tapvpwrvgnd_1
XFILLER_35_462 VGND VGND VPWR VPWR sky130_fd_sc_hd__decap_3
XFILLER_23_613 VGND VGND VPWR VPWR sky130_fd_sc_hd__decap_3
X_6844_ _6450_/B _6859_/A _6843_/A VGND VGND VPWR VPWR _6845_/B sky130_fd_sc_hd__a21oi_2
XFILLER_50_421 VGND VGND VPWR VPWR sky130_fd_sc_hd__decap_3
XFILLER_22_112 VGND VGND VPWR VPWR sky130_fd_sc_hd__fill_1
X_6775_ _6920_/A _6920_/B VGND VGND VPWR VPWR _6777_/A sky130_fd_sc_hd__nand2_2
XFILLER_10_318 VGND VGND VPWR VPWR sky130_fd_sc_hd__decap_3
X_8514_ _8514_/A _8514_/B VGND VGND VPWR VPWR _8514_/Y sky130_fd_sc_hd__nor2_2
XFILLER_22_189 VGND VGND VPWR VPWR sky130_fd_sc_hd__decap_3
X_5726_ _5726_/A _5726_/B VGND VGND VPWR VPWR _5822_/B sky130_fd_sc_hd__xnor2_4
XFILLER_109_729 VGND VGND VPWR VPWR sky130_fd_sc_hd__decap_3
X_8445_ _8445_/A _8445_/B _8445_/C VGND VGND VPWR VPWR _8445_/X sky130_fd_sc_hd__and3_2
X_5657_ _5804_/B _5546_/B _5803_/A VGND VGND VPWR VPWR _5657_/X sky130_fd_sc_hd__mux2_2
XFILLER_108_239 VGND VGND VPWR VPWR sky130_fd_sc_hd__decap_3
X_4608_ _9055_/Q _4608_/A1 _4608_/S VGND VGND VPWR VPWR _4608_/X sky130_fd_sc_hd__mux2_2
X_5588_ _5588_/A _5588_/B _5588_/C VGND VGND VPWR VPWR _6963_/C sky130_fd_sc_hd__nor3_4
X_8376_ _8218_/B _8184_/B wire45/X _8379_/B _8184_/A VGND VGND VPWR VPWR _8376_/Y
+ sky130_fd_sc_hd__a2111oi_2
XFILLER_117_762 VGND VGND VPWR VPWR sky130_fd_sc_hd__decap_3
XFILLER_2_506 VGND VGND VPWR VPWR sky130_fd_sc_hd__fill_2
XFILLER_117_12 VGND VGND VPWR VPWR sky130_fd_sc_hd__decap_3
XFILLER_116_250 VGND VGND VPWR VPWR sky130_fd_sc_hd__fill_2
X_4539_ _4539_/A VGND VGND VPWR VPWR _9022_/D sky130_fd_sc_hd__buf_1
X_7327_ _7326_/A _7326_/B _7951_/A _7065_/B VGND VGND VPWR VPWR _7332_/B sky130_fd_sc_hd__a211o_2
XFILLER_116_261 VGND VGND VPWR VPWR sky130_fd_sc_hd__decap_3
XFILLER_117_45 VGND VGND VPWR VPWR sky130_fd_sc_hd__decap_3
XFILLER_116_294 VGND VGND VPWR VPWR sky130_fd_sc_hd__decap_3
X_7258_ _7513_/A _7258_/B VGND VGND VPWR VPWR _7508_/A sky130_fd_sc_hd__xnor2_2
XFILLER_117_78 VGND VGND VPWR VPWR sky130_fd_sc_hd__decap_3
XFILLER_77_38 VGND VGND VPWR VPWR sky130_fd_sc_hd__decap_3
X_6209_ _6209_/A VGND VGND VPWR VPWR _6209_/X sky130_fd_sc_hd__clkbuf_1
X_7189_ _7244_/B _8013_/A _7195_/A VGND VGND VPWR VPWR _7189_/X sky130_fd_sc_hd__o21a_2
XFILLER_58_510 VGND VGND VPWR VPWR sky130_fd_sc_hd__decap_3
XFILLER_58_521 VGND VGND VPWR VPWR sky130_fd_sc_hd__decap_3
XTAP_TAPCELL_ROW_5_344 VGND VPWR sky130_fd_sc_hd__tapvpwrvgnd_1
XTAP_TAPCELL_ROW_5_355 VGND VPWR sky130_fd_sc_hd__tapvpwrvgnd_1
Xhold1030 _8976_/X VGND VGND VPWR VPWR _8977_/A sky130_fd_sc_hd__dlygate4sd3_1
Xhold1041 _9298_/Q VGND VGND VPWR VPWR _8944_/A1 sky130_fd_sc_hd__dlygate4sd3_1
XFILLER_58_576 VGND VGND VPWR VPWR sky130_fd_sc_hd__decap_3
Xhold1052 _4634_/X VGND VGND VPWR VPWR _4635_/A sky130_fd_sc_hd__dlygate4sd3_1
Xhold1063 _9034_/Q VGND VGND VPWR VPWR _4598_/A1 sky130_fd_sc_hd__dlygate4sd3_1
XFILLER_73_524 VGND VGND VPWR VPWR sky130_fd_sc_hd__fill_1
XFILLER_58_598 VGND VGND VPWR VPWR sky130_fd_sc_hd__fill_2
XFILLER_45_215 VGND VGND VPWR VPWR sky130_fd_sc_hd__fill_2
Xhold1074 _9086_/Q VGND VGND VPWR VPWR _4708_/A1 sky130_fd_sc_hd__dlygate4sd3_1
XFILLER_85_384 VGND VGND VPWR VPWR sky130_fd_sc_hd__fill_1
XFILLER_46_749 VGND VGND VPWR VPWR sky130_fd_sc_hd__decap_3
Xhold1085 _9325_/Q VGND VGND VPWR VPWR _9001_/A1 sky130_fd_sc_hd__dlygate4sd3_1
Xhold1096 _9322_/Q VGND VGND VPWR VPWR _8995_/A1 sky130_fd_sc_hd__dlygate4sd3_1
XFILLER_45_248 VGND VGND VPWR VPWR sky130_fd_sc_hd__decap_3
XFILLER_26_462 VGND VGND VPWR VPWR sky130_fd_sc_hd__fill_1
XFILLER_41_432 VGND VGND VPWR VPWR sky130_fd_sc_hd__decap_3
XFILLER_13_123 VGND VGND VPWR VPWR sky130_fd_sc_hd__decap_3
XFILLER_14_668 VGND VGND VPWR VPWR sky130_fd_sc_hd__decap_3
XFILLER_9_116 VGND VGND VPWR VPWR sky130_fd_sc_hd__decap_3
XTAP_TAPCELL_ROW_52_983 VGND VPWR sky130_fd_sc_hd__tapvpwrvgnd_1
XFILLER_9_127 VGND VGND VPWR VPWR sky130_fd_sc_hd__fill_1
XFILLER_9_138 VGND VGND VPWR VPWR sky130_fd_sc_hd__decap_3
XFILLER_13_189 VGND VGND VPWR VPWR sky130_fd_sc_hd__decap_3
XFILLER_42_63 VGND VGND VPWR VPWR sky130_fd_sc_hd__decap_3
XFILLER_42_74 VGND VGND VPWR VPWR sky130_fd_sc_hd__decap_3
XFILLER_42_85 VGND VGND VPWR VPWR sky130_fd_sc_hd__decap_3
XFILLER_127_515 VGND VGND VPWR VPWR sky130_fd_sc_hd__decap_3
XFILLER_5_311 VGND VGND VPWR VPWR sky130_fd_sc_hd__decap_3
Xrebuffer460 _6598_/B VGND VGND VPWR VPWR _6908_/B sky130_fd_sc_hd__buf_2
XFILLER_5_333 VGND VGND VPWR VPWR sky130_fd_sc_hd__decap_3
XFILLER_127_559 VGND VGND VPWR VPWR sky130_fd_sc_hd__fill_1
Xrebuffer471 _6281_/Y VGND VGND VPWR VPWR _6287_/B sky130_fd_sc_hd__buf_4
Xrebuffer482 _5627_/B VGND VGND VPWR VPWR _5387_/B sky130_fd_sc_hd__buf_2
Xrebuffer493 _6910_/A VGND VGND VPWR VPWR _6770_/A sky130_fd_sc_hd__buf_2
XFILLER_5_355 VGND VGND VPWR VPWR sky130_fd_sc_hd__fill_2
XFILLER_114_209 VGND VGND VPWR VPWR sky130_fd_sc_hd__decap_3
XTAP_TAPCELL_ROW_114_1824 VGND VPWR sky130_fd_sc_hd__tapvpwrvgnd_1
XFILLER_5_377 VGND VGND VPWR VPWR sky130_fd_sc_hd__fill_1
XFILLER_123_721 VGND VGND VPWR VPWR sky130_fd_sc_hd__decap_3
XFILLER_123_732 VGND VGND VPWR VPWR sky130_fd_sc_hd__decap_3
XFILLER_123_765 VGND VGND VPWR VPWR sky130_fd_sc_hd__decap_3
XFILLER_3_24 VGND VGND VPWR VPWR sky130_fd_sc_hd__decap_3
XFILLER_122_253 VGND VGND VPWR VPWR sky130_fd_sc_hd__decap_3
XFILLER_110_404 VGND VGND VPWR VPWR sky130_fd_sc_hd__decap_3
XFILLER_96_638 VGND VGND VPWR VPWR sky130_fd_sc_hd__decap_3
XFILLER_3_57 VGND VGND VPWR VPWR sky130_fd_sc_hd__decap_3
XFILLER_49_532 VGND VGND VPWR VPWR sky130_fd_sc_hd__decap_3
XFILLER_1_594 VGND VGND VPWR VPWR sky130_fd_sc_hd__decap_3
XFILLER_67_60 VGND VGND VPWR VPWR sky130_fd_sc_hd__fill_1
XFILLER_49_554 VGND VGND VPWR VPWR sky130_fd_sc_hd__decap_3
XFILLER_49_587 VGND VGND VPWR VPWR sky130_fd_sc_hd__decap_3
XFILLER_64_513 VGND VGND VPWR VPWR sky130_fd_sc_hd__decap_3
XTAP_TAPCELL_ROW_125_1964 VGND VPWR sky130_fd_sc_hd__tapvpwrvgnd_1
XTAP_TAPCELL_ROW_125_1975 VGND VPWR sky130_fd_sc_hd__tapvpwrvgnd_1
XFILLER_51_218 VGND VGND VPWR VPWR sky130_fd_sc_hd__decap_3
XFILLER_83_70 VGND VGND VPWR VPWR sky130_fd_sc_hd__fill_1
X_4890_ _4876_/X _4889_/Y _4878_/X hold806/X VGND VGND VPWR VPWR _9185_/D sky130_fd_sc_hd__a2bb2o_2
XFILLER_17_495 VGND VGND VPWR VPWR sky130_fd_sc_hd__decap_3
XFILLER_60_730 VGND VGND VPWR VPWR sky130_fd_sc_hd__decap_3
XFILLER_32_465 VGND VGND VPWR VPWR sky130_fd_sc_hd__decap_3
X_6560_ _6560_/A _6560_/B _6560_/C VGND VGND VPWR VPWR _6560_/X sky130_fd_sc_hd__and3_2
X_5511_ _6873_/A VGND VGND VPWR VPWR _5925_/A sky130_fd_sc_hd__inv_2
X_6491_ _6812_/S _6491_/B VGND VGND VPWR VPWR _6492_/B sky130_fd_sc_hd__xnor2_2
XTAP_TAPCELL_ROW_30_688 VGND VPWR sky130_fd_sc_hd__tapvpwrvgnd_1
XFILLER_9_694 VGND VGND VPWR VPWR sky130_fd_sc_hd__decap_3
XFILLER_8_171 VGND VGND VPWR VPWR sky130_fd_sc_hd__decap_3
XTAP_TAPCELL_ROW_76_1307 VGND VPWR sky130_fd_sc_hd__tapvpwrvgnd_1
X_5442_ _5442_/A _5442_/B VGND VGND VPWR VPWR _5443_/B sky130_fd_sc_hd__nor2_2
X_8230_ _8232_/A _8231_/B VGND VGND VPWR VPWR _8230_/Y sky130_fd_sc_hd__nand2_2
XFILLER_105_209 VGND VGND VPWR VPWR sky130_fd_sc_hd__decap_3
XFILLER_114_710 VGND VGND VPWR VPWR sky130_fd_sc_hd__decap_3
X_5373_ _9056_/Q _5624_/B _5875_/B VGND VGND VPWR VPWR _5373_/X sky130_fd_sc_hd__and3_2
X_8161_ _8240_/A _8161_/B VGND VGND VPWR VPWR _8162_/B sky130_fd_sc_hd__nor2_2
XFILLER_126_570 VGND VGND VPWR VPWR sky130_fd_sc_hd__decap_3
XFILLER_99_421 VGND VGND VPWR VPWR sky130_fd_sc_hd__decap_3
XFILLER_126_592 VGND VGND VPWR VPWR sky130_fd_sc_hd__fill_1
XFILLER_99_432 VGND VGND VPWR VPWR sky130_fd_sc_hd__decap_3
X_7112_ _7112_/A VGND VGND VPWR VPWR _7112_/Y sky130_fd_sc_hd__inv_2
X_8092_ _7977_/A _7977_/B _7978_/A VGND VGND VPWR VPWR _8092_/X sky130_fd_sc_hd__a21bo_2
XFILLER_99_476 VGND VGND VPWR VPWR sky130_fd_sc_hd__fill_1
XFILLER_114_776 VGND VGND VPWR VPWR sky130_fd_sc_hd__fill_1
XFILLER_101_404 VGND VGND VPWR VPWR sky130_fd_sc_hd__decap_3
XFILLER_113_264 VGND VGND VPWR VPWR sky130_fd_sc_hd__decap_3
X_7043_ _7043_/A _7043_/B VGND VGND VPWR VPWR _7047_/B sky130_fd_sc_hd__nand2_2
XFILLER_86_115 VGND VGND VPWR VPWR sky130_fd_sc_hd__decap_3
XFILLER_86_126 VGND VGND VPWR VPWR sky130_fd_sc_hd__decap_3
XFILLER_101_437 VGND VGND VPWR VPWR sky130_fd_sc_hd__decap_3
XFILLER_101_459 VGND VGND VPWR VPWR sky130_fd_sc_hd__fill_2
XTAP_TAPCELL_ROW_2_303 VGND VPWR sky130_fd_sc_hd__tapvpwrvgnd_1
XTAP_TAPCELL_ROW_2_314 VGND VPWR sky130_fd_sc_hd__tapvpwrvgnd_1
XFILLER_95_682 VGND VGND VPWR VPWR sky130_fd_sc_hd__fill_1
XFILLER_55_524 VGND VGND VPWR VPWR sky130_fd_sc_hd__decap_3
XFILLER_28_738 VGND VGND VPWR VPWR sky130_fd_sc_hd__decap_3
X_8994_ _8994_/A VGND VGND VPWR VPWR _9337_/D sky130_fd_sc_hd__buf_1
XFILLER_82_321 VGND VGND VPWR VPWR sky130_fd_sc_hd__decap_3
XFILLER_55_546 VGND VGND VPWR VPWR sky130_fd_sc_hd__decap_3
XTAP_TAPCELL_ROW_87_1458 VGND VPWR sky130_fd_sc_hd__tapvpwrvgnd_1
XFILLER_82_343 VGND VGND VPWR VPWR sky130_fd_sc_hd__decap_3
X_7945_ _7945_/A _8050_/B VGND VGND VPWR VPWR _7946_/C sky130_fd_sc_hd__nand2_2
XFILLER_55_579 VGND VGND VPWR VPWR sky130_fd_sc_hd__decap_3
XFILLER_43_719 VGND VGND VPWR VPWR sky130_fd_sc_hd__decap_3
XFILLER_103_69 VGND VGND VPWR VPWR sky130_fd_sc_hd__decap_3
XTAP_TAPCELL_ROW_38_788 VGND VPWR sky130_fd_sc_hd__tapvpwrvgnd_1
XPHY_EDGE_ROW_118_Right_118 VGND VGND VPWR VPWR sky130_fd_sc_hd__decap_3
XTAP_TAPCELL_ROW_38_799 VGND VPWR sky130_fd_sc_hd__tapvpwrvgnd_1
XFILLER_70_538 VGND VGND VPWR VPWR sky130_fd_sc_hd__decap_3
XFILLER_35_270 VGND VGND VPWR VPWR sky130_fd_sc_hd__decap_3
X_7876_ _7229_/A _7885_/B _7881_/C _7877_/A VGND VGND VPWR VPWR _7884_/A sky130_fd_sc_hd__a211o_2
XFILLER_35_281 VGND VGND VPWR VPWR sky130_fd_sc_hd__decap_3
X_6827_ _6809_/A _5326_/X _6805_/A VGND VGND VPWR VPWR _7522_/A sky130_fd_sc_hd__a21oi_2
XFILLER_11_605 VGND VGND VPWR VPWR sky130_fd_sc_hd__decap_3
XFILLER_50_251 VGND VGND VPWR VPWR sky130_fd_sc_hd__fill_1
XFILLER_23_465 VGND VGND VPWR VPWR sky130_fd_sc_hd__fill_1
XFILLER_50_262 VGND VGND VPWR VPWR sky130_fd_sc_hd__decap_3
X_6758_ _9317_/Q _6758_/B _6758_/C VGND VGND VPWR VPWR _6758_/X sky130_fd_sc_hd__and3_2
X_5709_ _5709_/A _5709_/B _5464_/A1 VGND VGND VPWR VPWR _5710_/A sky130_fd_sc_hd__or3b_2
X_6689_ _6689_/A _6689_/B VGND VGND VPWR VPWR _6690_/B sky130_fd_sc_hd__xnor2_4
XFILLER_12_44 VGND VGND VPWR VPWR sky130_fd_sc_hd__fill_2
XFILLER_109_548 VGND VGND VPWR VPWR sky130_fd_sc_hd__decap_3
X_8428_ _7440_/X _7802_/X _8177_/B _8427_/Y VGND VGND VPWR VPWR _8430_/B sky130_fd_sc_hd__a2bb2o_2
XFILLER_12_66 VGND VGND VPWR VPWR sky130_fd_sc_hd__decap_3
XFILLER_128_44 VGND VGND VPWR VPWR sky130_fd_sc_hd__decap_3
XTAP_TAPCELL_ROW_98_1598 VGND VPWR sky130_fd_sc_hd__tapvpwrvgnd_1
XFILLER_124_507 VGND VGND VPWR VPWR sky130_fd_sc_hd__decap_3
XFILLER_128_77 VGND VGND VPWR VPWR sky130_fd_sc_hd__decap_3
X_8359_ _9220_/Q _8566_/A VGND VGND VPWR VPWR _8359_/Y sky130_fd_sc_hd__nand2_2
XFILLER_128_88 VGND VGND VPWR VPWR sky130_fd_sc_hd__decap_3
XFILLER_105_743 VGND VGND VPWR VPWR sky130_fd_sc_hd__fill_2
XFILLER_104_242 VGND VGND VPWR VPWR sky130_fd_sc_hd__decap_3
XFILLER_78_605 VGND VGND VPWR VPWR sky130_fd_sc_hd__decap_3
XFILLER_104_253 VGND VGND VPWR VPWR sky130_fd_sc_hd__decap_3
XFILLER_120_713 VGND VGND VPWR VPWR sky130_fd_sc_hd__decap_3
XFILLER_78_627 VGND VGND VPWR VPWR sky130_fd_sc_hd__decap_3
XTAP_TAPCELL_ROW_129_2020 VGND VPWR sky130_fd_sc_hd__tapvpwrvgnd_1
XFILLER_120_746 VGND VGND VPWR VPWR sky130_fd_sc_hd__decap_3
XFILLER_120_757 VGND VGND VPWR VPWR sky130_fd_sc_hd__decap_3
XFILLER_77_148 VGND VGND VPWR VPWR sky130_fd_sc_hd__decap_3
XFILLER_86_660 VGND VGND VPWR VPWR sky130_fd_sc_hd__decap_3
XFILLER_58_362 VGND VGND VPWR VPWR sky130_fd_sc_hd__fill_2
XFILLER_19_716 VGND VGND VPWR VPWR sky130_fd_sc_hd__decap_3
XFILLER_92_118 VGND VGND VPWR VPWR sky130_fd_sc_hd__fill_1
XFILLER_19_738 VGND VGND VPWR VPWR sky130_fd_sc_hd__decap_3
XFILLER_18_215 VGND VGND VPWR VPWR sky130_fd_sc_hd__decap_3
XFILLER_100_492 VGND VGND VPWR VPWR sky130_fd_sc_hd__decap_3
XFILLER_18_237 VGND VGND VPWR VPWR sky130_fd_sc_hd__decap_3
XFILLER_73_343 VGND VGND VPWR VPWR sky130_fd_sc_hd__fill_1
XFILLER_46_579 VGND VGND VPWR VPWR sky130_fd_sc_hd__decap_3
XFILLER_61_505 VGND VGND VPWR VPWR sky130_fd_sc_hd__decap_3
XFILLER_14_421 VGND VGND VPWR VPWR sky130_fd_sc_hd__decap_3
XFILLER_53_51 VGND VGND VPWR VPWR sky130_fd_sc_hd__decap_3
XFILLER_53_84 VGND VGND VPWR VPWR sky130_fd_sc_hd__decap_3
XFILLER_41_262 VGND VGND VPWR VPWR sky130_fd_sc_hd__decap_3
XFILLER_41_273 VGND VGND VPWR VPWR sky130_fd_sc_hd__decap_3
XFILLER_41_284 VGND VGND VPWR VPWR sky130_fd_sc_hd__decap_3
XFILLER_10_660 VGND VGND VPWR VPWR sky130_fd_sc_hd__decap_3
XFILLER_127_367 VGND VGND VPWR VPWR sky130_fd_sc_hd__decap_3
XFILLER_6_675 VGND VGND VPWR VPWR sky130_fd_sc_hd__decap_3
XTAP_TAPCELL_ROW_58_1059 VGND VPWR sky130_fd_sc_hd__tapvpwrvgnd_1
XFILLER_5_174 VGND VGND VPWR VPWR sky130_fd_sc_hd__fill_1
XFILLER_5_196 VGND VGND VPWR VPWR sky130_fd_sc_hd__decap_3
XFILLER_45_6 VGND VGND VPWR VPWR sky130_fd_sc_hd__decap_3
XFILLER_123_540 VGND VGND VPWR VPWR sky130_fd_sc_hd__decap_3
XTAP_TAPCELL_ROW_71_1237 VGND VPWR sky130_fd_sc_hd__tapvpwrvgnd_1
XFILLER_78_70 VGND VGND VPWR VPWR sky130_fd_sc_hd__fill_1
XFILLER_69_638 VGND VGND VPWR VPWR sky130_fd_sc_hd__decap_3
XFILLER_123_584 VGND VGND VPWR VPWR sky130_fd_sc_hd__decap_3
XFILLER_111_724 VGND VGND VPWR VPWR sky130_fd_sc_hd__decap_3
XFILLER_96_424 VGND VGND VPWR VPWR sky130_fd_sc_hd__fill_2
XFILLER_111_735 VGND VGND VPWR VPWR sky130_fd_sc_hd__fill_2
XFILLER_110_223 VGND VGND VPWR VPWR sky130_fd_sc_hd__decap_3
XFILLER_110_256 VGND VGND VPWR VPWR sky130_fd_sc_hd__fill_1
XFILLER_110_278 VGND VGND VPWR VPWR sky130_fd_sc_hd__decap_3
XFILLER_77_682 VGND VGND VPWR VPWR sky130_fd_sc_hd__decap_3
XFILLER_37_535 VGND VGND VPWR VPWR sky130_fd_sc_hd__decap_3
XFILLER_92_641 VGND VGND VPWR VPWR sky130_fd_sc_hd__decap_3
XFILLER_94_80 VGND VGND VPWR VPWR sky130_fd_sc_hd__decap_3
XFILLER_92_663 VGND VGND VPWR VPWR sky130_fd_sc_hd__fill_2
XFILLER_91_140 VGND VGND VPWR VPWR sky130_fd_sc_hd__decap_3
XFILLER_92_674 VGND VGND VPWR VPWR sky130_fd_sc_hd__decap_3
XFILLER_64_365 VGND VGND VPWR VPWR sky130_fd_sc_hd__fill_1
XFILLER_52_505 VGND VGND VPWR VPWR sky130_fd_sc_hd__decap_3
XFILLER_25_719 VGND VGND VPWR VPWR sky130_fd_sc_hd__decap_3
XFILLER_18_760 VGND VGND VPWR VPWR sky130_fd_sc_hd__decap_3
X_5991_ _9093_/Q _5115_/X _5991_/B1 _5988_/X _5990_/X VGND VGND VPWR VPWR _5991_/X
+ sky130_fd_sc_hd__a221o_2
XFILLER_92_696 VGND VGND VPWR VPWR sky130_fd_sc_hd__decap_3
X_7730_ _6798_/S _7726_/X _7727_/X _7729_/X VGND VGND VPWR VPWR _7731_/B sky130_fd_sc_hd__a31o_2
XFILLER_91_184 VGND VGND VPWR VPWR sky130_fd_sc_hd__decap_3
XFILLER_17_270 VGND VGND VPWR VPWR sky130_fd_sc_hd__fill_2
X_4942_ _5738_/S _6239_/A _9302_/Q VGND VGND VPWR VPWR _4942_/Y sky130_fd_sc_hd__nor3b_2
XFILLER_17_281 VGND VGND VPWR VPWR sky130_fd_sc_hd__decap_3
XTAP_TAPCELL_ROW_35_758 VGND VPWR sky130_fd_sc_hd__tapvpwrvgnd_1
X_7661_ _7661_/A _7661_/B VGND VGND VPWR VPWR _7661_/X sky130_fd_sc_hd__or2_2
X_4873_ _9227_/Q _9226_/Q _9228_/Q _9231_/Q VGND VGND VPWR VPWR _4873_/X sky130_fd_sc_hd__and4_2
XFILLER_60_571 VGND VGND VPWR VPWR sky130_fd_sc_hd__decap_3
XTAP_TAPCELL_ROW_82_1388 VGND VPWR sky130_fd_sc_hd__tapvpwrvgnd_1
XFILLER_60_582 VGND VGND VPWR VPWR sky130_fd_sc_hd__decap_3
X_6612_ _6612_/A _6612_/B _6612_/C _6612_/D VGND VGND VPWR VPWR _6612_/Y sky130_fd_sc_hd__nor4_4
XFILLER_20_424 VGND VGND VPWR VPWR sky130_fd_sc_hd__decap_3
XTAP_TAPCELL_ROW_15_482 VGND VPWR sky130_fd_sc_hd__tapvpwrvgnd_1
X_7592_ _7590_/X _7591_/X _7764_/A VGND VGND VPWR VPWR _7592_/X sky130_fd_sc_hd__a21o_2
XFILLER_20_457 VGND VGND VPWR VPWR sky130_fd_sc_hd__decap_3
X_9331_ _9331_/CLK _9331_/D fanout389/X VGND VGND VPWR VPWR _9331_/Q sky130_fd_sc_hd__dfrtp_2
X_6543_ _6363_/B _6542_/Y _6533_/A1 VGND VGND VPWR VPWR _6643_/B sky130_fd_sc_hd__a21boi_2
XFILLER_9_491 VGND VGND VPWR VPWR sky130_fd_sc_hd__fill_1
X_9262_ _9308_/CLK _9262_/D fanout367/X VGND VGND VPWR VPWR _9262_/Q sky130_fd_sc_hd__dfrtp_2
X_6474_ _6843_/A _6474_/B VGND VGND VPWR VPWR _6495_/B sky130_fd_sc_hd__xnor2_2
XFILLER_106_529 VGND VGND VPWR VPWR sky130_fd_sc_hd__decap_3
X_8213_ _8205_/Y _8212_/Y _8291_/S VGND VGND VPWR VPWR _8214_/A sky130_fd_sc_hd__mux2_2
XFILLER_118_389 VGND VGND VPWR VPWR sky130_fd_sc_hd__decap_3
X_5425_ _5425_/A _5425_/B VGND VGND VPWR VPWR _5426_/B sky130_fd_sc_hd__xor2_2
XPHY_EDGE_ROW_12_Right_12 VGND VGND VPWR VPWR sky130_fd_sc_hd__decap_3
X_9193_ _9227_/CLK _9193_/D load_slew416/X VGND VGND VPWR VPWR _9193_/Q sky130_fd_sc_hd__dfrtp_2
X_5356_ _5356_/A _8080_/A VGND VGND VPWR VPWR _5439_/S sky130_fd_sc_hd__nand2_2
X_8144_ _9220_/Q _8144_/B VGND VGND VPWR VPWR _8217_/A sky130_fd_sc_hd__xnor2_2
XFILLER_99_240 VGND VGND VPWR VPWR sky130_fd_sc_hd__fill_1
XFILLER_114_562 VGND VGND VPWR VPWR sky130_fd_sc_hd__decap_3
XFILLER_58_29 VGND VGND VPWR VPWR sky130_fd_sc_hd__fill_1
X_5287_ _6033_/A _5294_/B VGND VGND VPWR VPWR _6279_/A sky130_fd_sc_hd__nand2_2
X_8075_ _8075_/A _8075_/B VGND VGND VPWR VPWR _8078_/A sky130_fd_sc_hd__xnor2_2
XFILLER_101_234 VGND VGND VPWR VPWR sky130_fd_sc_hd__decap_3
XFILLER_102_757 VGND VGND VPWR VPWR sky130_fd_sc_hd__decap_3
XFILLER_87_457 VGND VGND VPWR VPWR sky130_fd_sc_hd__decap_3
X_7026_ _6904_/X _7025_/Y _8117_/S VGND VGND VPWR VPWR _7027_/A sky130_fd_sc_hd__mux2_2
XFILLER_114_24 VGND VGND VPWR VPWR sky130_fd_sc_hd__decap_3
XFILLER_114_35 VGND VGND VPWR VPWR sky130_fd_sc_hd__decap_3
XFILLER_68_693 VGND VGND VPWR VPWR sky130_fd_sc_hd__decap_3
XFILLER_114_68 VGND VGND VPWR VPWR sky130_fd_sc_hd__decap_3
XFILLER_55_343 VGND VGND VPWR VPWR sky130_fd_sc_hd__decap_3
XPHY_EDGE_ROW_21_Right_21 VGND VGND VPWR VPWR sky130_fd_sc_hd__decap_3
XFILLER_43_505 VGND VGND VPWR VPWR sky130_fd_sc_hd__decap_3
XFILLER_16_719 VGND VGND VPWR VPWR sky130_fd_sc_hd__decap_3
X_8977_ _8977_/A VGND VGND VPWR VPWR _9329_/D sky130_fd_sc_hd__buf_1
XFILLER_55_376 VGND VGND VPWR VPWR sky130_fd_sc_hd__decap_3
XFILLER_130_12 VGND VGND VPWR VPWR sky130_fd_sc_hd__decap_3
XFILLER_15_218 VGND VGND VPWR VPWR sky130_fd_sc_hd__decap_3
XFILLER_70_324 VGND VGND VPWR VPWR sky130_fd_sc_hd__decap_3
X_7928_ _7928_/A VGND VGND VPWR VPWR _7979_/A sky130_fd_sc_hd__inv_2
XFILLER_43_549 VGND VGND VPWR VPWR sky130_fd_sc_hd__decap_3
XFILLER_70_346 VGND VGND VPWR VPWR sky130_fd_sc_hd__decap_3
XFILLER_24_741 VGND VGND VPWR VPWR sky130_fd_sc_hd__decap_3
XFILLER_24_763 VGND VGND VPWR VPWR sky130_fd_sc_hd__decap_3
XFILLER_130_78 VGND VGND VPWR VPWR sky130_fd_sc_hd__decap_3
X_7859_ _7854_/X _7853_/X _7855_/X _7858_/X VGND VGND VPWR VPWR _7859_/Y sky130_fd_sc_hd__a211oi_4
XFILLER_23_21 VGND VGND VPWR VPWR sky130_fd_sc_hd__decap_3
XFILLER_51_593 VGND VGND VPWR VPWR sky130_fd_sc_hd__decap_3
XFILLER_23_284 VGND VGND VPWR VPWR sky130_fd_sc_hd__decap_3
XFILLER_11_435 VGND VGND VPWR VPWR sky130_fd_sc_hd__fill_1
XFILLER_128_109 VGND VGND VPWR VPWR sky130_fd_sc_hd__decap_3
Xwire326 _5926_/B VGND VGND VPWR VPWR _5936_/A sky130_fd_sc_hd__buf_4
XFILLER_23_76 VGND VGND VPWR VPWR sky130_fd_sc_hd__decap_3
XFILLER_128_3 VGND VGND VPWR VPWR sky130_fd_sc_hd__decap_3
XPHY_EDGE_ROW_30_Right_30 VGND VGND VPWR VPWR sky130_fd_sc_hd__decap_3
XFILLER_3_601 VGND VGND VPWR VPWR sky130_fd_sc_hd__decap_3
XFILLER_3_623 VGND VGND VPWR VPWR sky130_fd_sc_hd__decap_3
XFILLER_2_100 VGND VGND VPWR VPWR sky130_fd_sc_hd__decap_3
XFILLER_124_348 VGND VGND VPWR VPWR sky130_fd_sc_hd__decap_3
XFILLER_3_656 VGND VGND VPWR VPWR sky130_fd_sc_hd__decap_3
XFILLER_2_133 VGND VGND VPWR VPWR sky130_fd_sc_hd__decap_3
XFILLER_78_435 VGND VGND VPWR VPWR sky130_fd_sc_hd__decap_3
XFILLER_48_62 VGND VGND VPWR VPWR sky130_fd_sc_hd__decap_3
XFILLER_120_576 VGND VGND VPWR VPWR sky130_fd_sc_hd__fill_1
XFILLER_93_449 VGND VGND VPWR VPWR sky130_fd_sc_hd__decap_3
XFILLER_19_546 VGND VGND VPWR VPWR sky130_fd_sc_hd__decap_3
XTAP_TAPCELL_ROW_109_1756 VGND VPWR sky130_fd_sc_hd__tapvpwrvgnd_1
XFILLER_0_47 VGND VGND VPWR VPWR sky130_fd_sc_hd__decap_3
XFILLER_74_674 VGND VGND VPWR VPWR sky130_fd_sc_hd__decap_3
XFILLER_46_365 VGND VGND VPWR VPWR sky130_fd_sc_hd__decap_3
XFILLER_73_162 VGND VGND VPWR VPWR sky130_fd_sc_hd__decap_3
XFILLER_34_527 VGND VGND VPWR VPWR sky130_fd_sc_hd__decap_3
XFILLER_61_324 VGND VGND VPWR VPWR sky130_fd_sc_hd__decap_3
XTAP_TAPCELL_ROW_122_1923 VGND VPWR sky130_fd_sc_hd__tapvpwrvgnd_1
XTAP_TAPCELL_ROW_122_1934 VGND VPWR sky130_fd_sc_hd__tapvpwrvgnd_1
XFILLER_61_346 VGND VGND VPWR VPWR sky130_fd_sc_hd__decap_3
XFILLER_15_741 VGND VGND VPWR VPWR sky130_fd_sc_hd__decap_3
XPHY_EDGE_ROW_14_Left_145 VGND VGND VPWR VPWR sky130_fd_sc_hd__decap_3
XFILLER_9_12 VGND VGND VPWR VPWR sky130_fd_sc_hd__decap_3
XFILLER_61_379 VGND VGND VPWR VPWR sky130_fd_sc_hd__decap_3
XFILLER_15_774 VGND VGND VPWR VPWR sky130_fd_sc_hd__decap_3
XTAP_TAPCELL_ROW_32_717 VGND VPWR sky130_fd_sc_hd__tapvpwrvgnd_1
XFILLER_9_45 VGND VGND VPWR VPWR sky130_fd_sc_hd__decap_3
XFILLER_14_284 VGND VGND VPWR VPWR sky130_fd_sc_hd__decap_3
XFILLER_30_766 VGND VGND VPWR VPWR sky130_fd_sc_hd__decap_3
XTAP_TAPCELL_ROW_12_441 VGND VPWR sky130_fd_sc_hd__tapvpwrvgnd_1
XFILLER_128_610 VGND VGND VPWR VPWR sky130_fd_sc_hd__decap_3
XFILLER_80_82 VGND VGND VPWR VPWR sky130_fd_sc_hd__fill_2
XFILLER_80_93 VGND VGND VPWR VPWR sky130_fd_sc_hd__decap_3
XFILLER_128_643 VGND VGND VPWR VPWR sky130_fd_sc_hd__fill_1
XFILLER_128_654 VGND VGND VPWR VPWR sky130_fd_sc_hd__decap_3
XFILLER_127_131 VGND VGND VPWR VPWR sky130_fd_sc_hd__decap_3
Xhold907 _4756_/X VGND VGND VPWR VPWR _4757_/A sky130_fd_sc_hd__dlygate4sd3_1
XFILLER_128_687 VGND VGND VPWR VPWR sky130_fd_sc_hd__decap_3
Xhold918 _9128_/Q VGND VGND VPWR VPWR hold918/X sky130_fd_sc_hd__dlygate4sd3_1
XFILLER_127_164 VGND VGND VPWR VPWR sky130_fd_sc_hd__decap_3
XFILLER_127_175 VGND VGND VPWR VPWR sky130_fd_sc_hd__decap_3
Xhold929 _4773_/X VGND VGND VPWR VPWR _4774_/A sky130_fd_sc_hd__dlygate4sd3_1
XFILLER_6_483 VGND VGND VPWR VPWR sky130_fd_sc_hd__decap_3
XFILLER_115_337 VGND VGND VPWR VPWR sky130_fd_sc_hd__decap_3
X_5210_ _5244_/A _5210_/B VGND VGND VPWR VPWR _5211_/B sky130_fd_sc_hd__xor2_2
XPHY_EDGE_ROW_23_Left_154 VGND VGND VPWR VPWR sky130_fd_sc_hd__decap_3
X_6190_ _6190_/A _6190_/B VGND VGND VPWR VPWR _6190_/Y sky130_fd_sc_hd__nand2_2
XFILLER_43_3 VGND VGND VPWR VPWR sky130_fd_sc_hd__fill_2
XFILLER_130_318 VGND VGND VPWR VPWR sky130_fd_sc_hd__decap_3
X_5141_ _5443_/A VGND VGND VPWR VPWR _8780_/B sky130_fd_sc_hd__clkbuf_1
XFILLER_97_755 VGND VGND VPWR VPWR sky130_fd_sc_hd__fill_1
XFILLER_96_232 VGND VGND VPWR VPWR sky130_fd_sc_hd__decap_3
XFILLER_69_446 VGND VGND VPWR VPWR sky130_fd_sc_hd__fill_2
XFILLER_69_468 VGND VGND VPWR VPWR sky130_fd_sc_hd__decap_3
X_5072_ _5137_/A _6976_/C VGND VGND VPWR VPWR _7098_/C sky130_fd_sc_hd__nand2_4
XFILLER_96_265 VGND VGND VPWR VPWR sky130_fd_sc_hd__decap_3
XFILLER_84_427 VGND VGND VPWR VPWR sky130_fd_sc_hd__fill_2
X_8900_ _9293_/Q hold848/X _8904_/S VGND VGND VPWR VPWR _8900_/X sky130_fd_sc_hd__mux2_2
XFILLER_37_310 VGND VGND VPWR VPWR sky130_fd_sc_hd__decap_3
XFILLER_84_449 VGND VGND VPWR VPWR sky130_fd_sc_hd__decap_3
XFILLER_65_641 VGND VGND VPWR VPWR sky130_fd_sc_hd__decap_3
X_8831_ _8865_/A1 _8831_/A1 _8841_/S VGND VGND VPWR VPWR _8832_/A sky130_fd_sc_hd__mux2_2
XFILLER_37_354 VGND VGND VPWR VPWR sky130_fd_sc_hd__decap_3
XFILLER_25_505 VGND VGND VPWR VPWR sky130_fd_sc_hd__decap_3
XTAP_TAPCELL_ROW_84_1417 VGND VPWR sky130_fd_sc_hd__tapvpwrvgnd_1
XFILLER_92_471 VGND VGND VPWR VPWR sky130_fd_sc_hd__decap_3
XPHY_EDGE_ROW_32_Left_163 VGND VGND VPWR VPWR sky130_fd_sc_hd__decap_3
XFILLER_37_398 VGND VGND VPWR VPWR sky130_fd_sc_hd__decap_3
X_8762_ _8768_/A _8768_/B VGND VGND VPWR VPWR _8770_/C sky130_fd_sc_hd__nor2_2
X_5974_ _5973_/C _5972_/X _5907_/D _5973_/X VGND VGND VPWR VPWR wire48/A sky130_fd_sc_hd__a211oi_2
XFILLER_80_666 VGND VGND VPWR VPWR sky130_fd_sc_hd__decap_3
X_7713_ _6873_/Y _7176_/B _6487_/B VGND VGND VPWR VPWR _7713_/X sky130_fd_sc_hd__a21bo_2
X_4925_ _5457_/A VGND VGND VPWR VPWR _4955_/B sky130_fd_sc_hd__clkbuf_2
XFILLER_52_379 VGND VGND VPWR VPWR sky130_fd_sc_hd__decap_3
XFILLER_100_15 VGND VGND VPWR VPWR sky130_fd_sc_hd__decap_3
X_8693_ _9230_/Q _8693_/B VGND VGND VPWR VPWR _8694_/B sky130_fd_sc_hd__xnor2_2
XFILLER_80_699 VGND VGND VPWR VPWR sky130_fd_sc_hd__fill_1
XFILLER_21_711 VGND VGND VPWR VPWR sky130_fd_sc_hd__decap_3
X_7644_ _9213_/Q _7924_/B _7365_/A _7484_/A _7643_/B VGND VGND VPWR VPWR _7644_/X
+ sky130_fd_sc_hd__o311a_2
XFILLER_21_744 VGND VGND VPWR VPWR sky130_fd_sc_hd__decap_3
X_4856_ _4856_/A VGND VGND VPWR VPWR _9172_/D sky130_fd_sc_hd__buf_1
XFILLER_60_390 VGND VGND VPWR VPWR sky130_fd_sc_hd__decap_3
X_7575_ _6762_/C _7570_/X _7574_/X _8411_/A VGND VGND VPWR VPWR _7816_/A sky130_fd_sc_hd__a22o_2
XFILLER_20_265 VGND VGND VPWR VPWR sky130_fd_sc_hd__fill_1
X_4787_ _4787_/A VGND VGND VPWR VPWR _9139_/D sky130_fd_sc_hd__buf_1
X_9314_ _9346_/CLK _9314_/D fanout403/X VGND VGND VPWR VPWR _9314_/Q sky130_fd_sc_hd__dfrtp_2
X_6526_ _6526_/A _6526_/B VGND VGND VPWR VPWR _6526_/Y sky130_fd_sc_hd__xnor2_2
XFILLER_109_24 VGND VGND VPWR VPWR sky130_fd_sc_hd__decap_3
XFILLER_119_676 VGND VGND VPWR VPWR sky130_fd_sc_hd__decap_3
XFILLER_4_409 VGND VGND VPWR VPWR sky130_fd_sc_hd__fill_2
XFILLER_114_9 VGND VGND VPWR VPWR sky130_fd_sc_hd__decap_3
XFILLER_119_687 VGND VGND VPWR VPWR sky130_fd_sc_hd__decap_3
XPHY_EDGE_ROW_41_Left_172 VGND VGND VPWR VPWR sky130_fd_sc_hd__decap_3
X_9245_ _9308_/CLK _9245_/D fanout367/X VGND VGND VPWR VPWR _9245_/Q sky130_fd_sc_hd__dfrtp_2
X_6457_ _6509_/A _6457_/B VGND VGND VPWR VPWR _6458_/B sky130_fd_sc_hd__xor2_2
XFILLER_106_337 VGND VGND VPWR VPWR sky130_fd_sc_hd__fill_1
XTAP_TAPCELL_ROW_95_1568 VGND VPWR sky130_fd_sc_hd__tapvpwrvgnd_1
XFILLER_118_197 VGND VGND VPWR VPWR sky130_fd_sc_hd__decap_3
XFILLER_106_359 VGND VGND VPWR VPWR sky130_fd_sc_hd__decap_3
X_5408_ _5410_/B _5406_/X _5307_/B _5407_/X _5247_/A VGND VGND VPWR VPWR _5408_/X
+ sky130_fd_sc_hd__a221o_2
X_9176_ _9348_/CLK _9176_/D load_slew390/X VGND VGND VPWR VPWR _9176_/Q sky130_fd_sc_hd__dfrtp_2
XFILLER_0_604 VGND VGND VPWR VPWR sky130_fd_sc_hd__decap_3
X_6388_ _6266_/A _6266_/B _6387_/Y _6068_/Y VGND VGND VPWR VPWR _6388_/X sky130_fd_sc_hd__o22a_2
XFILLER_0_626 VGND VGND VPWR VPWR sky130_fd_sc_hd__decap_3
XFILLER_125_12 VGND VGND VPWR VPWR sky130_fd_sc_hd__decap_3
XFILLER_121_329 VGND VGND VPWR VPWR sky130_fd_sc_hd__decap_3
X_8127_ _8127_/A _8196_/C VGND VGND VPWR VPWR _8127_/X sky130_fd_sc_hd__xor2_2
X_5339_ _5339_/A0 hold824/X _5530_/S VGND VGND VPWR VPWR _5339_/X sky130_fd_sc_hd__mux2_2
XFILLER_88_744 VGND VGND VPWR VPWR sky130_fd_sc_hd__decap_3
XFILLER_0_648 VGND VGND VPWR VPWR sky130_fd_sc_hd__decap_3
XFILLER_125_45 VGND VGND VPWR VPWR sky130_fd_sc_hd__decap_3
XFILLER_114_392 VGND VGND VPWR VPWR sky130_fd_sc_hd__decap_3
XFILLER_102_543 VGND VGND VPWR VPWR sky130_fd_sc_hd__decap_3
X_8058_ _8058_/A _8058_/B VGND VGND VPWR VPWR _8058_/Y sky130_fd_sc_hd__xnor2_4
XFILLER_85_27 VGND VGND VPWR VPWR sky130_fd_sc_hd__decap_3
XFILLER_125_78 VGND VGND VPWR VPWR sky130_fd_sc_hd__decap_3
XFILLER_102_587 VGND VGND VPWR VPWR sky130_fd_sc_hd__fill_1
XFILLER_102_598 VGND VGND VPWR VPWR sky130_fd_sc_hd__decap_3
X_7009_ _7009_/A _7009_/B VGND VGND VPWR VPWR _7108_/A sky130_fd_sc_hd__xor2_4
XFILLER_47_129 VGND VGND VPWR VPWR sky130_fd_sc_hd__decap_3
XFILLER_18_21 VGND VGND VPWR VPWR sky130_fd_sc_hd__decap_3
XFILLER_75_449 VGND VGND VPWR VPWR sky130_fd_sc_hd__decap_3
XFILLER_56_630 VGND VGND VPWR VPWR sky130_fd_sc_hd__decap_3
XPHY_EDGE_ROW_50_Left_181 VGND VGND VPWR VPWR sky130_fd_sc_hd__decap_3
XFILLER_90_419 VGND VGND VPWR VPWR sky130_fd_sc_hd__fill_1
XFILLER_28_365 VGND VGND VPWR VPWR sky130_fd_sc_hd__decap_3
XFILLER_71_600 VGND VGND VPWR VPWR sky130_fd_sc_hd__decap_3
XFILLER_43_302 VGND VGND VPWR VPWR sky130_fd_sc_hd__decap_3
XFILLER_83_482 VGND VGND VPWR VPWR sky130_fd_sc_hd__decap_3
XFILLER_16_527 VGND VGND VPWR VPWR sky130_fd_sc_hd__decap_3
XFILLER_16_549 VGND VGND VPWR VPWR sky130_fd_sc_hd__decap_3
XFILLER_43_346 VGND VGND VPWR VPWR sky130_fd_sc_hd__decap_3
XFILLER_70_165 VGND VGND VPWR VPWR sky130_fd_sc_hd__decap_3
XFILLER_24_571 VGND VGND VPWR VPWR sky130_fd_sc_hd__decap_3
XFILLER_12_722 VGND VGND VPWR VPWR sky130_fd_sc_hd__decap_3
XTAP_TAPCELL_ROW_104_1686 VGND VPWR sky130_fd_sc_hd__tapvpwrvgnd_1
XFILLER_11_221 VGND VGND VPWR VPWR sky130_fd_sc_hd__decap_3
XFILLER_8_704 VGND VGND VPWR VPWR sky130_fd_sc_hd__decap_3
XFILLER_12_755 VGND VGND VPWR VPWR sky130_fd_sc_hd__fill_1
XFILLER_12_766 VGND VGND VPWR VPWR sky130_fd_sc_hd__decap_3
Xwire123 _5735_/Y VGND VGND VPWR VPWR wire123/X sky130_fd_sc_hd__buf_6
XFILLER_8_737 VGND VGND VPWR VPWR sky130_fd_sc_hd__decap_3
XFILLER_7_225 VGND VGND VPWR VPWR sky130_fd_sc_hd__decap_3
XFILLER_11_287 VGND VGND VPWR VPWR sky130_fd_sc_hd__decap_3
XFILLER_50_41 VGND VGND VPWR VPWR sky130_fd_sc_hd__decap_3
Xwire156 _5203_/Y VGND VGND VPWR VPWR _6685_/A sky130_fd_sc_hd__buf_4
XFILLER_124_112 VGND VGND VPWR VPWR sky130_fd_sc_hd__decap_3
XTAP_TAPCELL_ROW_55_1018 VGND VPWR sky130_fd_sc_hd__tapvpwrvgnd_1
XTAP_TAPCELL_ROW_55_1029 VGND VPWR sky130_fd_sc_hd__tapvpwrvgnd_1
XFILLER_124_156 VGND VGND VPWR VPWR sky130_fd_sc_hd__decap_3
XFILLER_124_189 VGND VGND VPWR VPWR sky130_fd_sc_hd__decap_3
XFILLER_105_381 VGND VGND VPWR VPWR sky130_fd_sc_hd__decap_3
XFILLER_93_202 VGND VGND VPWR VPWR sky130_fd_sc_hd__decap_3
XFILLER_66_427 VGND VGND VPWR VPWR sky130_fd_sc_hd__decap_3
XFILLER_94_747 VGND VGND VPWR VPWR sky130_fd_sc_hd__decap_3
XFILLER_19_365 VGND VGND VPWR VPWR sky130_fd_sc_hd__decap_3
XTAP_TAPCELL_ROW_17_511 VGND VPWR sky130_fd_sc_hd__tapvpwrvgnd_1
XFILLER_62_655 VGND VGND VPWR VPWR sky130_fd_sc_hd__decap_3
XTAP_TAPCELL_ROW_66_1169 VGND VPWR sky130_fd_sc_hd__tapvpwrvgnd_1
XFILLER_34_368 VGND VGND VPWR VPWR sky130_fd_sc_hd__decap_3
XTAP_TAPCELL_ROW_45_886 VGND VPWR sky130_fd_sc_hd__tapvpwrvgnd_1
X_4710_ _9103_/Q _4710_/A1 _4714_/S VGND VGND VPWR VPWR _4710_/X sky130_fd_sc_hd__mux2_2
XFILLER_15_593 VGND VGND VPWR VPWR sky130_fd_sc_hd__decap_3
XFILLER_30_530 VGND VGND VPWR VPWR sky130_fd_sc_hd__fill_2
X_5690_ _6685_/A _5897_/C VGND VGND VPWR VPWR _5695_/A sky130_fd_sc_hd__nand2_2
XFILLER_30_552 VGND VGND VPWR VPWR sky130_fd_sc_hd__decap_3
X_4641_ _4641_/A VGND VGND VPWR VPWR _9070_/D sky130_fd_sc_hd__buf_1
X_4572_ _4572_/A VGND VGND VPWR VPWR _9037_/D sky130_fd_sc_hd__buf_1
X_7360_ _5014_/X _5041_/B _5984_/B _8161_/B VGND VGND VPWR VPWR _7360_/X sky130_fd_sc_hd__o22a_2
X_6311_ _6311_/A _8066_/A VGND VGND VPWR VPWR _6315_/A sky130_fd_sc_hd__nor2_2
XFILLER_115_101 VGND VGND VPWR VPWR sky130_fd_sc_hd__decap_3
X_7291_ _6354_/A _6354_/B _7805_/A VGND VGND VPWR VPWR _7450_/B sky130_fd_sc_hd__a21o_2
XFILLER_6_291 VGND VGND VPWR VPWR sky130_fd_sc_hd__decap_3
X_9030_ _9142_/CLK _9030_/D load_slew404/X VGND VGND VPWR VPWR _9030_/Q sky130_fd_sc_hd__dfrtp_2
XFILLER_89_508 VGND VGND VPWR VPWR sky130_fd_sc_hd__fill_1
X_6242_ _9250_/Q _6751_/A2 _6241_/X VGND VGND VPWR VPWR _6354_/B sky130_fd_sc_hd__a21oi_2
Xhold759 _6426_/A VGND VGND VPWR VPWR hold759/X sky130_fd_sc_hd__dlygate4sd3_1
XFILLER_103_318 VGND VGND VPWR VPWR sky130_fd_sc_hd__fill_2
XFILLER_69_210 VGND VGND VPWR VPWR sky130_fd_sc_hd__decap_3
X_6173_ _6169_/B _6172_/C _6172_/A VGND VGND VPWR VPWR _6184_/D sky130_fd_sc_hd__a21oi_2
XFILLER_130_137 VGND VGND VPWR VPWR sky130_fd_sc_hd__decap_3
XFILLER_97_541 VGND VGND VPWR VPWR sky130_fd_sc_hd__decap_3
XFILLER_130_159 VGND VGND VPWR VPWR sky130_fd_sc_hd__decap_3
X_5124_ _5165_/A VGND VGND VPWR VPWR _7313_/A sky130_fd_sc_hd__clkbuf_4
XFILLER_69_254 VGND VGND VPWR VPWR sky130_fd_sc_hd__decap_3
XTAP_TAPCELL_ROW_90_1498 VGND VPWR sky130_fd_sc_hd__tapvpwrvgnd_1
XFILLER_84_202 VGND VGND VPWR VPWR sky130_fd_sc_hd__decap_3
XFILLER_69_276 VGND VGND VPWR VPWR sky130_fd_sc_hd__decap_3
XFILLER_29_107 VGND VGND VPWR VPWR sky130_fd_sc_hd__decap_3
XFILLER_85_747 VGND VGND VPWR VPWR sky130_fd_sc_hd__decap_3
XFILLER_111_384 VGND VGND VPWR VPWR sky130_fd_sc_hd__fill_1
X_5055_ _9036_/Q _6757_/B _5442_/A VGND VGND VPWR VPWR _5055_/X sky130_fd_sc_hd__and3_2
XFILLER_57_449 VGND VGND VPWR VPWR sky130_fd_sc_hd__decap_3
XFILLER_85_769 VGND VGND VPWR VPWR sky130_fd_sc_hd__decap_3
XFILLER_72_408 VGND VGND VPWR VPWR sky130_fd_sc_hd__decap_3
XFILLER_84_279 VGND VGND VPWR VPWR sky130_fd_sc_hd__decap_3
XFILLER_38_685 VGND VGND VPWR VPWR sky130_fd_sc_hd__decap_3
XFILLER_37_162 VGND VGND VPWR VPWR sky130_fd_sc_hd__decap_3
X_8814_ _9252_/Q hold812/X _8820_/S VGND VGND VPWR VPWR _8814_/X sky130_fd_sc_hd__mux2_2
XFILLER_52_110 VGND VGND VPWR VPWR sky130_fd_sc_hd__decap_3
XFILLER_111_36 VGND VGND VPWR VPWR sky130_fd_sc_hd__decap_3
XFILLER_80_463 VGND VGND VPWR VPWR sky130_fd_sc_hd__decap_3
XFILLER_52_154 VGND VGND VPWR VPWR sky130_fd_sc_hd__decap_3
XFILLER_25_368 VGND VGND VPWR VPWR sky130_fd_sc_hd__decap_3
X_8745_ _8770_/B _8745_/B VGND VGND VPWR VPWR _8746_/B sky130_fd_sc_hd__xnor2_2
X_5957_ _5957_/A _6076_/A _5794_/Y VGND VGND VPWR VPWR _5957_/X sky130_fd_sc_hd__or3b_2
XFILLER_80_485 VGND VGND VPWR VPWR sky130_fd_sc_hd__decap_3
X_4908_ _4876_/A _4907_/Y _4878_/A hold787/X VGND VGND VPWR VPWR _4908_/X sky130_fd_sc_hd__a2bb2o_2
X_8676_ _8678_/A _8676_/B _8676_/C VGND VGND VPWR VPWR _8676_/X sky130_fd_sc_hd__and3_2
XFILLER_21_530 VGND VGND VPWR VPWR sky130_fd_sc_hd__fill_2
X_5888_ _9280_/Q _6336_/B _6336_/C VGND VGND VPWR VPWR _5888_/X sky130_fd_sc_hd__and3_2
X_7627_ _7626_/A _7626_/B _7626_/C _7626_/D VGND VGND VPWR VPWR _7627_/X sky130_fd_sc_hd__o22a_2
X_4839_ _4839_/A VGND VGND VPWR VPWR _9164_/D sky130_fd_sc_hd__buf_1
X_7558_ _7558_/A _7558_/B VGND VGND VPWR VPWR _7559_/B sky130_fd_sc_hd__nand2_2
XFILLER_5_718 VGND VGND VPWR VPWR sky130_fd_sc_hd__decap_3
XFILLER_5_729 VGND VGND VPWR VPWR sky130_fd_sc_hd__decap_3
XFILLER_4_217 VGND VGND VPWR VPWR sky130_fd_sc_hd__fill_1
XFILLER_112_6 VGND VGND VPWR VPWR sky130_fd_sc_hd__decap_3
X_6509_ _6509_/A _6509_/B VGND VGND VPWR VPWR _6509_/Y sky130_fd_sc_hd__nor2_2
X_7489_ _7489_/A _7639_/B VGND VGND VPWR VPWR _7492_/B sky130_fd_sc_hd__and2_4
X_9228_ _9228_/CLK _9228_/D fanout405/A VGND VGND VPWR VPWR _9228_/Q sky130_fd_sc_hd__dfrtp_2
XFILLER_106_167 VGND VGND VPWR VPWR sky130_fd_sc_hd__decap_3
XFILLER_20_88 VGND VGND VPWR VPWR sky130_fd_sc_hd__decap_3
XFILLER_122_616 VGND VGND VPWR VPWR sky130_fd_sc_hd__decap_3
XFILLER_106_189 VGND VGND VPWR VPWR sky130_fd_sc_hd__decap_3
X_9159_ _9159_/CLK _9159_/D fanout389/X VGND VGND VPWR VPWR _9159_/Q sky130_fd_sc_hd__dfrtp_2
XFILLER_121_137 VGND VGND VPWR VPWR sky130_fd_sc_hd__decap_3
XFILLER_0_445 VGND VGND VPWR VPWR sky130_fd_sc_hd__decap_3
XFILLER_88_552 VGND VGND VPWR VPWR sky130_fd_sc_hd__decap_3
XFILLER_88_574 VGND VGND VPWR VPWR sky130_fd_sc_hd__fill_1
XFILLER_29_31 VGND VGND VPWR VPWR sky130_fd_sc_hd__decap_3
XFILLER_130_660 VGND VGND VPWR VPWR sky130_fd_sc_hd__decap_3
XFILLER_102_362 VGND VGND VPWR VPWR sky130_fd_sc_hd__fill_2
XFILLER_76_736 VGND VGND VPWR VPWR sky130_fd_sc_hd__decap_3
XFILLER_130_682 VGND VGND VPWR VPWR sky130_fd_sc_hd__decap_3
XFILLER_75_213 VGND VGND VPWR VPWR sky130_fd_sc_hd__fill_1
XFILLER_76_769 VGND VGND VPWR VPWR sky130_fd_sc_hd__decap_3
XFILLER_75_257 VGND VGND VPWR VPWR sky130_fd_sc_hd__decap_3
XFILLER_91_739 VGND VGND VPWR VPWR sky130_fd_sc_hd__fill_1
XTAP_TAPCELL_ROW_106_1715 VGND VPWR sky130_fd_sc_hd__tapvpwrvgnd_1
XFILLER_56_471 VGND VGND VPWR VPWR sky130_fd_sc_hd__decap_3
XFILLER_28_162 VGND VGND VPWR VPWR sky130_fd_sc_hd__decap_3
XFILLER_45_30 VGND VGND VPWR VPWR sky130_fd_sc_hd__decap_3
XFILLER_29_696 VGND VGND VPWR VPWR sky130_fd_sc_hd__decap_3
XFILLER_16_324 VGND VGND VPWR VPWR sky130_fd_sc_hd__decap_3
XFILLER_83_290 VGND VGND VPWR VPWR sky130_fd_sc_hd__fill_2
XFILLER_45_52 VGND VGND VPWR VPWR sky130_fd_sc_hd__decap_3
XFILLER_45_63 VGND VGND VPWR VPWR sky130_fd_sc_hd__fill_1
XFILLER_43_143 VGND VGND VPWR VPWR sky130_fd_sc_hd__decap_3
XFILLER_45_85 VGND VGND VPWR VPWR sky130_fd_sc_hd__fill_1
XFILLER_44_677 VGND VGND VPWR VPWR sky130_fd_sc_hd__decap_3
XFILLER_44_699 VGND VGND VPWR VPWR sky130_fd_sc_hd__fill_1
XFILLER_71_496 VGND VGND VPWR VPWR sky130_fd_sc_hd__decap_3
XTAP_TAPCELL_ROW_42_845 VGND VPWR sky130_fd_sc_hd__tapvpwrvgnd_1
XFILLER_31_349 VGND VGND VPWR VPWR sky130_fd_sc_hd__fill_2
XFILLER_12_530 VGND VGND VPWR VPWR sky130_fd_sc_hd__fill_2
XFILLER_12_563 VGND VGND VPWR VPWR sky130_fd_sc_hd__decap_3
XFILLER_8_523 VGND VGND VPWR VPWR sky130_fd_sc_hd__decap_3
XFILLER_129_237 VGND VGND VPWR VPWR sky130_fd_sc_hd__decap_3
XFILLER_8_545 VGND VGND VPWR VPWR sky130_fd_sc_hd__decap_3
XFILLER_77_9 VGND VGND VPWR VPWR sky130_fd_sc_hd__decap_3
XTAP_TAPCELL_ROW_61_1099 VGND VPWR sky130_fd_sc_hd__tapvpwrvgnd_1
XTAP_TAPCELL_ROW_22_580 VGND VPWR sky130_fd_sc_hd__tapvpwrvgnd_1
XFILLER_6_24 VGND VGND VPWR VPWR sky130_fd_sc_hd__decap_3
XFILLER_6_35 VGND VGND VPWR VPWR sky130_fd_sc_hd__decap_3
XANTENNA_6 _9221_/Q VGND VGND VPWR VPWR sky130_fd_sc_hd__diode_2
XTAP_TAPCELL_ROW_117_1855 VGND VPWR sky130_fd_sc_hd__tapvpwrvgnd_1
XTAP_TAPCELL_ROW_117_1866 VGND VPWR sky130_fd_sc_hd__tapvpwrvgnd_1
XFILLER_6_68 VGND VGND VPWR VPWR sky130_fd_sc_hd__fill_1
XFILLER_6_79 VGND VGND VPWR VPWR sky130_fd_sc_hd__decap_3
XFILLER_4_740 VGND VGND VPWR VPWR sky130_fd_sc_hd__decap_3
XFILLER_98_338 VGND VGND VPWR VPWR sky130_fd_sc_hd__decap_3
XFILLER_113_649 VGND VGND VPWR VPWR sky130_fd_sc_hd__decap_3
XFILLER_106_690 VGND VGND VPWR VPWR sky130_fd_sc_hd__decap_3
XFILLER_79_541 VGND VGND VPWR VPWR sky130_fd_sc_hd__decap_3
XFILLER_39_405 VGND VGND VPWR VPWR sky130_fd_sc_hd__decap_3
XFILLER_79_585 VGND VGND VPWR VPWR sky130_fd_sc_hd__decap_3
XFILLER_94_533 VGND VGND VPWR VPWR sky130_fd_sc_hd__decap_3
XFILLER_86_70 VGND VGND VPWR VPWR sky130_fd_sc_hd__decap_3
XFILLER_39_438 VGND VGND VPWR VPWR sky130_fd_sc_hd__fill_2
XFILLER_120_192 VGND VGND VPWR VPWR sky130_fd_sc_hd__decap_3
XFILLER_47_471 VGND VGND VPWR VPWR sky130_fd_sc_hd__decap_3
XFILLER_35_611 VGND VGND VPWR VPWR sky130_fd_sc_hd__decap_3
XFILLER_19_162 VGND VGND VPWR VPWR sky130_fd_sc_hd__decap_3
XFILLER_35_633 VGND VGND VPWR VPWR sky130_fd_sc_hd__decap_3
X_6860_ _7885_/B _7702_/A VGND VGND VPWR VPWR _6861_/B sky130_fd_sc_hd__nor2_2
XFILLER_62_430 VGND VGND VPWR VPWR sky130_fd_sc_hd__decap_3
X_5811_ _5811_/A _5811_/B VGND VGND VPWR VPWR _5811_/Y sky130_fd_sc_hd__nor2_2
XFILLER_62_463 VGND VGND VPWR VPWR sky130_fd_sc_hd__decap_3
X_6791_ _6798_/S _6485_/A _6790_/Y VGND VGND VPWR VPWR _6791_/X sky130_fd_sc_hd__o21ba_2
XFILLER_34_187 VGND VGND VPWR VPWR sky130_fd_sc_hd__decap_3
X_8530_ _8137_/A _8496_/S _8341_/Y VGND VGND VPWR VPWR _8530_/X sky130_fd_sc_hd__o21a_2
X_5742_ _5742_/A _5742_/B _5742_/C _5742_/D VGND VGND VPWR VPWR _5742_/Y sky130_fd_sc_hd__nor4_4
XFILLER_50_658 VGND VGND VPWR VPWR sky130_fd_sc_hd__decap_3
XFILLER_15_390 VGND VGND VPWR VPWR sky130_fd_sc_hd__fill_2
X_8461_ _8461_/A1 _8521_/S _8291_/S _8774_/C1 VGND VGND VPWR VPWR _8461_/X sky130_fd_sc_hd__o211a_4
X_5673_ _5673_/A _5673_/B VGND VGND VPWR VPWR _5681_/A sky130_fd_sc_hd__xnor2_2
XFILLER_30_371 VGND VGND VPWR VPWR sky130_fd_sc_hd__decap_3
X_7412_ _7412_/A1 _7404_/B _7099_/C VGND VGND VPWR VPWR _7412_/X sky130_fd_sc_hd__a21o_2
X_4624_ _4624_/A VGND VGND VPWR VPWR _9062_/D sky130_fd_sc_hd__buf_1
XPHY_EDGE_ROW_6_Right_6 VGND VGND VPWR VPWR sky130_fd_sc_hd__decap_3
X_8392_ _8392_/A VGND VGND VPWR VPWR _9222_/D sky130_fd_sc_hd__buf_1
XFILLER_129_771 VGND VGND VPWR VPWR sky130_fd_sc_hd__decap_3
XTAP_TAPCELL_ROW_79_1349 VGND VPWR sky130_fd_sc_hd__tapvpwrvgnd_1
XFILLER_116_410 VGND VGND VPWR VPWR sky130_fd_sc_hd__fill_1
X_7343_ _7090_/A _7344_/C _7344_/B VGND VGND VPWR VPWR _7346_/C sky130_fd_sc_hd__a21o_2
X_4555_ _4555_/A VGND VGND VPWR VPWR _9029_/D sky130_fd_sc_hd__buf_1
XTAP_TAPCELL_ROW_92_1527 VGND VPWR sky130_fd_sc_hd__tapvpwrvgnd_1
X_7274_ _7272_/B _7274_/B VGND VGND VPWR VPWR _7274_/X sky130_fd_sc_hd__and2b_2
X_9013_ _9347_/Q hold995/X _9015_/S VGND VGND VPWR VPWR _9013_/X sky130_fd_sc_hd__mux2_2
X_6225_ _9298_/Q _6753_/B _6336_/C VGND VGND VPWR VPWR _6225_/X sky130_fd_sc_hd__and3_2
X_6156_ _6052_/A _6152_/Y _6155_/X VGND VGND VPWR VPWR _6519_/B sky130_fd_sc_hd__a21oi_2
XFILLER_58_714 VGND VGND VPWR VPWR sky130_fd_sc_hd__decap_3
XFILLER_85_511 VGND VGND VPWR VPWR sky130_fd_sc_hd__decap_3
Xhold1201 _9257_/Q VGND VGND VPWR VPWR _8858_/A1 sky130_fd_sc_hd__dlygate4sd3_1
XFILLER_57_213 VGND VGND VPWR VPWR sky130_fd_sc_hd__decap_3
Xhold1212 _4798_/X VGND VGND VPWR VPWR _4799_/A sky130_fd_sc_hd__dlygate4sd3_1
X_5107_ _6177_/A VGND VGND VPWR VPWR _5345_/A sky130_fd_sc_hd__clkbuf_1
Xhold1223 _7728_/A VGND VGND VPWR VPWR _8806_/A1 sky130_fd_sc_hd__dlygate4sd3_1
X_6087_ _6094_/B _6096_/B _6095_/A VGND VGND VPWR VPWR _6087_/Y sky130_fd_sc_hd__a21oi_2
XFILLER_111_192 VGND VGND VPWR VPWR sky130_fd_sc_hd__decap_3
Xhold1245 _9229_/Q VGND VGND VPWR VPWR _8665_/A sky130_fd_sc_hd__dlygate4sd3_1
Xhold1256 _9215_/Q VGND VGND VPWR VPWR _7560_/A0 sky130_fd_sc_hd__dlygate4sd3_1
XFILLER_73_717 VGND VGND VPWR VPWR sky130_fd_sc_hd__decap_3
X_5038_ _6206_/A _8777_/B _7472_/A VGND VGND VPWR VPWR _8174_/B sky130_fd_sc_hd__o21a_2
XFILLER_122_24 VGND VGND VPWR VPWR sky130_fd_sc_hd__decap_3
XFILLER_122_35 VGND VGND VPWR VPWR sky130_fd_sc_hd__decap_3
XFILLER_38_471 VGND VGND VPWR VPWR sky130_fd_sc_hd__decap_3
XFILLER_38_493 VGND VGND VPWR VPWR sky130_fd_sc_hd__fill_1
XFILLER_25_110 VGND VGND VPWR VPWR sky130_fd_sc_hd__fill_2
XFILLER_122_68 VGND VGND VPWR VPWR sky130_fd_sc_hd__decap_3
XFILLER_26_666 VGND VGND VPWR VPWR sky130_fd_sc_hd__decap_3
XTAP_TAPCELL_ROW_0_264 VGND VPWR sky130_fd_sc_hd__tapvpwrvgnd_1
XFILLER_53_452 VGND VGND VPWR VPWR sky130_fd_sc_hd__fill_2
XTAP_TAPCELL_ROW_0_275 VGND VPWR sky130_fd_sc_hd__tapvpwrvgnd_1
XTAP_TAPCELL_ROW_0_286 VGND VPWR sky130_fd_sc_hd__tapvpwrvgnd_1
XFILLER_53_485 VGND VGND VPWR VPWR sky130_fd_sc_hd__decap_3
X_6989_ _6989_/A _6989_/B VGND VGND VPWR VPWR _6990_/A sky130_fd_sc_hd__xnor2_2
XFILLER_15_33 VGND VGND VPWR VPWR sky130_fd_sc_hd__fill_2
X_8728_ _8697_/C _8753_/A _8728_/S VGND VGND VPWR VPWR _8728_/X sky130_fd_sc_hd__mux2_2
XFILLER_40_135 VGND VGND VPWR VPWR sky130_fd_sc_hd__decap_3
XFILLER_15_66 VGND VGND VPWR VPWR sky130_fd_sc_hd__decap_3
XTAP_TAPCELL_ROW_101_1645 VGND VPWR sky130_fd_sc_hd__tapvpwrvgnd_1
X_8659_ _9227_/Q _8695_/B _8655_/B _8690_/A VGND VGND VPWR VPWR _8659_/X sky130_fd_sc_hd__o211a_2
XFILLER_21_382 VGND VGND VPWR VPWR sky130_fd_sc_hd__decap_3
XFILLER_21_393 VGND VGND VPWR VPWR sky130_fd_sc_hd__decap_3
XFILLER_31_32 VGND VGND VPWR VPWR sky130_fd_sc_hd__decap_3
Xrebuffer653 _5794_/Y VGND VGND VPWR VPWR _5795_/B sky130_fd_sc_hd__buf_2
XFILLER_126_218 VGND VGND VPWR VPWR sky130_fd_sc_hd__decap_3
XFILLER_107_410 VGND VGND VPWR VPWR sky130_fd_sc_hd__decap_3
XFILLER_110_3 VGND VGND VPWR VPWR sky130_fd_sc_hd__decap_3
Xrebuffer675 _8211_/X VGND VGND VPWR VPWR _8640_/C1 sky130_fd_sc_hd__buf_2
XFILLER_31_87 VGND VGND VPWR VPWR sky130_fd_sc_hd__decap_3
XFILLER_31_98 VGND VGND VPWR VPWR sky130_fd_sc_hd__decap_3
XFILLER_107_465 VGND VGND VPWR VPWR sky130_fd_sc_hd__fill_1
Xoutput21 _9190_/Q VGND VGND VPWR VPWR wire233/A sky130_fd_sc_hd__buf_1
Xoutput32 _9186_/Q VGND VGND VPWR VPWR wire222/A sky130_fd_sc_hd__buf_1
XFILLER_1_721 VGND VGND VPWR VPWR sky130_fd_sc_hd__decap_3
XFILLER_122_435 VGND VGND VPWR VPWR sky130_fd_sc_hd__decap_3
XFILLER_1_732 VGND VGND VPWR VPWR sky130_fd_sc_hd__decap_3
XFILLER_0_231 VGND VGND VPWR VPWR sky130_fd_sc_hd__decap_3
XFILLER_1_765 VGND VGND VPWR VPWR sky130_fd_sc_hd__decap_3
XFILLER_110_619 VGND VGND VPWR VPWR sky130_fd_sc_hd__decap_3
XFILLER_0_253 VGND VGND VPWR VPWR sky130_fd_sc_hd__decap_3
XTAP_TAPCELL_ROW_8_386 VGND VPWR sky130_fd_sc_hd__tapvpwrvgnd_1
XTAP_TAPCELL_ROW_112_1796 VGND VPWR sky130_fd_sc_hd__tapvpwrvgnd_1
XFILLER_76_511 VGND VGND VPWR VPWR sky130_fd_sc_hd__decap_3
XFILLER_76_533 VGND VGND VPWR VPWR sky130_fd_sc_hd__decap_3
XFILLER_48_224 VGND VGND VPWR VPWR sky130_fd_sc_hd__decap_3
XFILLER_102_181 VGND VGND VPWR VPWR sky130_fd_sc_hd__decap_3
XTAP_TAPCELL_ROW_47_915 VGND VPWR sky130_fd_sc_hd__tapvpwrvgnd_1
XFILLER_64_728 VGND VGND VPWR VPWR sky130_fd_sc_hd__decap_3
XFILLER_91_525 VGND VGND VPWR VPWR sky130_fd_sc_hd__decap_3
XFILLER_17_611 VGND VGND VPWR VPWR sky130_fd_sc_hd__decap_3
XFILLER_29_482 VGND VGND VPWR VPWR sky130_fd_sc_hd__decap_3
XFILLER_91_547 VGND VGND VPWR VPWR sky130_fd_sc_hd__decap_3
XFILLER_16_110 VGND VGND VPWR VPWR sky130_fd_sc_hd__decap_3
XFILLER_17_666 VGND VGND VPWR VPWR sky130_fd_sc_hd__decap_3
XTAP_TAPCELL_ROW_27_650 VGND VPWR sky130_fd_sc_hd__tapvpwrvgnd_1
XFILLER_16_165 VGND VGND VPWR VPWR sky130_fd_sc_hd__decap_3
XTAP_TAPCELL_ROW_63_1128 VGND VPWR sky130_fd_sc_hd__tapvpwrvgnd_1
XFILLER_44_485 VGND VGND VPWR VPWR sky130_fd_sc_hd__decap_3
XFILLER_32_636 VGND VGND VPWR VPWR sky130_fd_sc_hd__decap_3
XFILLER_72_50 VGND VGND VPWR VPWR sky130_fd_sc_hd__decap_3
XFILLER_32_658 VGND VGND VPWR VPWR sky130_fd_sc_hd__decap_3
XFILLER_31_179 VGND VGND VPWR VPWR sky130_fd_sc_hd__decap_3
XFILLER_12_360 VGND VGND VPWR VPWR sky130_fd_sc_hd__decap_3
XPHY_EDGE_ROW_59_Right_59 VGND VGND VPWR VPWR sky130_fd_sc_hd__decap_3
XFILLER_75_6 VGND VGND VPWR VPWR sky130_fd_sc_hd__fill_1
XFILLER_118_719 VGND VGND VPWR VPWR sky130_fd_sc_hd__decap_3
XFILLER_8_353 VGND VGND VPWR VPWR sky130_fd_sc_hd__decap_3
XFILLER_8_386 VGND VGND VPWR VPWR sky130_fd_sc_hd__decap_3
XFILLER_126_752 VGND VGND VPWR VPWR sky130_fd_sc_hd__decap_3
XFILLER_99_603 VGND VGND VPWR VPWR sky130_fd_sc_hd__decap_3
XFILLER_126_763 VGND VGND VPWR VPWR sky130_fd_sc_hd__decap_3
XFILLER_125_240 VGND VGND VPWR VPWR sky130_fd_sc_hd__decap_3
XFILLER_113_402 VGND VGND VPWR VPWR sky130_fd_sc_hd__decap_3
XFILLER_99_636 VGND VGND VPWR VPWR sky130_fd_sc_hd__decap_3
XFILLER_125_273 VGND VGND VPWR VPWR sky130_fd_sc_hd__decap_3
XFILLER_98_124 VGND VGND VPWR VPWR sky130_fd_sc_hd__decap_3
XFILLER_125_284 VGND VGND VPWR VPWR sky130_fd_sc_hd__fill_1
XFILLER_99_669 VGND VGND VPWR VPWR sky130_fd_sc_hd__decap_3
XFILLER_113_446 VGND VGND VPWR VPWR sky130_fd_sc_hd__fill_2
XTAP_TAPCELL_ROW_74_1279 VGND VPWR sky130_fd_sc_hd__tapvpwrvgnd_1
XFILLER_98_157 VGND VGND VPWR VPWR sky130_fd_sc_hd__fill_1
X_6010_ _6010_/A _6972_/A VGND VGND VPWR VPWR _6174_/A sky130_fd_sc_hd__nand2_2
XFILLER_98_179 VGND VGND VPWR VPWR sky130_fd_sc_hd__decap_3
XPHY_EDGE_ROW_68_Right_68 VGND VGND VPWR VPWR sky130_fd_sc_hd__decap_3
XFILLER_79_371 VGND VGND VPWR VPWR sky130_fd_sc_hd__decap_3
XFILLER_67_522 VGND VGND VPWR VPWR sky130_fd_sc_hd__fill_1
XFILLER_79_393 VGND VGND VPWR VPWR sky130_fd_sc_hd__decap_3
XFILLER_121_490 VGND VGND VPWR VPWR sky130_fd_sc_hd__decap_3
XFILLER_55_706 VGND VGND VPWR VPWR sky130_fd_sc_hd__decap_3
XFILLER_39_268 VGND VGND VPWR VPWR sky130_fd_sc_hd__decap_3
X_7961_ _7781_/B _7959_/X _7960_/X VGND VGND VPWR VPWR _7962_/B sky130_fd_sc_hd__a21oi_2
XFILLER_94_374 VGND VGND VPWR VPWR sky130_fd_sc_hd__decap_3
XPHY_EDGE_ROW_6_Left_137 VGND VGND VPWR VPWR sky130_fd_sc_hd__decap_3
XFILLER_82_536 VGND VGND VPWR VPWR sky130_fd_sc_hd__decap_3
X_6912_ _6912_/A _6912_/B _6912_/C VGND VGND VPWR VPWR _6912_/X sky130_fd_sc_hd__and3_2
XFILLER_82_558 VGND VGND VPWR VPWR sky130_fd_sc_hd__decap_3
X_7892_ _8006_/B _7892_/B VGND VGND VPWR VPWR _7894_/A sky130_fd_sc_hd__xnor2_2
XFILLER_35_441 VGND VGND VPWR VPWR sky130_fd_sc_hd__decap_3
XFILLER_23_603 VGND VGND VPWR VPWR sky130_fd_sc_hd__decap_3
XFILLER_63_772 VGND VGND VPWR VPWR sky130_fd_sc_hd__decap_3
X_6843_ _6843_/A _6845_/A VGND VGND VPWR VPWR _6843_/X sky130_fd_sc_hd__or2b_2
XFILLER_35_474 VGND VGND VPWR VPWR sky130_fd_sc_hd__decap_3
XFILLER_35_496 VGND VGND VPWR VPWR sky130_fd_sc_hd__decap_3
XFILLER_22_124 VGND VGND VPWR VPWR sky130_fd_sc_hd__fill_1
X_6774_ _6774_/A _6774_/B _6774_/C _6774_/D VGND VGND VPWR VPWR _6920_/B sky130_fd_sc_hd__nand4_2
XFILLER_50_455 VGND VGND VPWR VPWR sky130_fd_sc_hd__decap_3
XPHY_EDGE_ROW_77_Right_77 VGND VGND VPWR VPWR sky130_fd_sc_hd__decap_3
X_8513_ _8418_/B _8421_/B _8482_/A VGND VGND VPWR VPWR _8513_/Y sky130_fd_sc_hd__o21ai_2
XFILLER_50_477 VGND VGND VPWR VPWR sky130_fd_sc_hd__decap_3
X_5725_ _5725_/A _5725_/B VGND VGND VPWR VPWR _5726_/B sky130_fd_sc_hd__or2_4
XFILLER_109_708 VGND VGND VPWR VPWR sky130_fd_sc_hd__decap_3
X_8444_ _8446_/A _6749_/X _8438_/Y _9221_/Q VGND VGND VPWR VPWR _8445_/C sky130_fd_sc_hd__a211o_2
X_5656_ _5656_/A _5656_/B VGND VGND VPWR VPWR _5656_/Y sky130_fd_sc_hd__nor2_2
X_4607_ _4607_/A VGND VGND VPWR VPWR _9054_/D sky130_fd_sc_hd__buf_1
X_8375_ _8218_/B _8184_/X _8185_/A VGND VGND VPWR VPWR _8375_/X sky130_fd_sc_hd__a21o_2
XFILLER_117_741 VGND VGND VPWR VPWR sky130_fd_sc_hd__decap_3
X_5587_ _6711_/C VGND VGND VPWR VPWR _8309_/A sky130_fd_sc_hd__clkbuf_2
X_7326_ _7326_/A _7326_/B VGND VGND VPWR VPWR _7332_/A sky130_fd_sc_hd__or2_2
X_4538_ hold837/X _4538_/A1 _4544_/S VGND VGND VPWR VPWR _4539_/A sky130_fd_sc_hd__mux2_2
XFILLER_117_24 VGND VGND VPWR VPWR sky130_fd_sc_hd__decap_3
XFILLER_7_9 VGND VGND VPWR VPWR sky130_fd_sc_hd__decap_3
XFILLER_117_57 VGND VGND VPWR VPWR sky130_fd_sc_hd__decap_3
X_7257_ _7257_/A _7513_/B VGND VGND VPWR VPWR _7258_/B sky130_fd_sc_hd__xor2_2
XFILLER_104_457 VGND VGND VPWR VPWR sky130_fd_sc_hd__decap_3
XPHY_EDGE_ROW_86_Right_86 VGND VGND VPWR VPWR sky130_fd_sc_hd__decap_3
XFILLER_89_157 VGND VGND VPWR VPWR sky130_fd_sc_hd__decap_3
XFILLER_77_308 VGND VGND VPWR VPWR sky130_fd_sc_hd__decap_3
X_6208_ _6953_/A _6305_/B VGND VGND VPWR VPWR _6209_/A sky130_fd_sc_hd__or2_2
XFILLER_77_319 VGND VGND VPWR VPWR sky130_fd_sc_hd__decap_3
X_7188_ _7716_/A _7670_/A _7187_/X VGND VGND VPWR VPWR _7243_/B sky130_fd_sc_hd__a21o_2
XTAP_TAPCELL_ROW_5_345 VGND VPWR sky130_fd_sc_hd__tapvpwrvgnd_1
X_6139_ _5962_/A _5962_/B _6138_/X VGND VGND VPWR VPWR _6140_/B sky130_fd_sc_hd__a21o_2
Xhold1020 _4710_/X VGND VGND VPWR VPWR _4711_/A sky130_fd_sc_hd__dlygate4sd3_1
Xhold1031 _9096_/Q VGND VGND VPWR VPWR _4729_/A1 sky130_fd_sc_hd__dlygate4sd3_1
Xhold1042 _8911_/X VGND VGND VPWR VPWR _8912_/A sky130_fd_sc_hd__dlygate4sd3_1
XFILLER_46_717 VGND VGND VPWR VPWR sky130_fd_sc_hd__decap_3
Xhold1053 _9260_/Q VGND VGND VPWR VPWR _8865_/A1 sky130_fd_sc_hd__dlygate4sd3_1
XFILLER_93_16 VGND VGND VPWR VPWR sky130_fd_sc_hd__fill_2
XFILLER_73_503 VGND VGND VPWR VPWR sky130_fd_sc_hd__fill_1
Xhold1064 _4598_/X VGND VGND VPWR VPWR _4599_/A sky130_fd_sc_hd__dlygate4sd3_1
XFILLER_46_739 VGND VGND VPWR VPWR sky130_fd_sc_hd__fill_1
XFILLER_100_696 VGND VGND VPWR VPWR sky130_fd_sc_hd__decap_3
Xhold1075 _9304_/Q VGND VGND VPWR VPWR _8957_/A1 sky130_fd_sc_hd__dlygate4sd3_1
XFILLER_85_396 VGND VGND VPWR VPWR sky130_fd_sc_hd__decap_3
XFILLER_73_536 VGND VGND VPWR VPWR sky130_fd_sc_hd__fill_2
Xhold1086 _9057_/Q VGND VGND VPWR VPWR _4646_/A1 sky130_fd_sc_hd__dlygate4sd3_1
Xhold1097 _8995_/X VGND VGND VPWR VPWR _8996_/A sky130_fd_sc_hd__dlygate4sd3_1
XFILLER_26_430 VGND VGND VPWR VPWR sky130_fd_sc_hd__decap_3
XFILLER_61_709 VGND VGND VPWR VPWR sky130_fd_sc_hd__decap_3
XFILLER_38_290 VGND VGND VPWR VPWR sky130_fd_sc_hd__decap_3
XFILLER_26_43 VGND VGND VPWR VPWR sky130_fd_sc_hd__decap_3
XFILLER_54_761 VGND VGND VPWR VPWR sky130_fd_sc_hd__decap_3
XFILLER_60_208 VGND VGND VPWR VPWR sky130_fd_sc_hd__fill_2
XFILLER_26_474 VGND VGND VPWR VPWR sky130_fd_sc_hd__fill_2
XFILLER_14_625 VGND VGND VPWR VPWR sky130_fd_sc_hd__fill_1
XFILLER_81_580 VGND VGND VPWR VPWR sky130_fd_sc_hd__fill_2
XPHY_EDGE_ROW_95_Right_95 VGND VGND VPWR VPWR sky130_fd_sc_hd__decap_3
XFILLER_81_591 VGND VGND VPWR VPWR sky130_fd_sc_hd__fill_2
XTAP_TAPCELL_ROW_52_984 VGND VPWR sky130_fd_sc_hd__tapvpwrvgnd_1
XFILLER_127_527 VGND VGND VPWR VPWR sky130_fd_sc_hd__decap_3
XFILLER_127_538 VGND VGND VPWR VPWR sky130_fd_sc_hd__decap_3
Xrebuffer450 _5473_/Y VGND VGND VPWR VPWR _5475_/A1 sky130_fd_sc_hd__buf_2
Xrebuffer461 _6598_/B VGND VGND VPWR VPWR _6673_/A sky130_fd_sc_hd__buf_2
Xrebuffer472 _6564_/B VGND VGND VPWR VPWR _6668_/A sky130_fd_sc_hd__buf_2
Xrebuffer483 _4515_/A VGND VGND VPWR VPWR _5623_/B1 sky130_fd_sc_hd__buf_2
XTAP_TAPCELL_ROW_114_1814 VGND VPWR sky130_fd_sc_hd__tapvpwrvgnd_1
Xrebuffer494 _6990_/Y VGND VGND VPWR VPWR _7000_/A sky130_fd_sc_hd__buf_2
XFILLER_107_251 VGND VGND VPWR VPWR sky130_fd_sc_hd__fill_1
XTAP_TAPCELL_ROW_114_1825 VGND VPWR sky130_fd_sc_hd__tapvpwrvgnd_1
XFILLER_5_367 VGND VGND VPWR VPWR sky130_fd_sc_hd__fill_2
XFILLER_123_744 VGND VGND VPWR VPWR sky130_fd_sc_hd__decap_3
XFILLER_122_221 VGND VGND VPWR VPWR sky130_fd_sc_hd__decap_3
XFILLER_96_606 VGND VGND VPWR VPWR sky130_fd_sc_hd__decap_3
XFILLER_122_243 VGND VGND VPWR VPWR sky130_fd_sc_hd__decap_3
XFILLER_3_36 VGND VGND VPWR VPWR sky130_fd_sc_hd__decap_3
XFILLER_1_551 VGND VGND VPWR VPWR sky130_fd_sc_hd__decap_3
XFILLER_96_628 VGND VGND VPWR VPWR sky130_fd_sc_hd__decap_3
XFILLER_95_116 VGND VGND VPWR VPWR sky130_fd_sc_hd__decap_3
XFILLER_49_511 VGND VGND VPWR VPWR sky130_fd_sc_hd__decap_3
XFILLER_110_416 VGND VGND VPWR VPWR sky130_fd_sc_hd__decap_3
XFILLER_110_427 VGND VGND VPWR VPWR sky130_fd_sc_hd__decap_3
XFILLER_89_691 VGND VGND VPWR VPWR sky130_fd_sc_hd__decap_3
XFILLER_3_69 VGND VGND VPWR VPWR sky130_fd_sc_hd__decap_3
XFILLER_122_298 VGND VGND VPWR VPWR sky130_fd_sc_hd__decap_3
XFILLER_67_50 VGND VGND VPWR VPWR sky130_fd_sc_hd__decap_3
XFILLER_95_149 VGND VGND VPWR VPWR sky130_fd_sc_hd__decap_3
XFILLER_76_330 VGND VGND VPWR VPWR sky130_fd_sc_hd__decap_3
XFILLER_37_706 VGND VGND VPWR VPWR sky130_fd_sc_hd__decap_3
XFILLER_67_83 VGND VGND VPWR VPWR sky130_fd_sc_hd__decap_3
XFILLER_49_599 VGND VGND VPWR VPWR sky130_fd_sc_hd__decap_3
XFILLER_36_216 VGND VGND VPWR VPWR sky130_fd_sc_hd__decap_3
XFILLER_64_536 VGND VGND VPWR VPWR sky130_fd_sc_hd__decap_3
XFILLER_17_430 VGND VGND VPWR VPWR sky130_fd_sc_hd__decap_3
XFILLER_17_452 VGND VGND VPWR VPWR sky130_fd_sc_hd__decap_3
XTAP_TAPCELL_ROW_125_1965 VGND VPWR sky130_fd_sc_hd__tapvpwrvgnd_1
XFILLER_83_60 VGND VGND VPWR VPWR sky130_fd_sc_hd__fill_1
XFILLER_45_772 VGND VGND VPWR VPWR sky130_fd_sc_hd__decap_3
XFILLER_91_388 VGND VGND VPWR VPWR sky130_fd_sc_hd__decap_3
XFILLER_17_474 VGND VGND VPWR VPWR sky130_fd_sc_hd__decap_3
XFILLER_91_399 VGND VGND VPWR VPWR sky130_fd_sc_hd__decap_3
XFILLER_60_742 VGND VGND VPWR VPWR sky130_fd_sc_hd__decap_3
XFILLER_32_477 VGND VGND VPWR VPWR sky130_fd_sc_hd__decap_3
XFILLER_13_691 VGND VGND VPWR VPWR sky130_fd_sc_hd__decap_3
X_5510_ _5538_/A _5510_/B VGND VGND VPWR VPWR _5524_/B sky130_fd_sc_hd__or2_2
X_6490_ _6490_/A _6490_/B VGND VGND VPWR VPWR _6491_/B sky130_fd_sc_hd__xnor2_2
XFILLER_9_673 VGND VGND VPWR VPWR sky130_fd_sc_hd__fill_2
XFILLER_73_3 VGND VGND VPWR VPWR sky130_fd_sc_hd__fill_1
XFILLER_118_516 VGND VGND VPWR VPWR sky130_fd_sc_hd__decap_3
XFILLER_8_150 VGND VGND VPWR VPWR sky130_fd_sc_hd__decap_3
XTAP_TAPCELL_ROW_30_689 VGND VPWR sky130_fd_sc_hd__tapvpwrvgnd_1
X_5441_ _5366_/A _5438_/X _5440_/X _5364_/X VGND VGND VPWR VPWR _5450_/A sky130_fd_sc_hd__o211a_2
XTAP_TAPCELL_ROW_76_1308 VGND VPWR sky130_fd_sc_hd__tapvpwrvgnd_1
X_8160_ _8313_/A wire88/X VGND VGND VPWR VPWR _8162_/A sky130_fd_sc_hd__nand2_2
X_5372_ _9072_/Q _5469_/B _5879_/B VGND VGND VPWR VPWR _5372_/X sky130_fd_sc_hd__and3_2
X_7111_ _7009_/A _7110_/X _7006_/X _7007_/X VGND VGND VPWR VPWR _7377_/A sky130_fd_sc_hd__a2bb2o_2
XFILLER_99_444 VGND VGND VPWR VPWR sky130_fd_sc_hd__decap_3
XFILLER_114_744 VGND VGND VPWR VPWR sky130_fd_sc_hd__decap_3
X_8091_ _8131_/A _8091_/B VGND VGND VPWR VPWR _8094_/A sky130_fd_sc_hd__xnor2_2
XFILLER_99_455 VGND VGND VPWR VPWR sky130_fd_sc_hd__decap_3
XFILLER_113_243 VGND VGND VPWR VPWR sky130_fd_sc_hd__decap_3
XFILLER_87_617 VGND VGND VPWR VPWR sky130_fd_sc_hd__decap_3
X_7042_ _7035_/Y _7037_/X _7039_/X _7041_/X VGND VGND VPWR VPWR wire55/A sky130_fd_sc_hd__a211oi_2
XFILLER_59_319 VGND VGND VPWR VPWR sky130_fd_sc_hd__decap_3
XFILLER_101_427 VGND VGND VPWR VPWR sky130_fd_sc_hd__fill_1
XFILLER_101_449 VGND VGND VPWR VPWR sky130_fd_sc_hd__fill_1
XFILLER_79_190 VGND VGND VPWR VPWR sky130_fd_sc_hd__decap_3
XTAP_TAPCELL_ROW_2_304 VGND VPWR sky130_fd_sc_hd__tapvpwrvgnd_1
XTAP_TAPCELL_ROW_2_315 VGND VPWR sky130_fd_sc_hd__tapvpwrvgnd_1
XFILLER_28_717 VGND VGND VPWR VPWR sky130_fd_sc_hd__decap_3
XFILLER_82_300 VGND VGND VPWR VPWR sky130_fd_sc_hd__decap_3
XFILLER_103_15 VGND VGND VPWR VPWR sky130_fd_sc_hd__fill_1
X_8993_ hold966/X _8993_/A1 _9009_/S VGND VGND VPWR VPWR _8994_/A sky130_fd_sc_hd__mux2_2
XTAP_TAPCELL_ROW_87_1459 VGND VPWR sky130_fd_sc_hd__tapvpwrvgnd_1
XFILLER_55_558 VGND VGND VPWR VPWR sky130_fd_sc_hd__fill_2
XFILLER_103_48 VGND VGND VPWR VPWR sky130_fd_sc_hd__decap_3
X_7944_ _7763_/B _7773_/A _7413_/A VGND VGND VPWR VPWR _7946_/B sky130_fd_sc_hd__a21o_2
XFILLER_36_750 VGND VGND VPWR VPWR sky130_fd_sc_hd__decap_3
XTAP_TAPCELL_ROW_38_789 VGND VPWR sky130_fd_sc_hd__tapvpwrvgnd_1
XFILLER_70_528 VGND VGND VPWR VPWR sky130_fd_sc_hd__decap_3
XFILLER_42_219 VGND VGND VPWR VPWR sky130_fd_sc_hd__decap_3
XFILLER_82_388 VGND VGND VPWR VPWR sky130_fd_sc_hd__decap_3
X_7875_ _7722_/A _7721_/B _7874_/X VGND VGND VPWR VPWR _7889_/A sky130_fd_sc_hd__a21oi_2
XFILLER_51_720 VGND VGND VPWR VPWR sky130_fd_sc_hd__decap_3
XFILLER_63_591 VGND VGND VPWR VPWR sky130_fd_sc_hd__decap_3
XFILLER_51_742 VGND VGND VPWR VPWR sky130_fd_sc_hd__decap_3
XFILLER_35_293 VGND VGND VPWR VPWR sky130_fd_sc_hd__decap_3
X_6826_ _6826_/A1 _6825_/B _6871_/B VGND VGND VPWR VPWR _6880_/A sky130_fd_sc_hd__a21oi_2
XFILLER_23_444 VGND VGND VPWR VPWR sky130_fd_sc_hd__decap_3
XFILLER_50_274 VGND VGND VPWR VPWR sky130_fd_sc_hd__decap_3
X_6757_ _9049_/Q _6757_/B _6757_/C VGND VGND VPWR VPWR _6757_/X sky130_fd_sc_hd__and3_2
XFILLER_11_639 VGND VGND VPWR VPWR sky130_fd_sc_hd__decap_3
XFILLER_109_505 VGND VGND VPWR VPWR sky130_fd_sc_hd__fill_1
X_5708_ _5444_/Y _7794_/B _5737_/B VGND VGND VPWR VPWR _5709_/B sky130_fd_sc_hd__o21a_2
XFILLER_12_12 VGND VGND VPWR VPWR sky130_fd_sc_hd__decap_3
XFILLER_109_516 VGND VGND VPWR VPWR sky130_fd_sc_hd__decap_3
XFILLER_6_109 VGND VGND VPWR VPWR sky130_fd_sc_hd__decap_3
X_6688_ _6688_/A _6939_/C VGND VGND VPWR VPWR _6689_/B sky130_fd_sc_hd__xnor2_2
XFILLER_128_12 VGND VGND VPWR VPWR sky130_fd_sc_hd__decap_3
X_8427_ _8780_/A _8427_/B _8427_/C VGND VGND VPWR VPWR _8427_/Y sky130_fd_sc_hd__nand3_2
X_5639_ _5489_/A _5489_/B _5490_/A VGND VGND VPWR VPWR _5639_/X sky130_fd_sc_hd__a21bo_2
XTAP_TAPCELL_ROW_98_1599 VGND VPWR sky130_fd_sc_hd__tapvpwrvgnd_1
XFILLER_128_56 VGND VGND VPWR VPWR sky130_fd_sc_hd__decap_3
XFILLER_105_700 VGND VGND VPWR VPWR sky130_fd_sc_hd__decap_3
X_8358_ _7908_/X _8367_/B _8441_/B VGND VGND VPWR VPWR _8358_/X sky130_fd_sc_hd__mux2_2
X_7309_ _7468_/A _7468_/B VGND VGND VPWR VPWR _7353_/A sky130_fd_sc_hd__nor2_2
XFILLER_5_6 VGND VGND VPWR VPWR sky130_fd_sc_hd__decap_3
XFILLER_105_766 VGND VGND VPWR VPWR sky130_fd_sc_hd__fill_2
X_8289_ _9221_/Q VGND VGND VPWR VPWR _8441_/B sky130_fd_sc_hd__inv_2
XFILLER_104_265 VGND VGND VPWR VPWR sky130_fd_sc_hd__decap_3
XFILLER_78_639 VGND VGND VPWR VPWR sky130_fd_sc_hd__decap_3
XFILLER_120_725 VGND VGND VPWR VPWR sky130_fd_sc_hd__decap_3
XTAP_TAPCELL_ROW_129_2021 VGND VPWR sky130_fd_sc_hd__tapvpwrvgnd_1
XFILLER_120_769 VGND VGND VPWR VPWR sky130_fd_sc_hd__decap_3
XFILLER_58_341 VGND VGND VPWR VPWR sky130_fd_sc_hd__decap_3
XFILLER_86_672 VGND VGND VPWR VPWR sky130_fd_sc_hd__decap_3
XFILLER_37_20 VGND VGND VPWR VPWR sky130_fd_sc_hd__decap_3
XFILLER_58_374 VGND VGND VPWR VPWR sky130_fd_sc_hd__decap_3
XFILLER_46_536 VGND VGND VPWR VPWR sky130_fd_sc_hd__decap_3
XFILLER_46_558 VGND VGND VPWR VPWR sky130_fd_sc_hd__decap_3
XFILLER_73_355 VGND VGND VPWR VPWR sky130_fd_sc_hd__decap_3
XFILLER_61_517 VGND VGND VPWR VPWR sky130_fd_sc_hd__decap_3
XFILLER_27_761 VGND VGND VPWR VPWR sky130_fd_sc_hd__decap_3
XFILLER_73_399 VGND VGND VPWR VPWR sky130_fd_sc_hd__decap_3
XFILLER_42_731 VGND VGND VPWR VPWR sky130_fd_sc_hd__fill_2
XFILLER_53_30 VGND VGND VPWR VPWR sky130_fd_sc_hd__decap_3
XFILLER_42_742 VGND VGND VPWR VPWR sky130_fd_sc_hd__decap_3
XFILLER_14_433 VGND VGND VPWR VPWR sky130_fd_sc_hd__decap_3
XFILLER_42_775 VGND VGND VPWR VPWR sky130_fd_sc_hd__fill_2
XFILLER_14_477 VGND VGND VPWR VPWR sky130_fd_sc_hd__decap_3
XPHY_EDGE_ROW_78_Left_209 VGND VGND VPWR VPWR sky130_fd_sc_hd__decap_3
XTAP_TAPCELL_ROW_120_1895 VGND VPWR sky130_fd_sc_hd__tapvpwrvgnd_1
XFILLER_127_346 VGND VGND VPWR VPWR sky130_fd_sc_hd__decap_3
XFILLER_6_643 VGND VGND VPWR VPWR sky130_fd_sc_hd__fill_1
XFILLER_5_131 VGND VGND VPWR VPWR sky130_fd_sc_hd__decap_3
XFILLER_127_379 VGND VGND VPWR VPWR sky130_fd_sc_hd__decap_3
XFILLER_115_519 VGND VGND VPWR VPWR sky130_fd_sc_hd__fill_2
XFILLER_108_571 VGND VGND VPWR VPWR sky130_fd_sc_hd__decap_3
XFILLER_6_687 VGND VGND VPWR VPWR sky130_fd_sc_hd__decap_3
XFILLER_69_606 VGND VGND VPWR VPWR sky130_fd_sc_hd__decap_3
XFILLER_123_552 VGND VGND VPWR VPWR sky130_fd_sc_hd__fill_1
XFILLER_69_617 VGND VGND VPWR VPWR sky130_fd_sc_hd__decap_3
XFILLER_111_703 VGND VGND VPWR VPWR sky130_fd_sc_hd__decap_3
XTAP_TAPCELL_ROW_71_1238 VGND VPWR sky130_fd_sc_hd__tapvpwrvgnd_1
XPHY_EDGE_ROW_87_Left_218 VGND VGND VPWR VPWR sky130_fd_sc_hd__decap_3
XFILLER_38_6 VGND VGND VPWR VPWR sky130_fd_sc_hd__fill_2
XFILLER_68_116 VGND VGND VPWR VPWR sky130_fd_sc_hd__decap_3
XFILLER_1_370 VGND VGND VPWR VPWR sky130_fd_sc_hd__decap_3
XFILLER_96_458 VGND VGND VPWR VPWR sky130_fd_sc_hd__fill_1
XFILLER_83_119 VGND VGND VPWR VPWR sky130_fd_sc_hd__fill_1
XFILLER_49_374 VGND VGND VPWR VPWR sky130_fd_sc_hd__decap_3
XFILLER_37_514 VGND VGND VPWR VPWR sky130_fd_sc_hd__fill_1
XFILLER_37_547 VGND VGND VPWR VPWR sky130_fd_sc_hd__decap_3
X_5990_ _5990_/A _6336_/C _5990_/C VGND VGND VPWR VPWR _5990_/X sky130_fd_sc_hd__and3_2
XFILLER_18_772 VGND VGND VPWR VPWR sky130_fd_sc_hd__decap_3
X_4941_ _5737_/B _6239_/A _9130_/Q VGND VGND VPWR VPWR _4941_/X sky130_fd_sc_hd__and3_2
XFILLER_52_539 VGND VGND VPWR VPWR sky130_fd_sc_hd__decap_3
XTAP_TAPCELL_ROW_35_748 VGND VPWR sky130_fd_sc_hd__tapvpwrvgnd_1
XFILLER_45_591 VGND VGND VPWR VPWR sky130_fd_sc_hd__fill_2
XTAP_TAPCELL_ROW_35_759 VGND VPWR sky130_fd_sc_hd__tapvpwrvgnd_1
X_7660_ _7661_/A _7661_/B _7549_/B _7659_/X VGND VGND VPWR VPWR _7660_/X sky130_fd_sc_hd__a22o_2
XPHY_EDGE_ROW_96_Left_227 VGND VGND VPWR VPWR sky130_fd_sc_hd__decap_3
X_4872_ _9211_/Q _4907_/B VGND VGND VPWR VPWR _4872_/Y sky130_fd_sc_hd__nor2_2
XFILLER_32_241 VGND VGND VPWR VPWR sky130_fd_sc_hd__decap_3
X_6611_ _9064_/Q _5730_/X _5065_/X _9284_/Q VGND VGND VPWR VPWR _6612_/D sky130_fd_sc_hd__a22o_2
XTAP_TAPCELL_ROW_82_1389 VGND VPWR sky130_fd_sc_hd__tapvpwrvgnd_1
XFILLER_20_414 VGND VGND VPWR VPWR sky130_fd_sc_hd__decap_3
X_7591_ _7591_/A wire84/X _8050_/A VGND VGND VPWR VPWR _7591_/X sky130_fd_sc_hd__or3_2
XFILLER_32_285 VGND VGND VPWR VPWR sky130_fd_sc_hd__decap_3
XTAP_TAPCELL_ROW_15_483 VGND VPWR sky130_fd_sc_hd__tapvpwrvgnd_1
XFILLER_20_436 VGND VGND VPWR VPWR sky130_fd_sc_hd__decap_3
X_9330_ _9346_/CLK _9330_/D fanout403/X VGND VGND VPWR VPWR _9330_/Q sky130_fd_sc_hd__dfrtp_2
X_6542_ _6542_/A VGND VGND VPWR VPWR _6542_/Y sky130_fd_sc_hd__inv_2
X_9261_ _9308_/CLK _9261_/D load_slew370/X VGND VGND VPWR VPWR _9261_/Q sky130_fd_sc_hd__dfrtp_2
XFILLER_118_335 VGND VGND VPWR VPWR sky130_fd_sc_hd__decap_3
X_6473_ _7885_/B _6473_/B VGND VGND VPWR VPWR _6474_/B sky130_fd_sc_hd__xnor2_2
XFILLER_118_357 VGND VGND VPWR VPWR sky130_fd_sc_hd__decap_3
XFILLER_118_368 VGND VGND VPWR VPWR sky130_fd_sc_hd__decap_3
X_8212_ _8461_/A1 _8445_/A _8211_/X VGND VGND VPWR VPWR _8212_/Y sky130_fd_sc_hd__o21ai_2
X_5424_ _7313_/A _7313_/B _5201_/A VGND VGND VPWR VPWR _5425_/B sky130_fd_sc_hd__a21oi_2
X_9192_ _9223_/CLK _9192_/D load_slew414/X VGND VGND VPWR VPWR _9192_/Q sky130_fd_sc_hd__dfrtp_2
X_8143_ _8271_/C _8141_/Y _8271_/D VGND VGND VPWR VPWR _8144_/B sky130_fd_sc_hd__a21boi_2
XFILLER_114_530 VGND VGND VPWR VPWR sky130_fd_sc_hd__fill_2
X_5355_ _5855_/A _7805_/A VGND VGND VPWR VPWR _5440_/A sky130_fd_sc_hd__or2_2
XFILLER_58_19 VGND VGND VPWR VPWR sky130_fd_sc_hd__decap_3
XFILLER_114_574 VGND VGND VPWR VPWR sky130_fd_sc_hd__decap_3
XFILLER_102_725 VGND VGND VPWR VPWR sky130_fd_sc_hd__decap_3
X_8074_ _8074_/A _8074_/B VGND VGND VPWR VPWR _8075_/B sky130_fd_sc_hd__xnor2_2
X_5286_ _5284_/Y _5285_/X _6027_/B VGND VGND VPWR VPWR _5294_/B sky130_fd_sc_hd__mux2_2
XFILLER_59_116 VGND VGND VPWR VPWR sky130_fd_sc_hd__decap_3
XFILLER_101_213 VGND VGND VPWR VPWR sky130_fd_sc_hd__decap_3
XFILLER_102_747 VGND VGND VPWR VPWR sky130_fd_sc_hd__decap_3
XFILLER_87_447 VGND VGND VPWR VPWR sky130_fd_sc_hd__fill_1
XFILLER_59_138 VGND VGND VPWR VPWR sky130_fd_sc_hd__fill_2
X_7025_ _7025_/A _7025_/B VGND VGND VPWR VPWR _7025_/Y sky130_fd_sc_hd__xnor2_2
XFILLER_28_503 VGND VGND VPWR VPWR sky130_fd_sc_hd__decap_3
XFILLER_114_47 VGND VGND VPWR VPWR sky130_fd_sc_hd__decap_3
XFILLER_55_300 VGND VGND VPWR VPWR sky130_fd_sc_hd__decap_3
XFILLER_95_491 VGND VGND VPWR VPWR sky130_fd_sc_hd__decap_3
XFILLER_83_631 VGND VGND VPWR VPWR sky130_fd_sc_hd__decap_3
XFILLER_55_322 VGND VGND VPWR VPWR sky130_fd_sc_hd__fill_1
XFILLER_83_664 VGND VGND VPWR VPWR sky130_fd_sc_hd__decap_3
XFILLER_82_141 VGND VGND VPWR VPWR sky130_fd_sc_hd__decap_3
XFILLER_55_355 VGND VGND VPWR VPWR sky130_fd_sc_hd__decap_3
X_8976_ _9329_/Q _8976_/A1 _8988_/S VGND VGND VPWR VPWR _8976_/X sky130_fd_sc_hd__mux2_2
XFILLER_83_686 VGND VGND VPWR VPWR sky130_fd_sc_hd__fill_1
XFILLER_70_303 VGND VGND VPWR VPWR sky130_fd_sc_hd__decap_3
XFILLER_130_24 VGND VGND VPWR VPWR sky130_fd_sc_hd__decap_3
X_7927_ _8104_/C _7927_/B VGND VGND VPWR VPWR _7928_/A sky130_fd_sc_hd__xnor2_2
XFILLER_55_399 VGND VGND VPWR VPWR sky130_fd_sc_hd__fill_1
XFILLER_24_720 VGND VGND VPWR VPWR sky130_fd_sc_hd__decap_3
XFILLER_130_35 VGND VGND VPWR VPWR sky130_fd_sc_hd__decap_3
XFILLER_70_336 VGND VGND VPWR VPWR sky130_fd_sc_hd__fill_1
XFILLER_130_57 VGND VGND VPWR VPWR sky130_fd_sc_hd__decap_3
XFILLER_24_753 VGND VGND VPWR VPWR sky130_fd_sc_hd__decap_3
X_7858_ _7856_/A _7742_/Y _7856_/X _7994_/A1 _7857_/X VGND VGND VPWR VPWR _7858_/X
+ sky130_fd_sc_hd__o221a_4
XFILLER_24_775 VGND VGND VPWR VPWR sky130_fd_sc_hd__fill_2
XFILLER_51_572 VGND VGND VPWR VPWR sky130_fd_sc_hd__decap_3
X_6809_ _6809_/A _6809_/B VGND VGND VPWR VPWR _6809_/Y sky130_fd_sc_hd__nor2_2
XFILLER_23_274 VGND VGND VPWR VPWR sky130_fd_sc_hd__decap_3
XFILLER_11_414 VGND VGND VPWR VPWR sky130_fd_sc_hd__fill_2
X_7789_ _7789_/A _7789_/B VGND VGND VPWR VPWR _7790_/B sky130_fd_sc_hd__xnor2_2
XFILLER_23_44 VGND VGND VPWR VPWR sky130_fd_sc_hd__decap_3
XFILLER_11_447 VGND VGND VPWR VPWR sky130_fd_sc_hd__fill_1
Xwire316 wire316/A VGND VGND VPWR VPWR _7560_/S sky130_fd_sc_hd__clkbuf_4
XFILLER_7_429 VGND VGND VPWR VPWR sky130_fd_sc_hd__fill_1
XFILLER_23_88 VGND VGND VPWR VPWR sky130_fd_sc_hd__fill_2
XFILLER_99_15 VGND VGND VPWR VPWR sky130_fd_sc_hd__decap_3
XFILLER_3_613 VGND VGND VPWR VPWR sky130_fd_sc_hd__decap_3
XFILLER_3_635 VGND VGND VPWR VPWR sky130_fd_sc_hd__decap_3
XFILLER_2_112 VGND VGND VPWR VPWR sky130_fd_sc_hd__decap_3
XFILLER_105_541 VGND VGND VPWR VPWR sky130_fd_sc_hd__decap_3
XFILLER_3_3 VGND VGND VPWR VPWR sky130_fd_sc_hd__decap_3
XFILLER_3_668 VGND VGND VPWR VPWR sky130_fd_sc_hd__decap_3
XFILLER_3_679 VGND VGND VPWR VPWR sky130_fd_sc_hd__decap_3
XFILLER_78_414 VGND VGND VPWR VPWR sky130_fd_sc_hd__decap_3
XFILLER_105_596 VGND VGND VPWR VPWR sky130_fd_sc_hd__decap_3
XFILLER_78_447 VGND VGND VPWR VPWR sky130_fd_sc_hd__decap_3
XFILLER_120_533 VGND VGND VPWR VPWR sky130_fd_sc_hd__decap_3
XFILLER_66_609 VGND VGND VPWR VPWR sky130_fd_sc_hd__decap_3
XFILLER_78_469 VGND VGND VPWR VPWR sky130_fd_sc_hd__decap_3
XFILLER_59_650 VGND VGND VPWR VPWR sky130_fd_sc_hd__decap_3
XFILLER_93_406 VGND VGND VPWR VPWR sky130_fd_sc_hd__decap_3
XFILLER_48_74 VGND VGND VPWR VPWR sky130_fd_sc_hd__decap_3
XFILLER_93_428 VGND VGND VPWR VPWR sky130_fd_sc_hd__decap_3
XFILLER_65_119 VGND VGND VPWR VPWR sky130_fd_sc_hd__decap_3
XFILLER_48_85 VGND VGND VPWR VPWR sky130_fd_sc_hd__decap_3
XFILLER_93_439 VGND VGND VPWR VPWR sky130_fd_sc_hd__decap_3
XFILLER_19_525 VGND VGND VPWR VPWR sky130_fd_sc_hd__decap_3
XFILLER_86_480 VGND VGND VPWR VPWR sky130_fd_sc_hd__decap_3
XFILLER_0_15 VGND VGND VPWR VPWR sky130_fd_sc_hd__decap_3
XFILLER_74_642 VGND VGND VPWR VPWR sky130_fd_sc_hd__fill_2
XTAP_TAPCELL_ROW_109_1757 VGND VPWR sky130_fd_sc_hd__tapvpwrvgnd_1
XFILLER_46_344 VGND VGND VPWR VPWR sky130_fd_sc_hd__decap_3
XFILLER_19_558 VGND VGND VPWR VPWR sky130_fd_sc_hd__fill_2
XFILLER_34_517 VGND VGND VPWR VPWR sky130_fd_sc_hd__fill_2
XFILLER_64_40 VGND VGND VPWR VPWR sky130_fd_sc_hd__fill_1
XFILLER_46_377 VGND VGND VPWR VPWR sky130_fd_sc_hd__fill_2
XFILLER_46_388 VGND VGND VPWR VPWR sky130_fd_sc_hd__decap_3
XFILLER_34_539 VGND VGND VPWR VPWR sky130_fd_sc_hd__decap_3
XTAP_TAPCELL_ROW_122_1924 VGND VPWR sky130_fd_sc_hd__tapvpwrvgnd_1
XTAP_TAPCELL_ROW_122_1935 VGND VPWR sky130_fd_sc_hd__tapvpwrvgnd_1
XFILLER_27_591 VGND VGND VPWR VPWR sky130_fd_sc_hd__decap_3
XFILLER_61_358 VGND VGND VPWR VPWR sky130_fd_sc_hd__decap_3
XFILLER_15_753 VGND VGND VPWR VPWR sky130_fd_sc_hd__decap_3
XTAP_TAPCELL_ROW_32_707 VGND VPWR sky130_fd_sc_hd__tapvpwrvgnd_1
XFILLER_42_550 VGND VGND VPWR VPWR sky130_fd_sc_hd__decap_3
XTAP_TAPCELL_ROW_32_718 VGND VPWR sky130_fd_sc_hd__tapvpwrvgnd_1
XFILLER_9_24 VGND VGND VPWR VPWR sky130_fd_sc_hd__decap_3
XFILLER_30_701 VGND VGND VPWR VPWR sky130_fd_sc_hd__decap_3
XFILLER_42_572 VGND VGND VPWR VPWR sky130_fd_sc_hd__decap_3
XFILLER_14_296 VGND VGND VPWR VPWR sky130_fd_sc_hd__decap_3
XFILLER_80_61 VGND VGND VPWR VPWR sky130_fd_sc_hd__decap_3
XTAP_TAPCELL_ROW_12_442 VGND VPWR sky130_fd_sc_hd__tapvpwrvgnd_1
XFILLER_128_622 VGND VGND VPWR VPWR sky130_fd_sc_hd__decap_3
XFILLER_10_480 VGND VGND VPWR VPWR sky130_fd_sc_hd__decap_3
XFILLER_128_666 VGND VGND VPWR VPWR sky130_fd_sc_hd__decap_3
XFILLER_127_143 VGND VGND VPWR VPWR sky130_fd_sc_hd__decap_3
Xhold908 _9018_/Q VGND VGND VPWR VPWR hold908/X sky130_fd_sc_hd__dlygate4sd3_1
XFILLER_6_451 VGND VGND VPWR VPWR sky130_fd_sc_hd__decap_3
Xhold919 _4796_/X VGND VGND VPWR VPWR _4797_/A sky130_fd_sc_hd__dlygate4sd3_1
XFILLER_128_699 VGND VGND VPWR VPWR sky130_fd_sc_hd__fill_1
XFILLER_127_187 VGND VGND VPWR VPWR sky130_fd_sc_hd__decap_3
XFILLER_115_349 VGND VGND VPWR VPWR sky130_fd_sc_hd__decap_3
X_5140_ _6206_/A VGND VGND VPWR VPWR _5443_/A sky130_fd_sc_hd__inv_8
XFILLER_97_723 VGND VGND VPWR VPWR sky130_fd_sc_hd__decap_3
XFILLER_96_200 VGND VGND VPWR VPWR sky130_fd_sc_hd__decap_3
XFILLER_111_511 VGND VGND VPWR VPWR sky130_fd_sc_hd__decap_3
XFILLER_123_382 VGND VGND VPWR VPWR sky130_fd_sc_hd__decap_3
XFILLER_2_690 VGND VGND VPWR VPWR sky130_fd_sc_hd__decap_3
XFILLER_123_393 VGND VGND VPWR VPWR sky130_fd_sc_hd__fill_2
XFILLER_96_244 VGND VGND VPWR VPWR sky130_fd_sc_hd__decap_3
XFILLER_111_544 VGND VGND VPWR VPWR sky130_fd_sc_hd__decap_3
X_5071_ _5071_/A _5071_/B _5071_/C VGND VGND VPWR VPWR _5071_/Y sky130_fd_sc_hd__nor3_2
XFILLER_57_609 VGND VGND VPWR VPWR sky130_fd_sc_hd__decap_3
XFILLER_84_406 VGND VGND VPWR VPWR sky130_fd_sc_hd__decap_3
XFILLER_84_417 VGND VGND VPWR VPWR sky130_fd_sc_hd__decap_3
XFILLER_111_588 VGND VGND VPWR VPWR sky130_fd_sc_hd__decap_3
XFILLER_65_620 VGND VGND VPWR VPWR sky130_fd_sc_hd__decap_3
XFILLER_49_193 VGND VGND VPWR VPWR sky130_fd_sc_hd__decap_3
XFILLER_65_653 VGND VGND VPWR VPWR sky130_fd_sc_hd__decap_3
X_8830_ _8830_/A VGND VGND VPWR VPWR _9259_/D sky130_fd_sc_hd__buf_1
XFILLER_64_141 VGND VGND VPWR VPWR sky130_fd_sc_hd__decap_3
XFILLER_92_461 VGND VGND VPWR VPWR sky130_fd_sc_hd__decap_3
XTAP_TAPCELL_ROW_84_1418 VGND VPWR sky130_fd_sc_hd__tapvpwrvgnd_1
XFILLER_37_377 VGND VGND VPWR VPWR sky130_fd_sc_hd__decap_3
XFILLER_25_517 VGND VGND VPWR VPWR sky130_fd_sc_hd__decap_3
X_8761_ _8761_/A _8761_/B VGND VGND VPWR VPWR _8773_/B sky130_fd_sc_hd__xnor2_2
XFILLER_92_483 VGND VGND VPWR VPWR sky130_fd_sc_hd__fill_2
X_5973_ _5973_/A _5973_/B _5973_/C VGND VGND VPWR VPWR _5973_/X sky130_fd_sc_hd__and3_2
XFILLER_52_325 VGND VGND VPWR VPWR sky130_fd_sc_hd__decap_3
XFILLER_80_645 VGND VGND VPWR VPWR sky130_fd_sc_hd__decap_3
XFILLER_52_347 VGND VGND VPWR VPWR sky130_fd_sc_hd__decap_3
X_7712_ _7708_/X _7737_/B _7710_/X _7711_/X VGND VGND VPWR VPWR _7739_/A sky130_fd_sc_hd__a31oi_2
XFILLER_52_358 VGND VGND VPWR VPWR sky130_fd_sc_hd__fill_2
X_4924_ _6232_/C _4924_/B _6231_/B VGND VGND VPWR VPWR _5878_/B sky130_fd_sc_hd__nor3b_2
XFILLER_40_509 VGND VGND VPWR VPWR sky130_fd_sc_hd__decap_3
X_8692_ _8758_/A _8690_/Y _8691_/X VGND VGND VPWR VPWR _8693_/B sky130_fd_sc_hd__o21a_2
XFILLER_33_561 VGND VGND VPWR VPWR sky130_fd_sc_hd__fill_2
XFILLER_21_723 VGND VGND VPWR VPWR sky130_fd_sc_hd__decap_3
X_7643_ _7836_/B _7643_/B VGND VGND VPWR VPWR _7643_/Y sky130_fd_sc_hd__nor2_2
X_4855_ _4855_/A0 _9156_/Q _4861_/S VGND VGND VPWR VPWR _4855_/X sky130_fd_sc_hd__mux2_2
XFILLER_20_222 VGND VGND VPWR VPWR sky130_fd_sc_hd__decap_3
XFILLER_21_756 VGND VGND VPWR VPWR sky130_fd_sc_hd__decap_3
XFILLER_119_600 VGND VGND VPWR VPWR sky130_fd_sc_hd__fill_1
X_7574_ _8080_/A _6762_/C _7572_/X _7573_/X VGND VGND VPWR VPWR _7574_/X sky130_fd_sc_hd__a31o_2
X_4786_ _9139_/Q _4786_/A1 _4798_/S VGND VGND VPWR VPWR _4786_/X sky130_fd_sc_hd__mux2_2
XFILLER_20_277 VGND VGND VPWR VPWR sky130_fd_sc_hd__decap_3
X_9313_ _9313_/CLK _9313_/D load_slew388/X VGND VGND VPWR VPWR _9313_/Q sky130_fd_sc_hd__dfrtp_2
X_6525_ _6525_/A _6525_/B VGND VGND VPWR VPWR _6652_/A sky130_fd_sc_hd__nand2_4
XFILLER_118_121 VGND VGND VPWR VPWR sky130_fd_sc_hd__decap_3
XFILLER_20_299 VGND VGND VPWR VPWR sky130_fd_sc_hd__decap_3
XFILLER_109_36 VGND VGND VPWR VPWR sky130_fd_sc_hd__decap_3
X_9244_ clkload3/A _9244_/D fanout367/X VGND VGND VPWR VPWR _9244_/Q sky130_fd_sc_hd__dfrtp_2
XFILLER_118_165 VGND VGND VPWR VPWR sky130_fd_sc_hd__decap_3
X_6456_ _6456_/A _6509_/B VGND VGND VPWR VPWR _6457_/B sky130_fd_sc_hd__or2b_2
XFILLER_119_699 VGND VGND VPWR VPWR sky130_fd_sc_hd__decap_3
XTAP_TAPCELL_ROW_95_1558 VGND VPWR sky130_fd_sc_hd__tapvpwrvgnd_1
XTAP_TAPCELL_ROW_95_1569 VGND VPWR sky130_fd_sc_hd__tapvpwrvgnd_1
XFILLER_107_9 VGND VGND VPWR VPWR sky130_fd_sc_hd__decap_3
X_5407_ _5407_/A _5412_/B VGND VGND VPWR VPWR _5407_/X sky130_fd_sc_hd__or2_2
X_9175_ _9331_/CLK _9175_/D fanout389/X VGND VGND VPWR VPWR _9175_/Q sky130_fd_sc_hd__dfrtp_2
X_6387_ _6387_/A _6387_/B VGND VGND VPWR VPWR _6387_/Y sky130_fd_sc_hd__nor2_2
XFILLER_88_712 VGND VGND VPWR VPWR sky130_fd_sc_hd__decap_3
X_8126_ _8126_/A _8126_/B VGND VGND VPWR VPWR _8196_/C sky130_fd_sc_hd__nand2_2
X_5338_ _5338_/A _5338_/B VGND VGND VPWR VPWR _5338_/Y sky130_fd_sc_hd__xnor2_2
XFILLER_114_371 VGND VGND VPWR VPWR sky130_fd_sc_hd__decap_3
XFILLER_0_638 VGND VGND VPWR VPWR sky130_fd_sc_hd__decap_3
XFILLER_102_522 VGND VGND VPWR VPWR sky130_fd_sc_hd__decap_3
XFILLER_125_24 VGND VGND VPWR VPWR sky130_fd_sc_hd__decap_3
XFILLER_102_533 VGND VGND VPWR VPWR sky130_fd_sc_hd__decap_3
XFILLER_125_57 VGND VGND VPWR VPWR sky130_fd_sc_hd__decap_3
XFILLER_102_555 VGND VGND VPWR VPWR sky130_fd_sc_hd__decap_3
X_8057_ _8057_/A _8057_/B VGND VGND VPWR VPWR _8058_/A sky130_fd_sc_hd__xor2_4
X_5269_ _9071_/Q _9087_/Q _6231_/B VGND VGND VPWR VPWR _5269_/X sky130_fd_sc_hd__mux2_2
X_7008_ _7110_/A _7110_/B _7006_/X _7007_/X VGND VGND VPWR VPWR _7009_/B sky130_fd_sc_hd__a22o_2
XFILLER_68_480 VGND VGND VPWR VPWR sky130_fd_sc_hd__fill_2
XFILLER_56_664 VGND VGND VPWR VPWR sky130_fd_sc_hd__decap_3
XFILLER_55_141 VGND VGND VPWR VPWR sky130_fd_sc_hd__decap_3
XFILLER_83_461 VGND VGND VPWR VPWR sky130_fd_sc_hd__decap_3
XFILLER_56_697 VGND VGND VPWR VPWR sky130_fd_sc_hd__decap_3
X_8959_ _9321_/Q _8959_/A1 _8967_/S VGND VGND VPWR VPWR _8959_/X sky130_fd_sc_hd__mux2_2
XFILLER_71_667 VGND VGND VPWR VPWR sky130_fd_sc_hd__decap_3
XFILLER_12_701 VGND VGND VPWR VPWR sky130_fd_sc_hd__decap_3
XTAP_TAPCELL_ROW_104_1687 VGND VPWR sky130_fd_sc_hd__tapvpwrvgnd_1
XFILLER_24_583 VGND VGND VPWR VPWR sky130_fd_sc_hd__decap_3
XFILLER_12_734 VGND VGND VPWR VPWR sky130_fd_sc_hd__decap_3
XFILLER_51_380 VGND VGND VPWR VPWR sky130_fd_sc_hd__decap_3
XFILLER_8_716 VGND VGND VPWR VPWR sky130_fd_sc_hd__decap_3
XFILLER_11_244 VGND VGND VPWR VPWR sky130_fd_sc_hd__decap_3
Xwire113 wire113/A VGND VGND VPWR VPWR ready sky130_fd_sc_hd__buf_4
XFILLER_8_749 VGND VGND VPWR VPWR sky130_fd_sc_hd__decap_3
Xwire146 _5993_/Y VGND VGND VPWR VPWR wire146/X sky130_fd_sc_hd__buf_6
XFILLER_7_248 VGND VGND VPWR VPWR sky130_fd_sc_hd__decap_3
XFILLER_11_299 VGND VGND VPWR VPWR sky130_fd_sc_hd__decap_3
XFILLER_50_53 VGND VGND VPWR VPWR sky130_fd_sc_hd__decap_3
XFILLER_124_124 VGND VGND VPWR VPWR sky130_fd_sc_hd__decap_3
XTAP_TAPCELL_ROW_55_1019 VGND VPWR sky130_fd_sc_hd__tapvpwrvgnd_1
XFILLER_98_509 VGND VGND VPWR VPWR sky130_fd_sc_hd__decap_3
XFILLER_79_701 VGND VGND VPWR VPWR sky130_fd_sc_hd__fill_1
XFILLER_3_465 VGND VGND VPWR VPWR sky130_fd_sc_hd__decap_3
XFILLER_124_168 VGND VGND VPWR VPWR sky130_fd_sc_hd__decap_3
XFILLER_79_723 VGND VGND VPWR VPWR sky130_fd_sc_hd__decap_3
XFILLER_105_393 VGND VGND VPWR VPWR sky130_fd_sc_hd__decap_3
XFILLER_59_73 VGND VGND VPWR VPWR sky130_fd_sc_hd__decap_3
XFILLER_22_9 VGND VGND VPWR VPWR sky130_fd_sc_hd__decap_3
XFILLER_38_108 VGND VGND VPWR VPWR sky130_fd_sc_hd__fill_1
XFILLER_66_439 VGND VGND VPWR VPWR sky130_fd_sc_hd__decap_3
XFILLER_47_620 VGND VGND VPWR VPWR sky130_fd_sc_hd__fill_1
XFILLER_19_311 VGND VGND VPWR VPWR sky130_fd_sc_hd__decap_3
Xfanout290 input5/X VGND VGND VPWR VPWR _6885_/A sky130_fd_sc_hd__clkdlybuf4s25_1
XFILLER_46_130 VGND VGND VPWR VPWR sky130_fd_sc_hd__decap_3
XFILLER_75_83 VGND VGND VPWR VPWR sky130_fd_sc_hd__fill_2
XFILLER_74_483 VGND VGND VPWR VPWR sky130_fd_sc_hd__decap_3
XFILLER_61_100 VGND VGND VPWR VPWR sky130_fd_sc_hd__decap_3
XFILLER_19_388 VGND VGND VPWR VPWR sky130_fd_sc_hd__decap_3
XTAP_TAPCELL_ROW_17_512 VGND VPWR sky130_fd_sc_hd__tapvpwrvgnd_1
XFILLER_34_325 VGND VGND VPWR VPWR sky130_fd_sc_hd__fill_1
XFILLER_61_122 VGND VGND VPWR VPWR sky130_fd_sc_hd__fill_2
XFILLER_34_347 VGND VGND VPWR VPWR sky130_fd_sc_hd__decap_3
XFILLER_62_667 VGND VGND VPWR VPWR sky130_fd_sc_hd__decap_3
XFILLER_61_144 VGND VGND VPWR VPWR sky130_fd_sc_hd__decap_3
XTAP_TAPCELL_ROW_45_887 VGND VPWR sky130_fd_sc_hd__tapvpwrvgnd_1
XFILLER_15_561 VGND VGND VPWR VPWR sky130_fd_sc_hd__decap_3
XFILLER_91_60 VGND VGND VPWR VPWR sky130_fd_sc_hd__decap_3
XFILLER_15_572 VGND VGND VPWR VPWR sky130_fd_sc_hd__decap_3
XFILLER_91_71 VGND VGND VPWR VPWR sky130_fd_sc_hd__decap_3
XFILLER_42_380 VGND VGND VPWR VPWR sky130_fd_sc_hd__decap_3
XFILLER_30_520 VGND VGND VPWR VPWR sky130_fd_sc_hd__fill_2
X_4640_ hold892/X _4640_/A1 _4650_/S VGND VGND VPWR VPWR _4641_/A sky130_fd_sc_hd__mux2_2
XFILLER_30_564 VGND VGND VPWR VPWR sky130_fd_sc_hd__decap_3
X_4571_ _9037_/Q hold827/X _4587_/S VGND VGND VPWR VPWR _4571_/X sky130_fd_sc_hd__mux2_2
XFILLER_116_603 VGND VGND VPWR VPWR sky130_fd_sc_hd__decap_3
X_6310_ _6583_/A _6583_/B VGND VGND VPWR VPWR _6568_/A sky130_fd_sc_hd__xor2_2
XFILLER_7_771 VGND VGND VPWR VPWR sky130_fd_sc_hd__decap_3
X_7290_ _6346_/A _6346_/B _7799_/A VGND VGND VPWR VPWR _7450_/A sky130_fd_sc_hd__a21o_2
XFILLER_115_113 VGND VGND VPWR VPWR sky130_fd_sc_hd__decap_3
X_6241_ _9078_/Q _5456_/B _5065_/X _9282_/Q VGND VGND VPWR VPWR _6241_/X sky130_fd_sc_hd__a22o_2
Xhold749 input10/X VGND VGND VPWR VPWR hold749/X sky130_fd_sc_hd__dlygate4sd3_1
XFILLER_116_669 VGND VGND VPWR VPWR sky130_fd_sc_hd__fill_1
X_6172_ _6172_/A _6172_/B _6172_/C VGND VGND VPWR VPWR _6184_/C sky130_fd_sc_hd__and3_4
XFILLER_130_116 VGND VGND VPWR VPWR sky130_fd_sc_hd__decap_3
X_5123_ _5123_/A _5123_/B _5123_/C _5123_/D VGND VGND VPWR VPWR _5123_/Y sky130_fd_sc_hd__nor4_2
XFILLER_123_190 VGND VGND VPWR VPWR sky130_fd_sc_hd__decap_3
XFILLER_97_564 VGND VGND VPWR VPWR sky130_fd_sc_hd__decap_3
XFILLER_85_704 VGND VGND VPWR VPWR sky130_fd_sc_hd__decap_3
XFILLER_111_352 VGND VGND VPWR VPWR sky130_fd_sc_hd__decap_3
XTAP_TAPCELL_ROW_90_1499 VGND VPWR sky130_fd_sc_hd__tapvpwrvgnd_1
XFILLER_111_374 VGND VGND VPWR VPWR sky130_fd_sc_hd__decap_3
X_5054_ _9240_/Q _5742_/D VGND VGND VPWR VPWR _5054_/X sky130_fd_sc_hd__and2_2
XFILLER_38_631 VGND VGND VPWR VPWR sky130_fd_sc_hd__decap_3
XFILLER_38_664 VGND VGND VPWR VPWR sky130_fd_sc_hd__decap_3
XFILLER_65_461 VGND VGND VPWR VPWR sky130_fd_sc_hd__decap_3
XFILLER_65_483 VGND VGND VPWR VPWR sky130_fd_sc_hd__decap_3
XFILLER_1_91 VGND VGND VPWR VPWR sky130_fd_sc_hd__decap_3
X_8813_ _8813_/A VGND VGND VPWR VPWR _9251_/D sky130_fd_sc_hd__buf_1
XFILLER_37_185 VGND VGND VPWR VPWR sky130_fd_sc_hd__decap_3
XFILLER_111_15 VGND VGND VPWR VPWR sky130_fd_sc_hd__decap_3
XFILLER_80_442 VGND VGND VPWR VPWR sky130_fd_sc_hd__decap_3
XFILLER_52_133 VGND VGND VPWR VPWR sky130_fd_sc_hd__decap_3
XFILLER_111_48 VGND VGND VPWR VPWR sky130_fd_sc_hd__decap_3
X_5956_ _6076_/A _5088_/A _5955_/Y VGND VGND VPWR VPWR _5956_/Y sky130_fd_sc_hd__a21oi_2
X_8744_ _8768_/A _8744_/B VGND VGND VPWR VPWR _8745_/B sky130_fd_sc_hd__xnor2_2
XFILLER_52_166 VGND VGND VPWR VPWR sky130_fd_sc_hd__decap_3
XFILLER_40_306 VGND VGND VPWR VPWR sky130_fd_sc_hd__fill_2
XFILLER_80_497 VGND VGND VPWR VPWR sky130_fd_sc_hd__decap_3
X_4907_ _9225_/Q _4907_/B VGND VGND VPWR VPWR _4907_/Y sky130_fd_sc_hd__nor2_2
X_8675_ _8678_/A _8673_/Y _8674_/X VGND VGND VPWR VPWR _8675_/X sky130_fd_sc_hd__a21o_2
XFILLER_33_380 VGND VGND VPWR VPWR sky130_fd_sc_hd__decap_3
X_5887_ _9076_/Q _6336_/B _6754_/B VGND VGND VPWR VPWR _5887_/X sky130_fd_sc_hd__and3_2
X_4838_ hold944/X _9148_/Q _4840_/S VGND VGND VPWR VPWR _4838_/X sky130_fd_sc_hd__mux2_2
X_7626_ _7626_/A _7626_/B _7626_/C _7626_/D VGND VGND VPWR VPWR _7626_/X sky130_fd_sc_hd__or4_4
X_7557_ _7557_/A VGND VGND VPWR VPWR _7558_/B sky130_fd_sc_hd__inv_2
X_4769_ _9131_/Q _4769_/A1 _4777_/S VGND VGND VPWR VPWR _4769_/X sky130_fd_sc_hd__mux2_2
XFILLER_119_452 VGND VGND VPWR VPWR sky130_fd_sc_hd__decap_3
XFILLER_107_603 VGND VGND VPWR VPWR sky130_fd_sc_hd__fill_1
X_6508_ _6509_/A _6456_/A _6786_/B _6394_/A VGND VGND VPWR VPWR _6508_/X sky130_fd_sc_hd__a22o_2
XFILLER_119_474 VGND VGND VPWR VPWR sky130_fd_sc_hd__decap_3
XFILLER_106_102 VGND VGND VPWR VPWR sky130_fd_sc_hd__decap_3
XFILLER_20_12 VGND VGND VPWR VPWR sky130_fd_sc_hd__decap_3
X_7488_ _7488_/A _7488_/B VGND VGND VPWR VPWR _7490_/B sky130_fd_sc_hd__or2_4
XFILLER_119_496 VGND VGND VPWR VPWR sky130_fd_sc_hd__decap_3
XFILLER_105_6 VGND VGND VPWR VPWR sky130_fd_sc_hd__decap_3
XFILLER_107_669 VGND VGND VPWR VPWR sky130_fd_sc_hd__decap_3
X_6439_ _6435_/X _6437_/X _6124_/A _6438_/Y VGND VGND VPWR VPWR _6439_/X sky130_fd_sc_hd__o2bb2a_2
X_9227_ _9227_/CLK _9227_/D wire417/X VGND VGND VPWR VPWR _9227_/Q sky130_fd_sc_hd__dfrtp_2
XFILLER_20_67 VGND VGND VPWR VPWR sky130_fd_sc_hd__decap_3
XFILLER_0_402 VGND VGND VPWR VPWR sky130_fd_sc_hd__decap_3
XFILLER_121_105 VGND VGND VPWR VPWR sky130_fd_sc_hd__decap_3
X_9158_ _9317_/CLK _9158_/D wire406/X VGND VGND VPWR VPWR _9158_/Q sky130_fd_sc_hd__dfrtp_2
XFILLER_122_639 VGND VGND VPWR VPWR sky130_fd_sc_hd__decap_3
XFILLER_121_116 VGND VGND VPWR VPWR sky130_fd_sc_hd__decap_3
XFILLER_96_27 VGND VGND VPWR VPWR sky130_fd_sc_hd__fill_1
XFILLER_0_424 VGND VGND VPWR VPWR sky130_fd_sc_hd__decap_3
XFILLER_115_691 VGND VGND VPWR VPWR sky130_fd_sc_hd__decap_3
X_8109_ _8109_/A _8109_/B VGND VGND VPWR VPWR _8112_/A sky130_fd_sc_hd__xnor2_2
XFILLER_121_149 VGND VGND VPWR VPWR sky130_fd_sc_hd__decap_3
XFILLER_114_190 VGND VGND VPWR VPWR sky130_fd_sc_hd__decap_3
XFILLER_102_341 VGND VGND VPWR VPWR sky130_fd_sc_hd__decap_3
X_9089_ _9168_/CLK _9089_/D fanout377/X VGND VGND VPWR VPWR _9089_/Q sky130_fd_sc_hd__dfrtp_2
XFILLER_76_748 VGND VGND VPWR VPWR sky130_fd_sc_hd__decap_3
XFILLER_130_694 VGND VGND VPWR VPWR sky130_fd_sc_hd__decap_3
XFILLER_75_225 VGND VGND VPWR VPWR sky130_fd_sc_hd__decap_3
XFILLER_28_141 VGND VGND VPWR VPWR sky130_fd_sc_hd__decap_3
XFILLER_91_729 VGND VGND VPWR VPWR sky130_fd_sc_hd__fill_2
XFILLER_90_217 VGND VGND VPWR VPWR sky130_fd_sc_hd__fill_1
XTAP_TAPCELL_ROW_106_1716 VGND VPWR sky130_fd_sc_hd__tapvpwrvgnd_1
XFILLER_28_174 VGND VGND VPWR VPWR sky130_fd_sc_hd__decap_3
XFILLER_43_111 VGND VGND VPWR VPWR sky130_fd_sc_hd__fill_1
XFILLER_71_431 VGND VGND VPWR VPWR sky130_fd_sc_hd__decap_3
XFILLER_44_645 VGND VGND VPWR VPWR sky130_fd_sc_hd__decap_3
XFILLER_16_336 VGND VGND VPWR VPWR sky130_fd_sc_hd__decap_3
XFILLER_71_453 VGND VGND VPWR VPWR sky130_fd_sc_hd__decap_3
XFILLER_43_155 VGND VGND VPWR VPWR sky130_fd_sc_hd__decap_3
XTAP_TAPCELL_ROW_42_846 VGND VPWR sky130_fd_sc_hd__tapvpwrvgnd_1
XFILLER_61_30 VGND VGND VPWR VPWR sky130_fd_sc_hd__decap_3
XFILLER_129_205 VGND VGND VPWR VPWR sky130_fd_sc_hd__decap_3
XFILLER_12_575 VGND VGND VPWR VPWR sky130_fd_sc_hd__decap_3
XFILLER_12_597 VGND VGND VPWR VPWR sky130_fd_sc_hd__decap_3
XTAP_TAPCELL_ROW_22_581 VGND VPWR sky130_fd_sc_hd__tapvpwrvgnd_1
XFILLER_8_557 VGND VGND VPWR VPWR sky130_fd_sc_hd__decap_3
XANTENNA_7 _7728_/B VGND VGND VPWR VPWR sky130_fd_sc_hd__diode_2
XFILLER_6_47 VGND VGND VPWR VPWR sky130_fd_sc_hd__decap_3
XTAP_TAPCELL_ROW_117_1856 VGND VPWR sky130_fd_sc_hd__tapvpwrvgnd_1
XTAP_TAPCELL_ROW_117_1867 VGND VPWR sky130_fd_sc_hd__tapvpwrvgnd_1
XFILLER_125_433 VGND VGND VPWR VPWR sky130_fd_sc_hd__fill_1
XFILLER_4_752 VGND VGND VPWR VPWR sky130_fd_sc_hd__decap_3
XFILLER_125_466 VGND VGND VPWR VPWR sky130_fd_sc_hd__decap_3
XFILLER_98_306 VGND VGND VPWR VPWR sky130_fd_sc_hd__fill_2
XFILLER_4_763 VGND VGND VPWR VPWR sky130_fd_sc_hd__decap_3
XFILLER_3_240 VGND VGND VPWR VPWR sky130_fd_sc_hd__decap_3
XFILLER_113_617 VGND VGND VPWR VPWR sky130_fd_sc_hd__decap_3
XFILLER_3_262 VGND VGND VPWR VPWR sky130_fd_sc_hd__decap_3
XFILLER_125_499 VGND VGND VPWR VPWR sky130_fd_sc_hd__decap_3
XFILLER_112_116 VGND VGND VPWR VPWR sky130_fd_sc_hd__decap_3
XFILLER_112_149 VGND VGND VPWR VPWR sky130_fd_sc_hd__decap_3
XFILLER_79_553 VGND VGND VPWR VPWR sky130_fd_sc_hd__decap_3
XFILLER_79_564 VGND VGND VPWR VPWR sky130_fd_sc_hd__decap_3
XFILLER_94_501 VGND VGND VPWR VPWR sky130_fd_sc_hd__decap_3
XFILLER_67_715 VGND VGND VPWR VPWR sky130_fd_sc_hd__decap_3
XFILLER_20_6 VGND VGND VPWR VPWR sky130_fd_sc_hd__decap_3
XFILLER_94_512 VGND VGND VPWR VPWR sky130_fd_sc_hd__decap_3
XFILLER_120_171 VGND VGND VPWR VPWR sky130_fd_sc_hd__decap_3
XFILLER_94_556 VGND VGND VPWR VPWR sky130_fd_sc_hd__decap_3
XFILLER_82_707 VGND VGND VPWR VPWR sky130_fd_sc_hd__decap_3
XFILLER_54_409 VGND VGND VPWR VPWR sky130_fd_sc_hd__decap_3
XFILLER_94_589 VGND VGND VPWR VPWR sky130_fd_sc_hd__decap_3
XFILLER_75_770 VGND VGND VPWR VPWR sky130_fd_sc_hd__decap_3
XFILLER_47_483 VGND VGND VPWR VPWR sky130_fd_sc_hd__fill_2
XFILLER_35_623 VGND VGND VPWR VPWR sky130_fd_sc_hd__fill_2
XFILLER_47_494 VGND VGND VPWR VPWR sky130_fd_sc_hd__decap_3
XFILLER_19_185 VGND VGND VPWR VPWR sky130_fd_sc_hd__decap_3
XFILLER_62_442 VGND VGND VPWR VPWR sky130_fd_sc_hd__decap_3
X_5810_ _5811_/A _5811_/B VGND VGND VPWR VPWR _5813_/A sky130_fd_sc_hd__nand2_2
XFILLER_90_762 VGND VGND VPWR VPWR sky130_fd_sc_hd__fill_2
XFILLER_34_144 VGND VGND VPWR VPWR sky130_fd_sc_hd__decap_3
XFILLER_90_773 VGND VGND VPWR VPWR sky130_fd_sc_hd__decap_3
X_6790_ _6790_/A _6885_/A VGND VGND VPWR VPWR _6790_/Y sky130_fd_sc_hd__nor2_2
XFILLER_50_615 VGND VGND VPWR VPWR sky130_fd_sc_hd__decap_3
XFILLER_62_475 VGND VGND VPWR VPWR sky130_fd_sc_hd__fill_1
XFILLER_50_626 VGND VGND VPWR VPWR sky130_fd_sc_hd__decap_3
XFILLER_34_177 VGND VGND VPWR VPWR sky130_fd_sc_hd__fill_1
X_5741_ _9171_/Q _4516_/X _5126_/X _9139_/Q VGND VGND VPWR VPWR _5742_/A sky130_fd_sc_hd__a22o_2
X_8460_ _8460_/A VGND VGND VPWR VPWR _8521_/S sky130_fd_sc_hd__inv_2
X_5672_ _5670_/Y _5672_/B VGND VGND VPWR VPWR _5673_/A sky130_fd_sc_hd__and2b_2
XFILLER_30_350 VGND VGND VPWR VPWR sky130_fd_sc_hd__decap_3
X_7411_ _7401_/X _7406_/X _7410_/X _8239_/A VGND VGND VPWR VPWR _7624_/A sky130_fd_sc_hd__a31o_2
XFILLER_30_383 VGND VGND VPWR VPWR sky130_fd_sc_hd__decap_3
X_4623_ _4658_/A1 hold989/X _4629_/S VGND VGND VPWR VPWR _4624_/A sky130_fd_sc_hd__mux2_2
X_8391_ _8388_/Y _8390_/Y _8688_/S VGND VGND VPWR VPWR _8392_/A sky130_fd_sc_hd__mux2_2
XFILLER_129_750 VGND VGND VPWR VPWR sky130_fd_sc_hd__decap_3
X_7342_ _7342_/A _7342_/B VGND VGND VPWR VPWR _7344_/B sky130_fd_sc_hd__and2_2
X_4554_ _4554_/A0 _9345_/Q _4566_/S VGND VGND VPWR VPWR _4554_/X sky130_fd_sc_hd__mux2_2
Xmax_cap210 _6808_/S VGND VGND VPWR VPWR _6395_/A sky130_fd_sc_hd__buf_4
XTAP_TAPCELL_ROW_92_1517 VGND VPWR sky130_fd_sc_hd__tapvpwrvgnd_1
X_7273_ _7273_/A _7273_/B _7272_/X VGND VGND VPWR VPWR _7273_/X sky130_fd_sc_hd__or3b_4
XFILLER_104_606 VGND VGND VPWR VPWR sky130_fd_sc_hd__fill_1
XTAP_TAPCELL_ROW_92_1528 VGND VPWR sky130_fd_sc_hd__tapvpwrvgnd_1
XFILLER_116_466 VGND VGND VPWR VPWR sky130_fd_sc_hd__decap_3
XFILLER_104_628 VGND VGND VPWR VPWR sky130_fd_sc_hd__decap_3
X_9012_ _9012_/A VGND VGND VPWR VPWR _9346_/D sky130_fd_sc_hd__buf_1
X_6224_ _6224_/A _6224_/B VGND VGND VPWR VPWR _6248_/A sky130_fd_sc_hd__and2_2
XFILLER_103_116 VGND VGND VPWR VPWR sky130_fd_sc_hd__decap_3
XFILLER_106_15 VGND VGND VPWR VPWR sky130_fd_sc_hd__decap_3
XFILLER_103_149 VGND VGND VPWR VPWR sky130_fd_sc_hd__decap_3
X_6155_ _6052_/A _6153_/Y _6154_/X _6151_/A VGND VGND VPWR VPWR _6155_/X sky130_fd_sc_hd__a2bb2o_2
Xhold1202 _9080_/Q VGND VGND VPWR VPWR _4696_/A1 sky130_fd_sc_hd__dlygate4sd3_1
X_5106_ _5106_/A1 _8174_/B _4916_/A _6302_/A VGND VGND VPWR VPWR _6177_/A sky130_fd_sc_hd__a211o_2
Xhold1213 _9090_/Q VGND VGND VPWR VPWR _4717_/A1 sky130_fd_sc_hd__dlygate4sd3_1
XFILLER_85_534 VGND VGND VPWR VPWR sky130_fd_sc_hd__decap_3
XFILLER_57_225 VGND VGND VPWR VPWR sky130_fd_sc_hd__decap_3
X_6086_ _6094_/B _6809_/A VGND VGND VPWR VPWR _6095_/A sky130_fd_sc_hd__and2b_2
Xhold1235 _5967_/Y VGND VGND VPWR VPWR _5968_/A1 sky130_fd_sc_hd__dlygate4sd3_1
Xhold1246 _9226_/Q VGND VGND VPWR VPWR _8581_/A sky130_fd_sc_hd__dlygate4sd3_1
XFILLER_85_556 VGND VGND VPWR VPWR sky130_fd_sc_hd__decap_3
Xhold1257 _6074_/X VGND VGND VPWR VPWR _6141_/A sky130_fd_sc_hd__dlygate4sd3_1
X_5037_ _5037_/A VGND VGND VPWR VPWR _9197_/D sky130_fd_sc_hd__buf_1
XFILLER_85_578 VGND VGND VPWR VPWR sky130_fd_sc_hd__decap_3
XFILLER_73_729 VGND VGND VPWR VPWR sky130_fd_sc_hd__fill_2
XFILLER_38_450 VGND VGND VPWR VPWR sky130_fd_sc_hd__decap_3
XFILLER_72_228 VGND VGND VPWR VPWR sky130_fd_sc_hd__decap_3
XFILLER_122_47 VGND VGND VPWR VPWR sky130_fd_sc_hd__decap_3
XFILLER_26_645 VGND VGND VPWR VPWR sky130_fd_sc_hd__decap_3
XFILLER_25_122 VGND VGND VPWR VPWR sky130_fd_sc_hd__decap_3
XFILLER_53_442 VGND VGND VPWR VPWR sky130_fd_sc_hd__decap_3
XTAP_TAPCELL_ROW_0_265 VGND VPWR sky130_fd_sc_hd__tapvpwrvgnd_1
XFILLER_81_762 VGND VGND VPWR VPWR sky130_fd_sc_hd__decap_3
XTAP_TAPCELL_ROW_0_276 VGND VPWR sky130_fd_sc_hd__tapvpwrvgnd_1
XFILLER_15_12 VGND VGND VPWR VPWR sky130_fd_sc_hd__decap_3
XTAP_TAPCELL_ROW_0_287 VGND VPWR sky130_fd_sc_hd__tapvpwrvgnd_1
XFILLER_41_615 VGND VGND VPWR VPWR sky130_fd_sc_hd__fill_1
X_6988_ _6616_/A _6616_/B _7050_/B VGND VGND VPWR VPWR _6989_/B sky130_fd_sc_hd__a21o_2
XFILLER_53_497 VGND VGND VPWR VPWR sky130_fd_sc_hd__decap_3
XFILLER_80_283 VGND VGND VPWR VPWR sky130_fd_sc_hd__decap_3
X_8727_ _8716_/B _8725_/Y _8726_/X VGND VGND VPWR VPWR _8770_/B sky130_fd_sc_hd__a21bo_2
X_5939_ _5937_/X _5938_/X _5939_/S VGND VGND VPWR VPWR _5939_/X sky130_fd_sc_hd__mux2_2
XFILLER_15_78 VGND VGND VPWR VPWR sky130_fd_sc_hd__decap_3
XTAP_TAPCELL_ROW_101_1646 VGND VPWR sky130_fd_sc_hd__tapvpwrvgnd_1
XFILLER_40_169 VGND VGND VPWR VPWR sky130_fd_sc_hd__decap_3
X_8658_ _9227_/Q _8739_/B VGND VGND VPWR VPWR _8666_/B sky130_fd_sc_hd__nor2_2
Xrebuffer610 _7859_/Y VGND VGND VPWR VPWR _7897_/A sky130_fd_sc_hd__buf_4
XFILLER_127_709 VGND VGND VPWR VPWR sky130_fd_sc_hd__decap_3
X_7609_ _7609_/A _7609_/B VGND VGND VPWR VPWR _7620_/A sky130_fd_sc_hd__xnor2_2
X_8589_ _8341_/A _8496_/X _8244_/A _8177_/B VGND VGND VPWR VPWR _8695_/B sky130_fd_sc_hd__a2bb2o_2
XFILLER_5_505 VGND VGND VPWR VPWR sky130_fd_sc_hd__decap_3
Xrebuffer654 fanout360/A VGND VGND VPWR VPWR _6809_/A sky130_fd_sc_hd__buf_2
XFILLER_31_55 VGND VGND VPWR VPWR sky130_fd_sc_hd__fill_1
XFILLER_119_271 VGND VGND VPWR VPWR sky130_fd_sc_hd__fill_2
Xrebuffer676 _8211_/X VGND VGND VPWR VPWR _8774_/C1 sky130_fd_sc_hd__buf_8
XFILLER_103_3 VGND VGND VPWR VPWR sky130_fd_sc_hd__decap_3
XFILLER_122_403 VGND VGND VPWR VPWR sky130_fd_sc_hd__decap_3
Xoutput22 _9191_/Q VGND VGND VPWR VPWR wire232/A sky130_fd_sc_hd__buf_1
XFILLER_1_700 VGND VGND VPWR VPWR sky130_fd_sc_hd__decap_3
Xoutput33 _9187_/Q VGND VGND VPWR VPWR wire221/A sky130_fd_sc_hd__buf_1
XFILLER_0_221 VGND VGND VPWR VPWR sky130_fd_sc_hd__decap_3
XFILLER_1_744 VGND VGND VPWR VPWR sky130_fd_sc_hd__decap_3
XFILLER_95_309 VGND VGND VPWR VPWR sky130_fd_sc_hd__decap_3
XFILLER_0_243 VGND VGND VPWR VPWR sky130_fd_sc_hd__fill_1
XFILLER_103_661 VGND VGND VPWR VPWR sky130_fd_sc_hd__fill_1
XTAP_TAPCELL_ROW_8_387 VGND VPWR sky130_fd_sc_hd__tapvpwrvgnd_1
XFILLER_0_265 VGND VGND VPWR VPWR sky130_fd_sc_hd__decap_3
XTAP_TAPCELL_ROW_112_1797 VGND VPWR sky130_fd_sc_hd__tapvpwrvgnd_1
XFILLER_0_287 VGND VGND VPWR VPWR sky130_fd_sc_hd__decap_3
XFILLER_49_748 VGND VGND VPWR VPWR sky130_fd_sc_hd__decap_3
XFILLER_130_480 VGND VGND VPWR VPWR sky130_fd_sc_hd__decap_3
XFILLER_48_236 VGND VGND VPWR VPWR sky130_fd_sc_hd__fill_1
XFILLER_76_556 VGND VGND VPWR VPWR sky130_fd_sc_hd__decap_3
XFILLER_56_41 VGND VGND VPWR VPWR sky130_fd_sc_hd__decap_3
XTAP_TAPCELL_ROW_47_916 VGND VPWR sky130_fd_sc_hd__tapvpwrvgnd_1
XFILLER_76_589 VGND VGND VPWR VPWR sky130_fd_sc_hd__decap_3
XFILLER_57_770 VGND VGND VPWR VPWR sky130_fd_sc_hd__decap_3
XFILLER_29_461 VGND VGND VPWR VPWR sky130_fd_sc_hd__decap_3
XFILLER_91_537 VGND VGND VPWR VPWR sky130_fd_sc_hd__fill_2
XFILLER_63_228 VGND VGND VPWR VPWR sky130_fd_sc_hd__decap_3
XFILLER_56_85 VGND VGND VPWR VPWR sky130_fd_sc_hd__decap_3
XFILLER_91_559 VGND VGND VPWR VPWR sky130_fd_sc_hd__fill_1
XFILLER_17_645 VGND VGND VPWR VPWR sky130_fd_sc_hd__decap_3
XFILLER_16_122 VGND VGND VPWR VPWR sky130_fd_sc_hd__fill_1
XTAP_TAPCELL_ROW_27_640 VGND VPWR sky130_fd_sc_hd__tapvpwrvgnd_1
XFILLER_16_144 VGND VGND VPWR VPWR sky130_fd_sc_hd__decap_3
XTAP_TAPCELL_ROW_27_651 VGND VPWR sky130_fd_sc_hd__tapvpwrvgnd_1
XFILLER_72_773 VGND VGND VPWR VPWR sky130_fd_sc_hd__decap_3
XFILLER_16_177 VGND VGND VPWR VPWR sky130_fd_sc_hd__decap_3
XTAP_TAPCELL_ROW_63_1129 VGND VPWR sky130_fd_sc_hd__tapvpwrvgnd_1
XFILLER_112_91 VGND VGND VPWR VPWR sky130_fd_sc_hd__decap_3
XFILLER_12_383 VGND VGND VPWR VPWR sky130_fd_sc_hd__decap_3
XFILLER_8_343 VGND VGND VPWR VPWR sky130_fd_sc_hd__decap_3
XFILLER_8_365 VGND VGND VPWR VPWR sky130_fd_sc_hd__decap_3
XFILLER_68_6 VGND VGND VPWR VPWR sky130_fd_sc_hd__fill_1
XFILLER_8_398 VGND VGND VPWR VPWR sky130_fd_sc_hd__decap_3
XFILLER_126_731 VGND VGND VPWR VPWR sky130_fd_sc_hd__decap_3
XFILLER_126_775 VGND VGND VPWR VPWR sky130_fd_sc_hd__fill_2
XFILLER_99_615 VGND VGND VPWR VPWR sky130_fd_sc_hd__fill_1
XFILLER_125_252 VGND VGND VPWR VPWR sky130_fd_sc_hd__decap_3
XFILLER_98_103 VGND VGND VPWR VPWR sky130_fd_sc_hd__decap_3
XFILLER_113_414 VGND VGND VPWR VPWR sky130_fd_sc_hd__decap_3
XFILLER_99_648 VGND VGND VPWR VPWR sky130_fd_sc_hd__fill_2
XFILLER_4_571 VGND VGND VPWR VPWR sky130_fd_sc_hd__decap_3
XFILLER_113_458 VGND VGND VPWR VPWR sky130_fd_sc_hd__decap_3
XFILLER_86_309 VGND VGND VPWR VPWR sky130_fd_sc_hd__decap_3
XFILLER_67_534 VGND VGND VPWR VPWR sky130_fd_sc_hd__decap_3
XFILLER_39_225 VGND VGND VPWR VPWR sky130_fd_sc_hd__decap_3
XFILLER_94_353 VGND VGND VPWR VPWR sky130_fd_sc_hd__decap_3
XFILLER_67_567 VGND VGND VPWR VPWR sky130_fd_sc_hd__decap_3
XFILLER_27_409 VGND VGND VPWR VPWR sky130_fd_sc_hd__decap_3
X_7960_ _8170_/A _8070_/A _7960_/C wire88/A VGND VGND VPWR VPWR _7960_/X sky130_fd_sc_hd__and4_2
XFILLER_67_589 VGND VGND VPWR VPWR sky130_fd_sc_hd__decap_3
XFILLER_55_729 VGND VGND VPWR VPWR sky130_fd_sc_hd__decap_3
XFILLER_48_770 VGND VGND VPWR VPWR sky130_fd_sc_hd__decap_3
XFILLER_94_386 VGND VGND VPWR VPWR sky130_fd_sc_hd__decap_3
X_6911_ _6912_/A _6912_/B _6912_/C VGND VGND VPWR VPWR _6911_/Y sky130_fd_sc_hd__a21oi_2
XFILLER_54_239 VGND VGND VPWR VPWR sky130_fd_sc_hd__fill_2
XFILLER_35_420 VGND VGND VPWR VPWR sky130_fd_sc_hd__decap_3
X_7891_ _7891_/A _8006_/C VGND VGND VPWR VPWR _7892_/B sky130_fd_sc_hd__xor2_2
X_6842_ _6506_/B _6842_/A2 _6841_/Y VGND VGND VPWR VPWR _6899_/A sky130_fd_sc_hd__a21bo_2
XFILLER_50_401 VGND VGND VPWR VPWR sky130_fd_sc_hd__decap_3
XFILLER_23_626 VGND VGND VPWR VPWR sky130_fd_sc_hd__fill_2
XFILLER_22_103 VGND VGND VPWR VPWR sky130_fd_sc_hd__decap_3
XFILLER_90_592 VGND VGND VPWR VPWR sky130_fd_sc_hd__fill_1
X_6773_ _6774_/A _6774_/B _6774_/C _6774_/D VGND VGND VPWR VPWR _6920_/A sky130_fd_sc_hd__a22o_2
XFILLER_50_467 VGND VGND VPWR VPWR sky130_fd_sc_hd__decap_3
X_5724_ _5861_/A _5724_/B _5861_/B VGND VGND VPWR VPWR _5725_/B sky130_fd_sc_hd__and3_2
X_8512_ _8512_/A _8512_/B VGND VGND VPWR VPWR _8512_/X sky130_fd_sc_hd__or2_4
X_5655_ _5790_/A _6873_/A VGND VGND VPWR VPWR _5656_/B sky130_fd_sc_hd__or2_2
X_8443_ _9221_/Q _8443_/B VGND VGND VPWR VPWR _8445_/B sky130_fd_sc_hd__nand2_2
X_4606_ _9054_/Q hold888/X _4608_/S VGND VGND VPWR VPWR _4606_/X sky130_fd_sc_hd__mux2_2
X_8374_ _8379_/B _8374_/B _8374_/C VGND VGND VPWR VPWR _8374_/Y sky130_fd_sc_hd__nand3_2
X_5586_ _5443_/X _5446_/X _8175_/A VGND VGND VPWR VPWR _6711_/C sky130_fd_sc_hd__a21o_2
XFILLER_129_591 VGND VGND VPWR VPWR sky130_fd_sc_hd__decap_3
XPHY_EDGE_ROW_107_Left_238 VGND VGND VPWR VPWR sky130_fd_sc_hd__decap_3
XFILLER_117_753 VGND VGND VPWR VPWR sky130_fd_sc_hd__decap_3
X_7325_ _7325_/A _7325_/B VGND VGND VPWR VPWR _7443_/A sky130_fd_sc_hd__xnor2_2
X_4537_ _4537_/A VGND VGND VPWR VPWR _9021_/D sky130_fd_sc_hd__buf_1
XFILLER_117_36 VGND VGND VPWR VPWR sky130_fd_sc_hd__decap_3
X_7256_ _7256_/A _7256_/B VGND VGND VPWR VPWR _7513_/B sky130_fd_sc_hd__and2_2
XFILLER_117_69 VGND VGND VPWR VPWR sky130_fd_sc_hd__decap_3
XFILLER_77_29 VGND VGND VPWR VPWR sky130_fd_sc_hd__decap_3
X_6207_ _6302_/A _6302_/B _8779_/B VGND VGND VPWR VPWR _6703_/A sky130_fd_sc_hd__nor3_4
X_7187_ _7716_/A _7186_/A _7522_/A VGND VGND VPWR VPWR _7187_/X sky130_fd_sc_hd__o21ba_2
XFILLER_98_670 VGND VGND VPWR VPWR sky130_fd_sc_hd__decap_3
XFILLER_58_501 VGND VGND VPWR VPWR sky130_fd_sc_hd__decap_3
X_6138_ _5962_/A _5962_/B _5963_/A VGND VGND VPWR VPWR _6138_/X sky130_fd_sc_hd__o21ba_2
XTAP_TAPCELL_ROW_5_346 VGND VPWR sky130_fd_sc_hd__tapvpwrvgnd_1
Xhold1010 _9266_/Q VGND VGND VPWR VPWR _8877_/A1 sky130_fd_sc_hd__dlygate4sd3_1
XFILLER_58_545 VGND VGND VPWR VPWR sky130_fd_sc_hd__fill_1
XFILLER_100_642 VGND VGND VPWR VPWR sky130_fd_sc_hd__fill_2
Xhold1021 _9049_/Q VGND VGND VPWR VPWR _4629_/A1 sky130_fd_sc_hd__dlygate4sd3_1
Xhold1032 _4729_/X VGND VGND VPWR VPWR _4730_/A sky130_fd_sc_hd__dlygate4sd3_1
XFILLER_58_567 VGND VGND VPWR VPWR sky130_fd_sc_hd__decap_3
XFILLER_100_664 VGND VGND VPWR VPWR sky130_fd_sc_hd__fill_1
Xhold1043 _9300_/Q VGND VGND VPWR VPWR _8949_/A1 sky130_fd_sc_hd__dlygate4sd3_1
XFILLER_18_409 VGND VGND VPWR VPWR sky130_fd_sc_hd__decap_3
X_6069_ _6069_/A _6069_/B VGND VGND VPWR VPWR _6070_/B sky130_fd_sc_hd__xor2_2
Xhold1054 _9299_/Q VGND VGND VPWR VPWR _8946_/A1 sky130_fd_sc_hd__dlygate4sd3_1
XFILLER_73_515 VGND VGND VPWR VPWR sky130_fd_sc_hd__decap_3
XFILLER_58_589 VGND VGND VPWR VPWR sky130_fd_sc_hd__decap_3
XFILLER_46_729 VGND VGND VPWR VPWR sky130_fd_sc_hd__fill_2
XFILLER_45_206 VGND VGND VPWR VPWR sky130_fd_sc_hd__decap_3
Xhold1065 _9054_/Q VGND VGND VPWR VPWR _4640_/A1 sky130_fd_sc_hd__dlygate4sd3_1
Xhold1076 _9291_/Q VGND VGND VPWR VPWR _8930_/A1 sky130_fd_sc_hd__dlygate4sd3_1
XPHY_EDGE_ROW_116_Left_247 VGND VGND VPWR VPWR sky130_fd_sc_hd__decap_3
Xhold1087 _4646_/X VGND VGND VPWR VPWR _4647_/A sky130_fd_sc_hd__dlygate4sd3_1
XFILLER_45_239 VGND VGND VPWR VPWR sky130_fd_sc_hd__decap_3
Xhold1098 _9309_/Q VGND VGND VPWR VPWR _8967_/A1 sky130_fd_sc_hd__dlygate4sd3_1
XFILLER_73_559 VGND VGND VPWR VPWR sky130_fd_sc_hd__fill_1
XFILLER_26_453 VGND VGND VPWR VPWR sky130_fd_sc_hd__decap_3
XFILLER_54_773 VGND VGND VPWR VPWR sky130_fd_sc_hd__decap_3
XFILLER_26_486 VGND VGND VPWR VPWR sky130_fd_sc_hd__fill_2
XFILLER_13_103 VGND VGND VPWR VPWR sky130_fd_sc_hd__decap_3
XTAP_TAPCELL_ROW_24_610 VGND VPWR sky130_fd_sc_hd__tapvpwrvgnd_1
XFILLER_14_637 VGND VGND VPWR VPWR sky130_fd_sc_hd__fill_1
XFILLER_14_659 VGND VGND VPWR VPWR sky130_fd_sc_hd__decap_3
XFILLER_41_445 VGND VGND VPWR VPWR sky130_fd_sc_hd__decap_3
XFILLER_41_456 VGND VGND VPWR VPWR sky130_fd_sc_hd__decap_3
XFILLER_13_169 VGND VGND VPWR VPWR sky130_fd_sc_hd__decap_3
XFILLER_42_32 VGND VGND VPWR VPWR sky130_fd_sc_hd__decap_3
XTAP_TAPCELL_ROW_52_985 VGND VPWR sky130_fd_sc_hd__tapvpwrvgnd_1
XPHY_EDGE_ROW_125_Left_256 VGND VGND VPWR VPWR sky130_fd_sc_hd__decap_3
Xrebuffer440 _5859_/B VGND VGND VPWR VPWR _6053_/B sky130_fd_sc_hd__buf_2
XFILLER_108_720 VGND VGND VPWR VPWR sky130_fd_sc_hd__fill_1
XFILLER_108_731 VGND VGND VPWR VPWR sky130_fd_sc_hd__fill_1
Xrebuffer451 hold1250/X VGND VGND VPWR VPWR _8781_/A2 sky130_fd_sc_hd__buf_2
Xrebuffer462 _7404_/B VGND VGND VPWR VPWR _7330_/A1 sky130_fd_sc_hd__buf_2
Xrebuffer473 _6717_/A VGND VGND VPWR VPWR _6971_/A sky130_fd_sc_hd__buf_2
Xrebuffer484 _5021_/A VGND VGND VPWR VPWR _5850_/A sky130_fd_sc_hd__buf_2
XFILLER_5_346 VGND VGND VPWR VPWR sky130_fd_sc_hd__decap_3
Xrebuffer495 wire158/X VGND VGND VPWR VPWR _7313_/C sky130_fd_sc_hd__buf_2
XTAP_TAPCELL_ROW_114_1815 VGND VPWR sky130_fd_sc_hd__tapvpwrvgnd_1
XTAP_TAPCELL_ROW_114_1826 VGND VPWR sky130_fd_sc_hd__tapvpwrvgnd_1
XFILLER_123_712 VGND VGND VPWR VPWR sky130_fd_sc_hd__decap_3
XFILLER_122_200 VGND VGND VPWR VPWR sky130_fd_sc_hd__decap_3
XFILLER_123_756 VGND VGND VPWR VPWR sky130_fd_sc_hd__decap_3
XFILLER_3_15 VGND VGND VPWR VPWR sky130_fd_sc_hd__decap_3
XFILLER_1_541 VGND VGND VPWR VPWR sky130_fd_sc_hd__decap_3
XFILLER_68_309 VGND VGND VPWR VPWR sky130_fd_sc_hd__decap_3
XFILLER_89_670 VGND VGND VPWR VPWR sky130_fd_sc_hd__fill_2
XFILLER_3_48 VGND VGND VPWR VPWR sky130_fd_sc_hd__decap_3
XFILLER_95_128 VGND VGND VPWR VPWR sky130_fd_sc_hd__decap_3
XFILLER_49_523 VGND VGND VPWR VPWR sky130_fd_sc_hd__decap_3
XFILLER_110_439 VGND VGND VPWR VPWR sky130_fd_sc_hd__decap_3
XFILLER_103_480 VGND VGND VPWR VPWR sky130_fd_sc_hd__fill_2
XFILLER_88_191 VGND VGND VPWR VPWR sky130_fd_sc_hd__fill_2
XFILLER_37_718 VGND VGND VPWR VPWR sky130_fd_sc_hd__fill_1
XFILLER_64_504 VGND VGND VPWR VPWR sky130_fd_sc_hd__decap_3
XFILLER_76_375 VGND VGND VPWR VPWR sky130_fd_sc_hd__decap_3
XFILLER_91_323 VGND VGND VPWR VPWR sky130_fd_sc_hd__decap_3
XFILLER_64_548 VGND VGND VPWR VPWR sky130_fd_sc_hd__fill_1
XFILLER_17_420 VGND VGND VPWR VPWR sky130_fd_sc_hd__fill_1
XFILLER_123_90 VGND VGND VPWR VPWR sky130_fd_sc_hd__decap_3
XTAP_TAPCELL_ROW_125_1966 VGND VPWR sky130_fd_sc_hd__tapvpwrvgnd_1
XFILLER_17_464 VGND VGND VPWR VPWR sky130_fd_sc_hd__fill_2
XFILLER_60_710 VGND VGND VPWR VPWR sky130_fd_sc_hd__decap_3
XFILLER_17_486 VGND VGND VPWR VPWR sky130_fd_sc_hd__fill_2
XFILLER_32_412 VGND VGND VPWR VPWR sky130_fd_sc_hd__decap_3
XFILLER_72_592 VGND VGND VPWR VPWR sky130_fd_sc_hd__decap_3
XFILLER_44_283 VGND VGND VPWR VPWR sky130_fd_sc_hd__decap_3
XFILLER_60_754 VGND VGND VPWR VPWR sky130_fd_sc_hd__fill_2
XFILLER_32_445 VGND VGND VPWR VPWR sky130_fd_sc_hd__decap_3
XFILLER_60_776 VGND VGND VPWR VPWR sky130_fd_sc_hd__fill_1
XFILLER_32_489 VGND VGND VPWR VPWR sky130_fd_sc_hd__fill_1
XFILLER_13_670 VGND VGND VPWR VPWR sky130_fd_sc_hd__fill_2
XFILLER_12_191 VGND VGND VPWR VPWR sky130_fd_sc_hd__decap_3
XFILLER_8_162 VGND VGND VPWR VPWR sky130_fd_sc_hd__decap_3
X_5440_ _5440_/A _5440_/B VGND VGND VPWR VPWR _5440_/X sky130_fd_sc_hd__or2_2
XTAP_TAPCELL_ROW_76_1309 VGND VPWR sky130_fd_sc_hd__tapvpwrvgnd_1
XFILLER_8_184 VGND VGND VPWR VPWR sky130_fd_sc_hd__fill_1
XFILLER_66_3 VGND VGND VPWR VPWR sky130_fd_sc_hd__decap_3
X_5371_ _9308_/Q _5880_/B _5875_/C VGND VGND VPWR VPWR _5371_/X sky130_fd_sc_hd__and3_2
XFILLER_114_701 VGND VGND VPWR VPWR sky130_fd_sc_hd__decap_3
XFILLER_126_561 VGND VGND VPWR VPWR sky130_fd_sc_hd__decap_3
X_7110_ _7110_/A _7110_/B VGND VGND VPWR VPWR _7110_/X sky130_fd_sc_hd__and2_2
X_8090_ _8090_/A _8090_/B VGND VGND VPWR VPWR _8091_/B sky130_fd_sc_hd__xnor2_2
XFILLER_113_222 VGND VGND VPWR VPWR sky130_fd_sc_hd__fill_2
X_7041_ _6951_/X _7040_/Y _7038_/A VGND VGND VPWR VPWR _7041_/X sky130_fd_sc_hd__o21a_2
XFILLER_86_106 VGND VGND VPWR VPWR sky130_fd_sc_hd__decap_3
XFILLER_86_139 VGND VGND VPWR VPWR sky130_fd_sc_hd__fill_1
XTAP_TAPCELL_ROW_2_305 VGND VPWR sky130_fd_sc_hd__tapvpwrvgnd_1
XFILLER_95_673 VGND VGND VPWR VPWR sky130_fd_sc_hd__decap_3
XFILLER_28_729 VGND VGND VPWR VPWR sky130_fd_sc_hd__decap_3
XFILLER_27_206 VGND VGND VPWR VPWR sky130_fd_sc_hd__decap_3
X_8992_ _8992_/A VGND VGND VPWR VPWR _9336_/D sky130_fd_sc_hd__buf_1
XFILLER_82_312 VGND VGND VPWR VPWR sky130_fd_sc_hd__fill_2
XFILLER_67_386 VGND VGND VPWR VPWR sky130_fd_sc_hd__fill_1
XFILLER_55_537 VGND VGND VPWR VPWR sky130_fd_sc_hd__decap_3
XFILLER_82_334 VGND VGND VPWR VPWR sky130_fd_sc_hd__decap_3
X_7943_ _7943_/A _7943_/B VGND VGND VPWR VPWR _7949_/A sky130_fd_sc_hd__xnor2_2
X_7874_ _7722_/A _7721_/B _7721_/A VGND VGND VPWR VPWR _7874_/X sky130_fd_sc_hd__o21ba_2
XFILLER_23_412 VGND VGND VPWR VPWR sky130_fd_sc_hd__decap_3
X_6825_ _6825_/A _6825_/B VGND VGND VPWR VPWR _6871_/B sky130_fd_sc_hd__nor2_2
XFILLER_51_754 VGND VGND VPWR VPWR sky130_fd_sc_hd__fill_2
XFILLER_50_220 VGND VGND VPWR VPWR sky130_fd_sc_hd__fill_1
XFILLER_50_253 VGND VGND VPWR VPWR sky130_fd_sc_hd__decap_3
XFILLER_23_478 VGND VGND VPWR VPWR sky130_fd_sc_hd__decap_3
X_6756_ _9033_/Q _6756_/B _6756_/C VGND VGND VPWR VPWR _6756_/X sky130_fd_sc_hd__and3_2
XFILLER_10_117 VGND VGND VPWR VPWR sky130_fd_sc_hd__decap_3
XFILLER_50_297 VGND VGND VPWR VPWR sky130_fd_sc_hd__decap_3
X_5707_ _5707_/A _5707_/B VGND VGND VPWR VPWR _5707_/Y sky130_fd_sc_hd__nor2_2
X_6687_ _6616_/A _6616_/B _6687_/B1 VGND VGND VPWR VPWR _6939_/C sky130_fd_sc_hd__a21o_2
XFILLER_12_24 VGND VGND VPWR VPWR sky130_fd_sc_hd__decap_3
XFILLER_12_35 VGND VGND VPWR VPWR sky130_fd_sc_hd__decap_3
XFILLER_109_539 VGND VGND VPWR VPWR sky130_fd_sc_hd__decap_3
X_8426_ _8780_/C _6756_/B _8425_/X _7472_/A VGND VGND VPWR VPWR _8427_/C sky130_fd_sc_hd__a22o_2
X_5638_ _5638_/A _5638_/B VGND VGND VPWR VPWR _5642_/A sky130_fd_sc_hd__or2_4
XFILLER_128_24 VGND VGND VPWR VPWR sky130_fd_sc_hd__decap_3
XFILLER_128_35 VGND VGND VPWR VPWR sky130_fd_sc_hd__decap_3
X_5569_ _5481_/A _5631_/B _5482_/A VGND VGND VPWR VPWR _5569_/X sky130_fd_sc_hd__o21a_2
X_8357_ _9219_/Q _8445_/A _8441_/B wire71/X _8356_/X VGND VGND VPWR VPWR _8357_/X
+ sky130_fd_sc_hd__o41a_2
XFILLER_128_68 VGND VGND VPWR VPWR sky130_fd_sc_hd__decap_3
XFILLER_117_561 VGND VGND VPWR VPWR sky130_fd_sc_hd__decap_3
XFILLER_104_200 VGND VGND VPWR VPWR sky130_fd_sc_hd__decap_3
X_7308_ _7307_/B _7307_/C _7307_/A VGND VGND VPWR VPWR _7468_/B sky130_fd_sc_hd__a21oi_2
XFILLER_2_327 VGND VGND VPWR VPWR sky130_fd_sc_hd__decap_3
X_8288_ _8288_/A _8288_/B VGND VGND VPWR VPWR _8288_/Y sky130_fd_sc_hd__xnor2_2
XFILLER_2_349 VGND VGND VPWR VPWR sky130_fd_sc_hd__fill_2
XFILLER_120_704 VGND VGND VPWR VPWR sky130_fd_sc_hd__decap_3
X_7239_ _7659_/A _7239_/B VGND VGND VPWR VPWR _7240_/B sky130_fd_sc_hd__xnor2_2
XFILLER_104_277 VGND VGND VPWR VPWR sky130_fd_sc_hd__fill_2
XTAP_TAPCELL_ROW_129_2022 VGND VPWR sky130_fd_sc_hd__tapvpwrvgnd_1
XFILLER_120_737 VGND VGND VPWR VPWR sky130_fd_sc_hd__decap_3
XFILLER_86_640 VGND VGND VPWR VPWR sky130_fd_sc_hd__decap_3
XFILLER_86_651 VGND VGND VPWR VPWR sky130_fd_sc_hd__decap_3
XFILLER_58_353 VGND VGND VPWR VPWR sky130_fd_sc_hd__decap_3
XFILLER_19_707 VGND VGND VPWR VPWR sky130_fd_sc_hd__decap_3
XFILLER_100_461 VGND VGND VPWR VPWR sky130_fd_sc_hd__decap_3
XFILLER_46_515 VGND VGND VPWR VPWR sky130_fd_sc_hd__decap_3
XFILLER_19_729 VGND VGND VPWR VPWR sky130_fd_sc_hd__decap_3
XFILLER_18_206 VGND VGND VPWR VPWR sky130_fd_sc_hd__decap_3
XFILLER_86_684 VGND VGND VPWR VPWR sky130_fd_sc_hd__decap_3
XFILLER_100_472 VGND VGND VPWR VPWR sky130_fd_sc_hd__decap_3
XFILLER_58_386 VGND VGND VPWR VPWR sky130_fd_sc_hd__decap_3
XFILLER_100_483 VGND VGND VPWR VPWR sky130_fd_sc_hd__decap_3
XFILLER_37_76 VGND VGND VPWR VPWR sky130_fd_sc_hd__decap_3
XFILLER_37_87 VGND VGND VPWR VPWR sky130_fd_sc_hd__decap_3
XFILLER_27_740 VGND VGND VPWR VPWR sky130_fd_sc_hd__decap_3
XFILLER_73_378 VGND VGND VPWR VPWR sky130_fd_sc_hd__decap_3
XFILLER_61_529 VGND VGND VPWR VPWR sky130_fd_sc_hd__decap_3
XFILLER_27_773 VGND VGND VPWR VPWR sky130_fd_sc_hd__decap_3
XFILLER_26_250 VGND VGND VPWR VPWR sky130_fd_sc_hd__fill_2
XFILLER_54_592 VGND VGND VPWR VPWR sky130_fd_sc_hd__fill_2
XFILLER_53_42 VGND VGND VPWR VPWR sky130_fd_sc_hd__decap_3
XFILLER_41_220 VGND VGND VPWR VPWR sky130_fd_sc_hd__decap_3
XFILLER_42_754 VGND VGND VPWR VPWR sky130_fd_sc_hd__fill_2
XFILLER_14_456 VGND VGND VPWR VPWR sky130_fd_sc_hd__decap_3
XFILLER_53_75 VGND VGND VPWR VPWR sky130_fd_sc_hd__decap_3
XFILLER_41_253 VGND VGND VPWR VPWR sky130_fd_sc_hd__decap_3
XTAP_TAPCELL_ROW_120_1896 VGND VPWR sky130_fd_sc_hd__tapvpwrvgnd_1
XFILLER_6_600 VGND VGND VPWR VPWR sky130_fd_sc_hd__fill_2
XFILLER_127_325 VGND VGND VPWR VPWR sky130_fd_sc_hd__decap_3
XFILLER_5_110 VGND VGND VPWR VPWR sky130_fd_sc_hd__fill_2
XFILLER_10_695 VGND VGND VPWR VPWR sky130_fd_sc_hd__decap_3
XFILLER_127_358 VGND VGND VPWR VPWR sky130_fd_sc_hd__decap_3
XFILLER_6_666 VGND VGND VPWR VPWR sky130_fd_sc_hd__decap_3
XFILLER_5_143 VGND VGND VPWR VPWR sky130_fd_sc_hd__decap_3
XFILLER_52_9 VGND VGND VPWR VPWR sky130_fd_sc_hd__decap_3
XFILLER_6_699 VGND VGND VPWR VPWR sky130_fd_sc_hd__fill_1
XFILLER_123_520 VGND VGND VPWR VPWR sky130_fd_sc_hd__decap_3
XFILLER_69_629 VGND VGND VPWR VPWR sky130_fd_sc_hd__decap_3
XFILLER_123_575 VGND VGND VPWR VPWR sky130_fd_sc_hd__decap_3
XFILLER_111_715 VGND VGND VPWR VPWR sky130_fd_sc_hd__decap_3
XTAP_TAPCELL_ROW_71_1239 VGND VPWR sky130_fd_sc_hd__tapvpwrvgnd_1
XFILLER_96_415 VGND VGND VPWR VPWR sky130_fd_sc_hd__decap_3
XFILLER_78_83 VGND VGND VPWR VPWR sky130_fd_sc_hd__fill_1
XFILLER_123_597 VGND VGND VPWR VPWR sky130_fd_sc_hd__decap_3
XFILLER_110_214 VGND VGND VPWR VPWR sky130_fd_sc_hd__decap_3
XFILLER_49_331 VGND VGND VPWR VPWR sky130_fd_sc_hd__decap_3
XFILLER_1_393 VGND VGND VPWR VPWR sky130_fd_sc_hd__decap_3
XFILLER_49_342 VGND VGND VPWR VPWR sky130_fd_sc_hd__decap_3
XFILLER_83_109 VGND VGND VPWR VPWR sky130_fd_sc_hd__decap_3
XFILLER_92_610 VGND VGND VPWR VPWR sky130_fd_sc_hd__decap_3
XFILLER_49_386 VGND VGND VPWR VPWR sky130_fd_sc_hd__decap_3
XFILLER_92_654 VGND VGND VPWR VPWR sky130_fd_sc_hd__decap_3
XFILLER_91_131 VGND VGND VPWR VPWR sky130_fd_sc_hd__decap_3
XFILLER_37_559 VGND VGND VPWR VPWR sky130_fd_sc_hd__fill_1
XFILLER_18_740 VGND VGND VPWR VPWR sky130_fd_sc_hd__decap_3
XFILLER_52_518 VGND VGND VPWR VPWR sky130_fd_sc_hd__decap_3
X_4940_ _4940_/A _4940_/B _4940_/C _4940_/D VGND VGND VPWR VPWR _4974_/A sky130_fd_sc_hd__nor4_2
XFILLER_92_687 VGND VGND VPWR VPWR sky130_fd_sc_hd__decap_3
XFILLER_52_529 VGND VGND VPWR VPWR sky130_fd_sc_hd__decap_3
XFILLER_33_710 VGND VGND VPWR VPWR sky130_fd_sc_hd__decap_3
XFILLER_17_261 VGND VGND VPWR VPWR sky130_fd_sc_hd__decap_3
XTAP_TAPCELL_ROW_35_749 VGND VPWR sky130_fd_sc_hd__tapvpwrvgnd_1
XFILLER_33_732 VGND VGND VPWR VPWR sky130_fd_sc_hd__decap_3
XFILLER_32_220 VGND VGND VPWR VPWR sky130_fd_sc_hd__decap_3
X_4871_ _9231_/Q _9230_/Q _4869_/X _4870_/Y VGND VGND VPWR VPWR _4907_/B sky130_fd_sc_hd__o31a_2
XFILLER_33_776 VGND VGND VPWR VPWR sky130_fd_sc_hd__fill_1
X_6610_ _9032_/Q _6608_/C _6756_/C _5062_/X _9268_/Q VGND VGND VPWR VPWR _6612_/C
+ sky130_fd_sc_hd__a32o_2
X_7590_ _7590_/A _7763_/A _7590_/C VGND VGND VPWR VPWR _7590_/X sky130_fd_sc_hd__or3_2
XTAP_TAPCELL_ROW_15_484 VGND VPWR sky130_fd_sc_hd__tapvpwrvgnd_1
XFILLER_32_297 VGND VGND VPWR VPWR sky130_fd_sc_hd__fill_2
X_6541_ _6526_/A _6539_/Y _6540_/Y VGND VGND VPWR VPWR _6643_/A sky130_fd_sc_hd__a21oi_2
X_6472_ _6788_/A _6472_/B VGND VGND VPWR VPWR _6473_/B sky130_fd_sc_hd__nand2_2
X_9260_ _9308_/CLK _9260_/D load_slew370/X VGND VGND VPWR VPWR _9260_/Q sky130_fd_sc_hd__dfrtp_2
XFILLER_9_482 VGND VGND VPWR VPWR sky130_fd_sc_hd__decap_3
XFILLER_118_347 VGND VGND VPWR VPWR sky130_fd_sc_hd__decap_3
X_5423_ _5137_/X _5138_/X _7799_/A VGND VGND VPWR VPWR _5425_/A sky130_fd_sc_hd__a21oi_2
X_8211_ _8211_/A VGND VGND VPWR VPWR _8211_/X sky130_fd_sc_hd__buf_8
X_9191_ _9223_/CLK _9191_/D load_slew416/X VGND VGND VPWR VPWR _9191_/Q sky130_fd_sc_hd__dfrtp_2
XFILLER_114_520 VGND VGND VPWR VPWR sky130_fd_sc_hd__decap_3
X_5354_ _6550_/B VGND VGND VPWR VPWR _7805_/A sky130_fd_sc_hd__clkbuf_4
X_8142_ _9219_/Q _8257_/B VGND VGND VPWR VPWR _8271_/D sky130_fd_sc_hd__nand2_2
XFILLER_99_231 VGND VGND VPWR VPWR sky130_fd_sc_hd__decap_3
XFILLER_126_391 VGND VGND VPWR VPWR sky130_fd_sc_hd__decap_3
XFILLER_114_553 VGND VGND VPWR VPWR sky130_fd_sc_hd__decap_3
X_8073_ _8073_/A _8073_/B VGND VGND VPWR VPWR _8074_/B sky130_fd_sc_hd__xnor2_2
XFILLER_99_264 VGND VGND VPWR VPWR sky130_fd_sc_hd__decap_3
XFILLER_87_404 VGND VGND VPWR VPWR sky130_fd_sc_hd__decap_3
X_5285_ _5348_/S _8780_/D _4980_/X VGND VGND VPWR VPWR _5285_/X sky130_fd_sc_hd__o21a_2
XFILLER_102_737 VGND VGND VPWR VPWR sky130_fd_sc_hd__fill_1
X_7024_ _7277_/B _7024_/B VGND VGND VPWR VPWR _7025_/B sky130_fd_sc_hd__xnor2_2
XFILLER_4_80 VGND VGND VPWR VPWR sky130_fd_sc_hd__decap_3
XFILLER_4_91 VGND VGND VPWR VPWR sky130_fd_sc_hd__decap_3
XFILLER_114_15 VGND VGND VPWR VPWR sky130_fd_sc_hd__decap_3
XFILLER_68_673 VGND VGND VPWR VPWR sky130_fd_sc_hd__decap_3
XFILLER_114_59 VGND VGND VPWR VPWR sky130_fd_sc_hd__decap_3
XFILLER_55_334 VGND VGND VPWR VPWR sky130_fd_sc_hd__fill_2
X_8975_ _8975_/A VGND VGND VPWR VPWR _9328_/D sky130_fd_sc_hd__buf_1
XFILLER_82_131 VGND VGND VPWR VPWR sky130_fd_sc_hd__decap_3
XFILLER_55_367 VGND VGND VPWR VPWR sky130_fd_sc_hd__decap_3
X_7926_ _9218_/Q _7926_/B VGND VGND VPWR VPWR _7927_/B sky130_fd_sc_hd__xnor2_2
XFILLER_82_186 VGND VGND VPWR VPWR sky130_fd_sc_hd__fill_2
XFILLER_36_581 VGND VGND VPWR VPWR sky130_fd_sc_hd__decap_3
XFILLER_82_197 VGND VGND VPWR VPWR sky130_fd_sc_hd__fill_2
XFILLER_24_732 VGND VGND VPWR VPWR sky130_fd_sc_hd__decap_3
XFILLER_130_47 VGND VGND VPWR VPWR sky130_fd_sc_hd__decap_3
X_7857_ _7857_/A _7857_/B VGND VGND VPWR VPWR _7857_/X sky130_fd_sc_hd__or2_2
XFILLER_23_231 VGND VGND VPWR VPWR sky130_fd_sc_hd__decap_3
XFILLER_130_69 VGND VGND VPWR VPWR sky130_fd_sc_hd__decap_3
X_6808_ _5320_/Y _6807_/X _6808_/S VGND VGND VPWR VPWR _6809_/B sky130_fd_sc_hd__mux2_2
XFILLER_23_12 VGND VGND VPWR VPWR sky130_fd_sc_hd__decap_3
XFILLER_51_584 VGND VGND VPWR VPWR sky130_fd_sc_hd__decap_3
X_7788_ _7614_/A _7786_/X _7787_/X VGND VGND VPWR VPWR _7789_/B sky130_fd_sc_hd__o21a_2
XFILLER_23_297 VGND VGND VPWR VPWR sky130_fd_sc_hd__decap_3
XFILLER_7_408 VGND VGND VPWR VPWR sky130_fd_sc_hd__decap_3
X_6739_ _6739_/A _8161_/B VGND VGND VPWR VPWR _6739_/Y sky130_fd_sc_hd__nand2_2
XFILLER_109_358 VGND VGND VPWR VPWR sky130_fd_sc_hd__decap_3
X_8409_ _8408_/A _8408_/B _8408_/C _8408_/D VGND VGND VPWR VPWR _8409_/X sky130_fd_sc_hd__o22a_2
XFILLER_105_520 VGND VGND VPWR VPWR sky130_fd_sc_hd__decap_3
XFILLER_3_647 VGND VGND VPWR VPWR sky130_fd_sc_hd__decap_3
XFILLER_2_124 VGND VGND VPWR VPWR sky130_fd_sc_hd__decap_3
XFILLER_117_391 VGND VGND VPWR VPWR sky130_fd_sc_hd__fill_1
XTAP_TAPCELL_ROW_57_1050 VGND VPWR sky130_fd_sc_hd__tapvpwrvgnd_1
XFILLER_120_501 VGND VGND VPWR VPWR sky130_fd_sc_hd__fill_1
XFILLER_120_523 VGND VGND VPWR VPWR sky130_fd_sc_hd__decap_3
XFILLER_120_556 VGND VGND VPWR VPWR sky130_fd_sc_hd__decap_3
XFILLER_48_53 VGND VGND VPWR VPWR sky130_fd_sc_hd__decap_3
XFILLER_120_567 VGND VGND VPWR VPWR sky130_fd_sc_hd__decap_3
XFILLER_59_673 VGND VGND VPWR VPWR sky130_fd_sc_hd__decap_3
XFILLER_120_589 VGND VGND VPWR VPWR sky130_fd_sc_hd__decap_3
XFILLER_74_610 VGND VGND VPWR VPWR sky130_fd_sc_hd__decap_3
XFILLER_48_97 VGND VGND VPWR VPWR sky130_fd_sc_hd__decap_3
XFILLER_86_492 VGND VGND VPWR VPWR sky130_fd_sc_hd__decap_3
XFILLER_19_537 VGND VGND VPWR VPWR sky130_fd_sc_hd__fill_1
XFILLER_46_334 VGND VGND VPWR VPWR sky130_fd_sc_hd__decap_3
XFILLER_0_27 VGND VGND VPWR VPWR sky130_fd_sc_hd__fill_1
XTAP_TAPCELL_ROW_109_1747 VGND VPWR sky130_fd_sc_hd__tapvpwrvgnd_1
XFILLER_58_194 VGND VGND VPWR VPWR sky130_fd_sc_hd__fill_2
XFILLER_0_38 VGND VGND VPWR VPWR sky130_fd_sc_hd__decap_3
XFILLER_100_291 VGND VGND VPWR VPWR sky130_fd_sc_hd__decap_3
XTAP_TAPCELL_ROW_109_1758 VGND VPWR sky130_fd_sc_hd__tapvpwrvgnd_1
XFILLER_46_356 VGND VGND VPWR VPWR sky130_fd_sc_hd__fill_1
XFILLER_74_698 VGND VGND VPWR VPWR sky130_fd_sc_hd__fill_2
XFILLER_27_570 VGND VGND VPWR VPWR sky130_fd_sc_hd__decap_3
XFILLER_15_721 VGND VGND VPWR VPWR sky130_fd_sc_hd__decap_3
XTAP_TAPCELL_ROW_122_1925 VGND VPWR sky130_fd_sc_hd__tapvpwrvgnd_1
XFILLER_64_74 VGND VGND VPWR VPWR sky130_fd_sc_hd__fill_2
XFILLER_61_337 VGND VGND VPWR VPWR sky130_fd_sc_hd__decap_3
XFILLER_15_732 VGND VGND VPWR VPWR sky130_fd_sc_hd__decap_3
XFILLER_15_765 VGND VGND VPWR VPWR sky130_fd_sc_hd__decap_3
XFILLER_14_242 VGND VGND VPWR VPWR sky130_fd_sc_hd__fill_1
XTAP_TAPCELL_ROW_32_708 VGND VPWR sky130_fd_sc_hd__tapvpwrvgnd_1
XTAP_TAPCELL_ROW_32_719 VGND VPWR sky130_fd_sc_hd__tapvpwrvgnd_1
XFILLER_42_562 VGND VGND VPWR VPWR sky130_fd_sc_hd__fill_1
XFILLER_14_253 VGND VGND VPWR VPWR sky130_fd_sc_hd__fill_1
XFILLER_9_36 VGND VGND VPWR VPWR sky130_fd_sc_hd__decap_3
XFILLER_30_713 VGND VGND VPWR VPWR sky130_fd_sc_hd__decap_3
XFILLER_42_584 VGND VGND VPWR VPWR sky130_fd_sc_hd__decap_3
XFILLER_14_275 VGND VGND VPWR VPWR sky130_fd_sc_hd__decap_3
XFILLER_42_595 VGND VGND VPWR VPWR sky130_fd_sc_hd__decap_3
XFILLER_120_80 VGND VGND VPWR VPWR sky130_fd_sc_hd__decap_3
XFILLER_120_91 VGND VGND VPWR VPWR sky130_fd_sc_hd__decap_3
XFILLER_30_757 VGND VGND VPWR VPWR sky130_fd_sc_hd__decap_3
XFILLER_128_601 VGND VGND VPWR VPWR sky130_fd_sc_hd__decap_3
XTAP_TAPCELL_ROW_12_443 VGND VPWR sky130_fd_sc_hd__tapvpwrvgnd_1
XFILLER_80_73 VGND VGND VPWR VPWR sky130_fd_sc_hd__decap_3
XFILLER_128_634 VGND VGND VPWR VPWR sky130_fd_sc_hd__decap_3
XFILLER_127_111 VGND VGND VPWR VPWR sky130_fd_sc_hd__fill_1
XFILLER_128_645 VGND VGND VPWR VPWR sky130_fd_sc_hd__decap_3
XFILLER_127_122 VGND VGND VPWR VPWR sky130_fd_sc_hd__decap_3
XFILLER_128_678 VGND VGND VPWR VPWR sky130_fd_sc_hd__decap_3
XFILLER_10_492 VGND VGND VPWR VPWR sky130_fd_sc_hd__decap_3
Xhold909 _4564_/X VGND VGND VPWR VPWR _4565_/A sky130_fd_sc_hd__dlygate4sd3_1
XFILLER_127_155 VGND VGND VPWR VPWR sky130_fd_sc_hd__decap_3
XFILLER_50_6 VGND VGND VPWR VPWR sky130_fd_sc_hd__decap_3
XFILLER_127_199 VGND VGND VPWR VPWR sky130_fd_sc_hd__decap_3
XFILLER_108_391 VGND VGND VPWR VPWR sky130_fd_sc_hd__decap_3
XFILLER_130_309 VGND VGND VPWR VPWR sky130_fd_sc_hd__decap_3
XFILLER_111_501 VGND VGND VPWR VPWR sky130_fd_sc_hd__decap_3
XFILLER_123_361 VGND VGND VPWR VPWR sky130_fd_sc_hd__decap_3
XFILLER_97_746 VGND VGND VPWR VPWR sky130_fd_sc_hd__decap_3
XFILLER_69_437 VGND VGND VPWR VPWR sky130_fd_sc_hd__decap_3
XFILLER_111_523 VGND VGND VPWR VPWR sky130_fd_sc_hd__fill_2
X_5070_ _9336_/Q _5002_/X _5069_/X _5262_/B VGND VGND VPWR VPWR _5071_/C sky130_fd_sc_hd__a22o_2
XFILLER_69_459 VGND VGND VPWR VPWR sky130_fd_sc_hd__fill_2
XFILLER_96_256 VGND VGND VPWR VPWR sky130_fd_sc_hd__decap_3
XFILLER_29_3 VGND VGND VPWR VPWR sky130_fd_sc_hd__decap_3
XFILLER_77_470 VGND VGND VPWR VPWR sky130_fd_sc_hd__decap_3
XFILLER_65_632 VGND VGND VPWR VPWR sky130_fd_sc_hd__decap_3
XFILLER_49_183 VGND VGND VPWR VPWR sky130_fd_sc_hd__fill_2
XFILLER_37_334 VGND VGND VPWR VPWR sky130_fd_sc_hd__fill_2
XFILLER_92_440 VGND VGND VPWR VPWR sky130_fd_sc_hd__fill_2
XFILLER_65_665 VGND VGND VPWR VPWR sky130_fd_sc_hd__decap_3
XFILLER_65_676 VGND VGND VPWR VPWR sky130_fd_sc_hd__decap_3
XTAP_TAPCELL_ROW_84_1419 VGND VPWR sky130_fd_sc_hd__tapvpwrvgnd_1
XFILLER_52_304 VGND VGND VPWR VPWR sky130_fd_sc_hd__fill_1
X_8760_ _8760_/A _8760_/B VGND VGND VPWR VPWR _8761_/B sky130_fd_sc_hd__xnor2_2
XFILLER_80_624 VGND VGND VPWR VPWR sky130_fd_sc_hd__decap_3
XFILLER_65_698 VGND VGND VPWR VPWR sky130_fd_sc_hd__decap_3
XFILLER_64_175 VGND VGND VPWR VPWR sky130_fd_sc_hd__decap_3
X_5972_ _5822_/B _5821_/A _5971_/X VGND VGND VPWR VPWR _5972_/X sky130_fd_sc_hd__a21o_2
XFILLER_18_592 VGND VGND VPWR VPWR sky130_fd_sc_hd__decap_3
X_7711_ _7688_/A _7711_/B VGND VGND VPWR VPWR _7711_/X sky130_fd_sc_hd__and2b_2
XFILLER_80_657 VGND VGND VPWR VPWR sky130_fd_sc_hd__decap_3
X_4923_ _9066_/Q _6757_/B _5262_/B VGND VGND VPWR VPWR _4940_/A sky130_fd_sc_hd__and3_2
X_8691_ _8656_/A _8690_/Y _9229_/Q VGND VGND VPWR VPWR _8691_/X sky130_fd_sc_hd__a21o_2
XFILLER_21_702 VGND VGND VPWR VPWR sky130_fd_sc_hd__decap_3
XFILLER_33_573 VGND VGND VPWR VPWR sky130_fd_sc_hd__decap_3
X_7642_ _7924_/B VGND VGND VPWR VPWR _7836_/B sky130_fd_sc_hd__clkbuf_1
X_4854_ _4854_/A VGND VGND VPWR VPWR _9171_/D sky130_fd_sc_hd__buf_1
XFILLER_21_735 VGND VGND VPWR VPWR sky130_fd_sc_hd__decap_3
XFILLER_21_768 VGND VGND VPWR VPWR sky130_fd_sc_hd__decap_3
X_4785_ _4785_/A VGND VGND VPWR VPWR _9138_/D sky130_fd_sc_hd__buf_1
X_7573_ _7449_/A _7573_/B _7799_/A _8410_/S VGND VGND VPWR VPWR _7573_/X sky130_fd_sc_hd__and4b_2
XFILLER_20_256 VGND VGND VPWR VPWR sky130_fd_sc_hd__decap_3
XFILLER_118_100 VGND VGND VPWR VPWR sky130_fd_sc_hd__decap_3
X_9312_ _9344_/CLK _9312_/D fanout379/X VGND VGND VPWR VPWR _9312_/Q sky130_fd_sc_hd__dfrtp_2
X_6524_ _6524_/A _6524_/B _6522_/X _6523_/X VGND VGND VPWR VPWR _6524_/X sky130_fd_sc_hd__or4bb_4
XFILLER_119_656 VGND VGND VPWR VPWR sky130_fd_sc_hd__fill_1
XFILLER_109_15 VGND VGND VPWR VPWR sky130_fd_sc_hd__decap_3
XFILLER_118_133 VGND VGND VPWR VPWR sky130_fd_sc_hd__decap_3
X_9243_ clkload4/A _9243_/D wire372/X VGND VGND VPWR VPWR _9243_/Q sky130_fd_sc_hd__dfrtp_2
XFILLER_109_48 VGND VGND VPWR VPWR sky130_fd_sc_hd__decap_3
X_6455_ _6455_/A _6455_/B VGND VGND VPWR VPWR _6509_/B sky130_fd_sc_hd__nand2_2
XFILLER_106_328 VGND VGND VPWR VPWR sky130_fd_sc_hd__decap_3
XTAP_TAPCELL_ROW_95_1559 VGND VPWR sky130_fd_sc_hd__tapvpwrvgnd_1
X_5406_ _9200_/Q _5410_/A VGND VGND VPWR VPWR _5406_/X sky130_fd_sc_hd__or2_2
X_6386_ _6524_/B _6386_/B VGND VGND VPWR VPWR _6390_/A sky130_fd_sc_hd__and2b_2
X_9174_ _9346_/CLK _9174_/D fanout403/X VGND VGND VPWR VPWR _9174_/Q sky130_fd_sc_hd__dfrtp_2
XFILLER_0_617 VGND VGND VPWR VPWR sky130_fd_sc_hd__decap_3
X_5337_ _5337_/A _5337_/B VGND VGND VPWR VPWR _5337_/Y sky130_fd_sc_hd__nor2_2
X_8125_ _8080_/X _8123_/X _8350_/B VGND VGND VPWR VPWR _8126_/B sky130_fd_sc_hd__a21o_2
XFILLER_88_735 VGND VGND VPWR VPWR sky130_fd_sc_hd__decap_3
XFILLER_87_212 VGND VGND VPWR VPWR sky130_fd_sc_hd__decap_3
XFILLER_125_36 VGND VGND VPWR VPWR sky130_fd_sc_hd__decap_3
XFILLER_114_383 VGND VGND VPWR VPWR sky130_fd_sc_hd__decap_3
XFILLER_88_757 VGND VGND VPWR VPWR sky130_fd_sc_hd__fill_2
X_5268_ _9023_/Q _6608_/C _6756_/C _5265_/X _5267_/X VGND VGND VPWR VPWR _5271_/C
+ sky130_fd_sc_hd__a311o_2
X_8056_ _8315_/A _8312_/A VGND VGND VPWR VPWR _8057_/A sky130_fd_sc_hd__nand2_2
XFILLER_125_69 VGND VGND VPWR VPWR sky130_fd_sc_hd__decap_3
XFILLER_102_578 VGND VGND VPWR VPWR sky130_fd_sc_hd__decap_3
XFILLER_102_589 VGND VGND VPWR VPWR sky130_fd_sc_hd__decap_3
X_7007_ _6690_/A _6690_/B _6691_/A VGND VGND VPWR VPWR _7007_/X sky130_fd_sc_hd__a21bo_2
XFILLER_47_109 VGND VGND VPWR VPWR sky130_fd_sc_hd__decap_3
XFILLER_18_12 VGND VGND VPWR VPWR sky130_fd_sc_hd__decap_3
X_5199_ _8174_/B _5198_/X _8780_/C VGND VGND VPWR VPWR _5199_/X sky130_fd_sc_hd__o21a_2
XFILLER_28_312 VGND VGND VPWR VPWR sky130_fd_sc_hd__decap_3
XFILLER_68_492 VGND VGND VPWR VPWR sky130_fd_sc_hd__decap_3
XFILLER_18_45 VGND VGND VPWR VPWR sky130_fd_sc_hd__decap_3
XFILLER_28_356 VGND VGND VPWR VPWR sky130_fd_sc_hd__decap_3
XFILLER_83_473 VGND VGND VPWR VPWR sky130_fd_sc_hd__decap_3
XFILLER_71_613 VGND VGND VPWR VPWR sky130_fd_sc_hd__decap_3
X_8958_ _8958_/A VGND VGND VPWR VPWR _9320_/D sky130_fd_sc_hd__buf_1
XFILLER_43_337 VGND VGND VPWR VPWR sky130_fd_sc_hd__fill_1
X_7909_ _7908_/X _7824_/A _7916_/B VGND VGND VPWR VPWR _7909_/X sky130_fd_sc_hd__mux2_2
XFILLER_70_145 VGND VGND VPWR VPWR sky130_fd_sc_hd__decap_3
X_8889_ _8889_/A VGND VGND VPWR VPWR _9287_/D sky130_fd_sc_hd__buf_1
XFILLER_70_156 VGND VGND VPWR VPWR sky130_fd_sc_hd__decap_3
XFILLER_12_713 VGND VGND VPWR VPWR sky130_fd_sc_hd__decap_3
XFILLER_34_66 VGND VGND VPWR VPWR sky130_fd_sc_hd__fill_1
XTAP_TAPCELL_ROW_104_1688 VGND VPWR sky130_fd_sc_hd__tapvpwrvgnd_1
XFILLER_12_746 VGND VGND VPWR VPWR sky130_fd_sc_hd__decap_3
XFILLER_12_757 VGND VGND VPWR VPWR sky130_fd_sc_hd__decap_3
XFILLER_8_728 VGND VGND VPWR VPWR sky130_fd_sc_hd__decap_3
XFILLER_11_256 VGND VGND VPWR VPWR sky130_fd_sc_hd__decap_3
XFILLER_109_100 VGND VGND VPWR VPWR sky130_fd_sc_hd__decap_3
XFILLER_11_267 VGND VGND VPWR VPWR sky130_fd_sc_hd__decap_3
XFILLER_109_111 VGND VGND VPWR VPWR sky130_fd_sc_hd__fill_1
XFILLER_109_122 VGND VGND VPWR VPWR sky130_fd_sc_hd__decap_3
Xwire158 _5191_/Y VGND VGND VPWR VPWR wire158/X sky130_fd_sc_hd__buf_6
XFILLER_109_155 VGND VGND VPWR VPWR sky130_fd_sc_hd__decap_3
XFILLER_125_626 VGND VGND VPWR VPWR sky130_fd_sc_hd__fill_2
XFILLER_124_103 VGND VGND VPWR VPWR sky130_fd_sc_hd__decap_3
XFILLER_50_98 VGND VGND VPWR VPWR sky130_fd_sc_hd__decap_3
XFILLER_125_648 VGND VGND VPWR VPWR sky130_fd_sc_hd__fill_2
XFILLER_124_136 VGND VGND VPWR VPWR sky130_fd_sc_hd__decap_3
XFILLER_124_147 VGND VGND VPWR VPWR sky130_fd_sc_hd__decap_3
XFILLER_112_309 VGND VGND VPWR VPWR sky130_fd_sc_hd__decap_3
XFILLER_105_361 VGND VGND VPWR VPWR sky130_fd_sc_hd__fill_1
XFILLER_3_477 VGND VGND VPWR VPWR sky130_fd_sc_hd__fill_2
XFILLER_78_256 VGND VGND VPWR VPWR sky130_fd_sc_hd__decap_3
XFILLER_94_738 VGND VGND VPWR VPWR sky130_fd_sc_hd__decap_3
Xfanout280 input8/X VGND VGND VPWR VPWR _7549_/A sky130_fd_sc_hd__clkdlybuf4s25_1
XFILLER_59_481 VGND VGND VPWR VPWR sky130_fd_sc_hd__decap_3
XFILLER_15_9 VGND VGND VPWR VPWR sky130_fd_sc_hd__decap_3
XFILLER_62_602 VGND VGND VPWR VPWR sky130_fd_sc_hd__decap_3
XFILLER_47_676 VGND VGND VPWR VPWR sky130_fd_sc_hd__decap_3
XFILLER_74_473 VGND VGND VPWR VPWR sky130_fd_sc_hd__decap_3
XTAP_TAPCELL_ROW_17_513 VGND VPWR sky130_fd_sc_hd__tapvpwrvgnd_1
XFILLER_74_495 VGND VGND VPWR VPWR sky130_fd_sc_hd__fill_1
XFILLER_46_197 VGND VGND VPWR VPWR sky130_fd_sc_hd__decap_3
XFILLER_34_359 VGND VGND VPWR VPWR sky130_fd_sc_hd__decap_3
XFILLER_62_679 VGND VGND VPWR VPWR sky130_fd_sc_hd__decap_3
XTAP_TAPCELL_ROW_45_888 VGND VPWR sky130_fd_sc_hd__tapvpwrvgnd_1
XFILLER_98_6 VGND VGND VPWR VPWR sky130_fd_sc_hd__decap_3
XFILLER_15_584 VGND VGND VPWR VPWR sky130_fd_sc_hd__decap_3
XFILLER_30_543 VGND VGND VPWR VPWR sky130_fd_sc_hd__fill_1
X_4570_ _4570_/A VGND VGND VPWR VPWR _9036_/D sky130_fd_sc_hd__buf_1
XFILLER_30_598 VGND VGND VPWR VPWR sky130_fd_sc_hd__fill_2
XFILLER_7_750 VGND VGND VPWR VPWR sky130_fd_sc_hd__decap_3
XFILLER_128_486 VGND VGND VPWR VPWR sky130_fd_sc_hd__decap_3
XFILLER_116_626 VGND VGND VPWR VPWR sky130_fd_sc_hd__decap_3
X_6240_ _6230_/X _6228_/X _6240_/C _6240_/D VGND VGND VPWR VPWR _6354_/A sky130_fd_sc_hd__and4bb_2
XFILLER_115_125 VGND VGND VPWR VPWR sky130_fd_sc_hd__fill_2
XFILLER_115_158 VGND VGND VPWR VPWR sky130_fd_sc_hd__fill_1
X_6171_ _6292_/A _6292_/B _6169_/Y _6170_/X VGND VGND VPWR VPWR _6171_/X sky130_fd_sc_hd__o211a_2
XFILLER_130_106 VGND VGND VPWR VPWR sky130_fd_sc_hd__decap_3
XFILLER_69_201 VGND VGND VPWR VPWR sky130_fd_sc_hd__decap_3
XFILLER_130_128 VGND VGND VPWR VPWR sky130_fd_sc_hd__decap_3
X_5122_ _9273_/Q _5065_/X _5066_/X _9149_/Q VGND VGND VPWR VPWR _5123_/D sky130_fd_sc_hd__a22o_2
XFILLER_69_245 VGND VGND VPWR VPWR sky130_fd_sc_hd__decap_3
XFILLER_97_576 VGND VGND VPWR VPWR sky130_fd_sc_hd__decap_3
XFILLER_85_727 VGND VGND VPWR VPWR sky130_fd_sc_hd__fill_1
X_5053_ _7794_/B _5051_/X _5052_/X _6027_/B VGND VGND VPWR VPWR _5053_/X sky130_fd_sc_hd__a22o_2
XFILLER_85_738 VGND VGND VPWR VPWR sky130_fd_sc_hd__decap_3
XFILLER_84_237 VGND VGND VPWR VPWR sky130_fd_sc_hd__decap_3
XFILLER_38_643 VGND VGND VPWR VPWR sky130_fd_sc_hd__fill_1
XFILLER_37_131 VGND VGND VPWR VPWR sky130_fd_sc_hd__decap_3
XFILLER_38_676 VGND VGND VPWR VPWR sky130_fd_sc_hd__decap_3
XFILLER_37_153 VGND VGND VPWR VPWR sky130_fd_sc_hd__decap_3
X_8812_ _9251_/Q hold770/X _8812_/S VGND VGND VPWR VPWR _8812_/X sky130_fd_sc_hd__mux2_2
XFILLER_80_421 VGND VGND VPWR VPWR sky130_fd_sc_hd__fill_1
XFILLER_65_495 VGND VGND VPWR VPWR sky130_fd_sc_hd__decap_3
XFILLER_37_197 VGND VGND VPWR VPWR sky130_fd_sc_hd__decap_3
XFILLER_25_337 VGND VGND VPWR VPWR sky130_fd_sc_hd__decap_3
XFILLER_111_27 VGND VGND VPWR VPWR sky130_fd_sc_hd__decap_3
XFILLER_53_657 VGND VGND VPWR VPWR sky130_fd_sc_hd__decap_3
X_8743_ _8770_/A _8768_/B VGND VGND VPWR VPWR _8744_/B sky130_fd_sc_hd__xnor2_2
XFILLER_25_359 VGND VGND VPWR VPWR sky130_fd_sc_hd__decap_3
X_5955_ _5221_/A _5954_/Y _5221_/Y _6076_/A VGND VGND VPWR VPWR _5955_/Y sky130_fd_sc_hd__a211oi_2
XFILLER_52_178 VGND VGND VPWR VPWR sky130_fd_sc_hd__fill_2
X_4906_ _4876_/A _4905_/Y _4878_/A hold801/X VGND VGND VPWR VPWR _4906_/X sky130_fd_sc_hd__a2bb2o_2
X_8674_ _8674_/A _8676_/B _8676_/C VGND VGND VPWR VPWR _8674_/X sky130_fd_sc_hd__and3_2
XFILLER_33_370 VGND VGND VPWR VPWR sky130_fd_sc_hd__fill_2
X_5886_ _9344_/Q _6336_/C _6607_/C VGND VGND VPWR VPWR _5886_/X sky130_fd_sc_hd__and3_2
X_7625_ _7568_/A _7624_/C _7624_/A VGND VGND VPWR VPWR _7626_/B sky130_fd_sc_hd__a21oi_2
XFILLER_21_554 VGND VGND VPWR VPWR sky130_fd_sc_hd__decap_3
X_4837_ _4837_/A VGND VGND VPWR VPWR _9163_/D sky130_fd_sc_hd__buf_1
X_7556_ _7556_/A _7556_/B _7556_/C VGND VGND VPWR VPWR _7557_/A sky130_fd_sc_hd__and3_2
X_4768_ _4768_/A VGND VGND VPWR VPWR _9130_/D sky130_fd_sc_hd__buf_1
XFILLER_5_709 VGND VGND VPWR VPWR sky130_fd_sc_hd__decap_3
XFILLER_119_442 VGND VGND VPWR VPWR sky130_fd_sc_hd__decap_3
X_6507_ _6443_/Y _6456_/A _6509_/B VGND VGND VPWR VPWR _6786_/B sky130_fd_sc_hd__o21a_2
XFILLER_107_626 VGND VGND VPWR VPWR sky130_fd_sc_hd__decap_3
X_4699_ _4699_/A VGND VGND VPWR VPWR _9097_/D sky130_fd_sc_hd__buf_1
X_7487_ _7487_/A _7639_/B VGND VGND VPWR VPWR _7487_/Y sky130_fd_sc_hd__nand2_2
XFILLER_20_24 VGND VGND VPWR VPWR sky130_fd_sc_hd__decap_3
X_9226_ _9227_/CLK _9226_/D load_slew416/X VGND VGND VPWR VPWR _9226_/Q sky130_fd_sc_hd__dfrtp_2
X_6438_ _6440_/B _6438_/B VGND VGND VPWR VPWR _6438_/Y sky130_fd_sc_hd__nand2_2
XFILLER_106_147 VGND VGND VPWR VPWR sky130_fd_sc_hd__decap_3
XFILLER_122_607 VGND VGND VPWR VPWR sky130_fd_sc_hd__decap_3
X_9157_ _9313_/CLK _9157_/D fanout387/X VGND VGND VPWR VPWR _9157_/Q sky130_fd_sc_hd__dfrtp_2
XFILLER_0_414 VGND VGND VPWR VPWR sky130_fd_sc_hd__decap_3
X_6369_ _6369_/A _6369_/B VGND VGND VPWR VPWR _6542_/A sky130_fd_sc_hd__and2_2
XFILLER_121_128 VGND VGND VPWR VPWR sky130_fd_sc_hd__decap_3
XFILLER_0_436 VGND VGND VPWR VPWR sky130_fd_sc_hd__decap_3
XFILLER_102_320 VGND VGND VPWR VPWR sky130_fd_sc_hd__fill_1
X_8108_ _8108_/A wire43/X VGND VGND VPWR VPWR _8109_/B sky130_fd_sc_hd__xnor2_2
XFILLER_88_543 VGND VGND VPWR VPWR sky130_fd_sc_hd__fill_1
XFILLER_0_458 VGND VGND VPWR VPWR sky130_fd_sc_hd__decap_3
X_9088_ _9308_/CLK _9088_/D load_slew368/X VGND VGND VPWR VPWR _9088_/Q sky130_fd_sc_hd__dfrtp_2
XFILLER_88_565 VGND VGND VPWR VPWR sky130_fd_sc_hd__decap_3
XFILLER_29_22 VGND VGND VPWR VPWR sky130_fd_sc_hd__decap_3
XFILLER_130_651 VGND VGND VPWR VPWR sky130_fd_sc_hd__decap_3
XFILLER_130_673 VGND VGND VPWR VPWR sky130_fd_sc_hd__decap_3
XFILLER_29_55 VGND VGND VPWR VPWR sky130_fd_sc_hd__fill_1
X_8039_ _8039_/A _8039_/B VGND VGND VPWR VPWR _8040_/B sky130_fd_sc_hd__xnor2_2
XFILLER_29_66 VGND VGND VPWR VPWR sky130_fd_sc_hd__decap_3
XFILLER_29_632 VGND VGND VPWR VPWR sky130_fd_sc_hd__decap_3
XFILLER_75_248 VGND VGND VPWR VPWR sky130_fd_sc_hd__decap_3
XFILLER_91_719 VGND VGND VPWR VPWR sky130_fd_sc_hd__decap_3
XTAP_TAPCELL_ROW_106_1706 VGND VPWR sky130_fd_sc_hd__tapvpwrvgnd_1
XFILLER_84_771 VGND VGND VPWR VPWR sky130_fd_sc_hd__decap_3
XFILLER_44_602 VGND VGND VPWR VPWR sky130_fd_sc_hd__fill_1
XFILLER_29_676 VGND VGND VPWR VPWR sky130_fd_sc_hd__fill_1
XFILLER_28_153 VGND VGND VPWR VPWR sky130_fd_sc_hd__decap_3
XTAP_TAPCELL_ROW_106_1717 VGND VPWR sky130_fd_sc_hd__tapvpwrvgnd_1
XFILLER_45_21 VGND VGND VPWR VPWR sky130_fd_sc_hd__decap_3
XFILLER_16_315 VGND VGND VPWR VPWR sky130_fd_sc_hd__decap_3
XFILLER_83_281 VGND VGND VPWR VPWR sky130_fd_sc_hd__fill_1
XFILLER_28_186 VGND VGND VPWR VPWR sky130_fd_sc_hd__decap_3
XFILLER_43_134 VGND VGND VPWR VPWR sky130_fd_sc_hd__decap_3
XFILLER_45_76 VGND VGND VPWR VPWR sky130_fd_sc_hd__decap_3
XFILLER_45_98 VGND VGND VPWR VPWR sky130_fd_sc_hd__decap_3
XFILLER_43_167 VGND VGND VPWR VPWR sky130_fd_sc_hd__fill_1
XTAP_TAPCELL_ROW_65_1160 VGND VPWR sky130_fd_sc_hd__tapvpwrvgnd_1
XFILLER_43_178 VGND VGND VPWR VPWR sky130_fd_sc_hd__decap_3
XFILLER_101_60 VGND VGND VPWR VPWR sky130_fd_sc_hd__decap_3
XTAP_TAPCELL_ROW_42_847 VGND VPWR sky130_fd_sc_hd__tapvpwrvgnd_1
XFILLER_8_503 VGND VGND VPWR VPWR sky130_fd_sc_hd__fill_1
XFILLER_61_42 VGND VGND VPWR VPWR sky130_fd_sc_hd__decap_3
XFILLER_12_554 VGND VGND VPWR VPWR sky130_fd_sc_hd__decap_3
XFILLER_129_217 VGND VGND VPWR VPWR sky130_fd_sc_hd__decap_3
XFILLER_8_514 VGND VGND VPWR VPWR sky130_fd_sc_hd__decap_3
XFILLER_61_53 VGND VGND VPWR VPWR sky130_fd_sc_hd__decap_3
XFILLER_129_228 VGND VGND VPWR VPWR sky130_fd_sc_hd__decap_3
XFILLER_8_536 VGND VGND VPWR VPWR sky130_fd_sc_hd__decap_3
XFILLER_12_587 VGND VGND VPWR VPWR sky130_fd_sc_hd__fill_1
XTAP_TAPCELL_ROW_22_582 VGND VPWR sky130_fd_sc_hd__tapvpwrvgnd_1
XFILLER_61_97 VGND VGND VPWR VPWR sky130_fd_sc_hd__decap_3
XFILLER_6_15 VGND VGND VPWR VPWR sky130_fd_sc_hd__decap_3
XTAP_TAPCELL_ROW_117_1857 VGND VPWR sky130_fd_sc_hd__tapvpwrvgnd_1
XFILLER_4_731 VGND VGND VPWR VPWR sky130_fd_sc_hd__decap_3
XFILLER_125_478 VGND VGND VPWR VPWR sky130_fd_sc_hd__decap_3
XFILLER_113_629 VGND VGND VPWR VPWR sky130_fd_sc_hd__decap_3
XFILLER_98_329 VGND VGND VPWR VPWR sky130_fd_sc_hd__decap_3
XFILLER_106_681 VGND VGND VPWR VPWR sky130_fd_sc_hd__decap_3
XFILLER_79_532 VGND VGND VPWR VPWR sky130_fd_sc_hd__decap_3
XFILLER_79_576 VGND VGND VPWR VPWR sky130_fd_sc_hd__decap_3
XFILLER_67_727 VGND VGND VPWR VPWR sky130_fd_sc_hd__fill_1
XFILLER_39_418 VGND VGND VPWR VPWR sky130_fd_sc_hd__decap_3
XFILLER_121_673 VGND VGND VPWR VPWR sky130_fd_sc_hd__decap_3
XFILLER_120_150 VGND VGND VPWR VPWR sky130_fd_sc_hd__decap_3
XFILLER_94_524 VGND VGND VPWR VPWR sky130_fd_sc_hd__decap_3
XFILLER_67_738 VGND VGND VPWR VPWR sky130_fd_sc_hd__decap_3
XFILLER_39_429 VGND VGND VPWR VPWR sky130_fd_sc_hd__decap_3
XFILLER_121_695 VGND VGND VPWR VPWR sky130_fd_sc_hd__decap_3
XFILLER_13_6 VGND VGND VPWR VPWR sky130_fd_sc_hd__decap_3
XFILLER_120_183 VGND VGND VPWR VPWR sky130_fd_sc_hd__decap_3
XFILLER_86_94 VGND VGND VPWR VPWR sky130_fd_sc_hd__decap_3
XFILLER_94_568 VGND VGND VPWR VPWR sky130_fd_sc_hd__decap_3
XFILLER_66_259 VGND VGND VPWR VPWR sky130_fd_sc_hd__decap_3
XFILLER_82_719 VGND VGND VPWR VPWR sky130_fd_sc_hd__fill_1
XFILLER_19_142 VGND VGND VPWR VPWR sky130_fd_sc_hd__decap_3
XFILLER_47_462 VGND VGND VPWR VPWR sky130_fd_sc_hd__decap_3
XFILLER_90_730 VGND VGND VPWR VPWR sky130_fd_sc_hd__decap_3
XFILLER_62_421 VGND VGND VPWR VPWR sky130_fd_sc_hd__decap_3
XFILLER_34_123 VGND VGND VPWR VPWR sky130_fd_sc_hd__decap_3
XFILLER_19_197 VGND VGND VPWR VPWR sky130_fd_sc_hd__fill_1
XFILLER_35_657 VGND VGND VPWR VPWR sky130_fd_sc_hd__fill_1
XFILLER_90_752 VGND VGND VPWR VPWR sky130_fd_sc_hd__decap_3
XFILLER_62_454 VGND VGND VPWR VPWR sky130_fd_sc_hd__decap_3
XFILLER_22_318 VGND VGND VPWR VPWR sky130_fd_sc_hd__decap_3
XFILLER_50_638 VGND VGND VPWR VPWR sky130_fd_sc_hd__fill_2
X_5740_ _4916_/A _5990_/A _5738_/X _5739_/X _5117_/Y VGND VGND VPWR VPWR _5742_/C
+ sky130_fd_sc_hd__a32o_2
XFILLER_15_381 VGND VGND VPWR VPWR sky130_fd_sc_hd__decap_3
X_5671_ _5671_/A _5671_/B VGND VGND VPWR VPWR _5672_/B sky130_fd_sc_hd__nand2_2
X_7410_ _7407_/X _7409_/X _7591_/A VGND VGND VPWR VPWR _7410_/X sky130_fd_sc_hd__a21o_2
X_4622_ _4622_/A VGND VGND VPWR VPWR _9061_/D sky130_fd_sc_hd__buf_1
X_8390_ wire313/X _8389_/Y _8687_/B1 VGND VGND VPWR VPWR _8390_/Y sky130_fd_sc_hd__o21ai_2
XFILLER_30_395 VGND VGND VPWR VPWR sky130_fd_sc_hd__decap_3
XFILLER_129_762 VGND VGND VPWR VPWR sky130_fd_sc_hd__decap_3
X_4553_ _4553_/A VGND VGND VPWR VPWR _9028_/D sky130_fd_sc_hd__buf_1
X_7341_ _7340_/B _7340_/C _7337_/Y VGND VGND VPWR VPWR _7342_/B sky130_fd_sc_hd__a21bo_2
Xmax_cap200 _6085_/X VGND VGND VPWR VPWR _6805_/A sky130_fd_sc_hd__buf_6
Xmax_cap211 _4970_/X VGND VGND VPWR VPWR _5033_/A sky130_fd_sc_hd__clkbuf_2
XFILLER_7_580 VGND VGND VPWR VPWR sky130_fd_sc_hd__decap_3
XFILLER_128_294 VGND VGND VPWR VPWR sky130_fd_sc_hd__decap_3
XFILLER_116_434 VGND VGND VPWR VPWR sky130_fd_sc_hd__decap_3
X_7272_ _7274_/B _7272_/B VGND VGND VPWR VPWR _7272_/X sky130_fd_sc_hd__and2b_2
XTAP_TAPCELL_ROW_92_1518 VGND VPWR sky130_fd_sc_hd__tapvpwrvgnd_1
XTAP_TAPCELL_ROW_92_1529 VGND VPWR sky130_fd_sc_hd__tapvpwrvgnd_1
X_9011_ hold904/X _9011_/A1 _9015_/S VGND VGND VPWR VPWR _9012_/A sky130_fd_sc_hd__mux2_2
X_6223_ _6177_/A _5893_/B _6017_/Y _6177_/B _7050_/A VGND VGND VPWR VPWR _6224_/B
+ sky130_fd_sc_hd__a32o_2
XFILLER_103_128 VGND VGND VPWR VPWR sky130_fd_sc_hd__decap_3
XFILLER_106_27 VGND VGND VPWR VPWR sky130_fd_sc_hd__fill_1
X_6154_ _5860_/A wire62/X _6053_/B VGND VGND VPWR VPWR _6154_/X sky130_fd_sc_hd__a21o_2
XFILLER_97_340 VGND VGND VPWR VPWR sky130_fd_sc_hd__decap_3
XFILLER_112_651 VGND VGND VPWR VPWR sky130_fd_sc_hd__decap_3
XFILLER_85_502 VGND VGND VPWR VPWR sky130_fd_sc_hd__fill_2
XFILLER_112_662 VGND VGND VPWR VPWR sky130_fd_sc_hd__fill_2
XPHY_EDGE_ROW_29_Left_160 VGND VGND VPWR VPWR sky130_fd_sc_hd__decap_3
XFILLER_112_673 VGND VGND VPWR VPWR sky130_fd_sc_hd__decap_3
X_5105_ _5146_/A _5105_/B _5105_/C VGND VGND VPWR VPWR _5105_/Y sky130_fd_sc_hd__nand3b_2
Xhold1203 _9244_/Q VGND VGND VPWR VPWR _8831_/A1 sky130_fd_sc_hd__dlygate4sd3_1
X_6085_ _6085_/A VGND VGND VPWR VPWR _6085_/X sky130_fd_sc_hd__clkbuf_1
Xhold1214 _9245_/Q VGND VGND VPWR VPWR _8833_/A1 sky130_fd_sc_hd__dlygate4sd3_1
Xhold1225 _6140_/Y VGND VGND VPWR VPWR _6141_/B sky130_fd_sc_hd__dlygate4sd3_1
XFILLER_111_183 VGND VGND VPWR VPWR sky130_fd_sc_hd__decap_3
Xhold1236 _9232_/Q VGND VGND VPWR VPWR _8760_/A sky130_fd_sc_hd__dlygate4sd3_1
X_5036_ hold772/X _5029_/X _5035_/X VGND VGND VPWR VPWR _5036_/X sky130_fd_sc_hd__o21ba_2
Xhold1247 _9225_/Q VGND VGND VPWR VPWR _8544_/A sky130_fd_sc_hd__dlygate4sd3_1
XFILLER_73_708 VGND VGND VPWR VPWR sky130_fd_sc_hd__decap_3
Xhold1258 _9208_/Q VGND VGND VPWR VPWR _6142_/A0 sky130_fd_sc_hd__dlygate4sd3_1
XFILLER_66_760 VGND VGND VPWR VPWR sky130_fd_sc_hd__decap_3
XFILLER_122_15 VGND VGND VPWR VPWR sky130_fd_sc_hd__decap_3
XFILLER_38_462 VGND VGND VPWR VPWR sky130_fd_sc_hd__decap_3
XFILLER_53_410 VGND VGND VPWR VPWR sky130_fd_sc_hd__decap_3
XFILLER_38_484 VGND VGND VPWR VPWR sky130_fd_sc_hd__decap_3
XFILLER_122_59 VGND VGND VPWR VPWR sky130_fd_sc_hd__decap_3
XFILLER_93_590 VGND VGND VPWR VPWR sky130_fd_sc_hd__decap_3
XFILLER_65_281 VGND VGND VPWR VPWR sky130_fd_sc_hd__fill_2
XFILLER_26_657 VGND VGND VPWR VPWR sky130_fd_sc_hd__decap_3
XTAP_TAPCELL_ROW_0_266 VGND VPWR sky130_fd_sc_hd__tapvpwrvgnd_1
XTAP_TAPCELL_ROW_0_277 VGND VPWR sky130_fd_sc_hd__tapvpwrvgnd_1
XFILLER_53_465 VGND VGND VPWR VPWR sky130_fd_sc_hd__decap_3
XFILLER_25_156 VGND VGND VPWR VPWR sky130_fd_sc_hd__decap_3
X_6987_ _6346_/A _6346_/B _6939_/A VGND VGND VPWR VPWR _6989_/A sky130_fd_sc_hd__a21o_4
XTAP_TAPCELL_ROW_0_288 VGND VPWR sky130_fd_sc_hd__tapvpwrvgnd_1
XFILLER_15_24 VGND VGND VPWR VPWR sky130_fd_sc_hd__decap_3
X_8726_ _8704_/B _8737_/A _8737_/B VGND VGND VPWR VPWR _8726_/X sky130_fd_sc_hd__mux2_2
XFILLER_41_638 VGND VGND VPWR VPWR sky130_fd_sc_hd__fill_2
X_5938_ _5940_/A1 _6873_/A _6826_/A1 _6868_/A VGND VGND VPWR VPWR _5938_/X sky130_fd_sc_hd__a31o_2
XFILLER_40_126 VGND VGND VPWR VPWR sky130_fd_sc_hd__decap_3
XFILLER_15_57 VGND VGND VPWR VPWR sky130_fd_sc_hd__decap_3
XFILLER_80_295 VGND VGND VPWR VPWR sky130_fd_sc_hd__decap_3
XTAP_TAPCELL_ROW_101_1647 VGND VPWR sky130_fd_sc_hd__tapvpwrvgnd_1
X_8657_ _9228_/Q _8657_/B VGND VGND VPWR VPWR _8666_/A sky130_fd_sc_hd__nand2_2
XFILLER_21_340 VGND VGND VPWR VPWR sky130_fd_sc_hd__decap_3
X_5869_ _5729_/A _5729_/B _5868_/Y _5749_/B _6246_/A VGND VGND VPWR VPWR _5872_/B
+ sky130_fd_sc_hd__a311o_2
XFILLER_21_373 VGND VGND VPWR VPWR sky130_fd_sc_hd__decap_3
X_7608_ _7608_/A _7608_/B VGND VGND VPWR VPWR _7609_/B sky130_fd_sc_hd__xnor2_2
Xrebuffer600 _6344_/A1 VGND VGND VPWR VPWR _6751_/A2 sky130_fd_sc_hd__buf_2
Xrebuffer611 _7150_/A VGND VGND VPWR VPWR _7149_/B2 sky130_fd_sc_hd__buf_2
XFILLER_31_23 VGND VGND VPWR VPWR sky130_fd_sc_hd__decap_3
X_8588_ _9224_/Q _8697_/C _8476_/X _8656_/A VGND VGND VPWR VPWR _8588_/X sky130_fd_sc_hd__o22a_2
Xrebuffer633 _6117_/B2 VGND VGND VPWR VPWR _7182_/A1 sky130_fd_sc_hd__buf_2
XTAP_TAPCELL_ROW_60_1090 VGND VPWR sky130_fd_sc_hd__tapvpwrvgnd_1
XFILLER_126_209 VGND VGND VPWR VPWR sky130_fd_sc_hd__decap_3
X_7539_ _7539_/A _7539_/B VGND VGND VPWR VPWR _7689_/A sky130_fd_sc_hd__xnor2_2
Xrebuffer655 rebuffer655/A VGND VGND VPWR VPWR _5950_/A sky130_fd_sc_hd__buf_2
XFILLER_107_423 VGND VGND VPWR VPWR sky130_fd_sc_hd__decap_3
Xrebuffer677 _6500_/A VGND VGND VPWR VPWR _6504_/A2 sky130_fd_sc_hd__buf_2
XFILLER_5_539 VGND VGND VPWR VPWR sky130_fd_sc_hd__decap_3
XFILLER_31_78 VGND VGND VPWR VPWR sky130_fd_sc_hd__decap_3
XFILLER_119_294 VGND VGND VPWR VPWR sky130_fd_sc_hd__decap_3
Xoutput23 _9192_/Q VGND VGND VPWR VPWR wire231/A sky130_fd_sc_hd__buf_1
Xoutput34 _9188_/Q VGND VGND VPWR VPWR wire220/A sky130_fd_sc_hd__buf_1
X_9209_ _9209_/CLK _9209_/D fanout418/X VGND VGND VPWR VPWR _9209_/Q sky130_fd_sc_hd__dfrtp_2
XFILLER_122_415 VGND VGND VPWR VPWR sky130_fd_sc_hd__decap_3
XFILLER_1_712 VGND VGND VPWR VPWR sky130_fd_sc_hd__decap_3
XFILLER_0_200 VGND VGND VPWR VPWR sky130_fd_sc_hd__decap_3
XFILLER_103_640 VGND VGND VPWR VPWR sky130_fd_sc_hd__decap_3
XFILLER_1_756 VGND VGND VPWR VPWR sky130_fd_sc_hd__decap_3
XFILLER_49_705 VGND VGND VPWR VPWR sky130_fd_sc_hd__fill_2
XTAP_TAPCELL_ROW_8_388 VGND VPWR sky130_fd_sc_hd__tapvpwrvgnd_1
XTAP_TAPCELL_ROW_112_1787 VGND VPWR sky130_fd_sc_hd__tapvpwrvgnd_1
XFILLER_103_673 VGND VGND VPWR VPWR sky130_fd_sc_hd__decap_3
XTAP_TAPCELL_ROW_112_1798 VGND VPWR sky130_fd_sc_hd__tapvpwrvgnd_1
XFILLER_102_150 VGND VGND VPWR VPWR sky130_fd_sc_hd__decap_3
XFILLER_48_215 VGND VGND VPWR VPWR sky130_fd_sc_hd__decap_3
XFILLER_102_172 VGND VGND VPWR VPWR sky130_fd_sc_hd__decap_3
XFILLER_103_695 VGND VGND VPWR VPWR sky130_fd_sc_hd__decap_3
XFILLER_130_492 VGND VGND VPWR VPWR sky130_fd_sc_hd__decap_3
XFILLER_56_20 VGND VGND VPWR VPWR sky130_fd_sc_hd__decap_3
XFILLER_48_248 VGND VGND VPWR VPWR sky130_fd_sc_hd__fill_1
XFILLER_76_568 VGND VGND VPWR VPWR sky130_fd_sc_hd__decap_3
XFILLER_91_505 VGND VGND VPWR VPWR sky130_fd_sc_hd__decap_3
XTAP_TAPCELL_ROW_47_917 VGND VPWR sky130_fd_sc_hd__tapvpwrvgnd_1
XFILLER_56_53 VGND VGND VPWR VPWR sky130_fd_sc_hd__decap_3
XFILLER_56_75 VGND VGND VPWR VPWR sky130_fd_sc_hd__decap_3
XFILLER_29_473 VGND VGND VPWR VPWR sky130_fd_sc_hd__decap_3
XFILLER_16_101 VGND VGND VPWR VPWR sky130_fd_sc_hd__decap_3
XFILLER_56_97 VGND VGND VPWR VPWR sky130_fd_sc_hd__decap_3
XFILLER_29_495 VGND VGND VPWR VPWR sky130_fd_sc_hd__decap_3
XFILLER_72_741 VGND VGND VPWR VPWR sky130_fd_sc_hd__decap_3
XTAP_TAPCELL_ROW_27_641 VGND VPWR sky130_fd_sc_hd__tapvpwrvgnd_1
XTAP_TAPCELL_ROW_27_652 VGND VPWR sky130_fd_sc_hd__tapvpwrvgnd_1
XPHY_EDGE_ROW_113_Right_113 VGND VGND VPWR VPWR sky130_fd_sc_hd__decap_3
XFILLER_44_465 VGND VGND VPWR VPWR sky130_fd_sc_hd__fill_1
XFILLER_16_156 VGND VGND VPWR VPWR sky130_fd_sc_hd__decap_3
XFILLER_112_81 VGND VGND VPWR VPWR sky130_fd_sc_hd__decap_3
XFILLER_32_627 VGND VGND VPWR VPWR sky130_fd_sc_hd__decap_3
XFILLER_31_104 VGND VGND VPWR VPWR sky130_fd_sc_hd__decap_3
XFILLER_16_189 VGND VGND VPWR VPWR sky130_fd_sc_hd__decap_3
XFILLER_40_660 VGND VGND VPWR VPWR sky130_fd_sc_hd__fill_1
XFILLER_82_9 VGND VGND VPWR VPWR sky130_fd_sc_hd__decap_3
XFILLER_117_209 VGND VGND VPWR VPWR sky130_fd_sc_hd__decap_3
XFILLER_126_710 VGND VGND VPWR VPWR sky130_fd_sc_hd__decap_3
XTAP_TAPCELL_ROW_78_1340 VGND VPWR sky130_fd_sc_hd__tapvpwrvgnd_1
XFILLER_126_743 VGND VGND VPWR VPWR sky130_fd_sc_hd__decap_3
XFILLER_125_220 VGND VGND VPWR VPWR sky130_fd_sc_hd__decap_3
XFILLER_125_231 VGND VGND VPWR VPWR sky130_fd_sc_hd__decap_3
XFILLER_125_264 VGND VGND VPWR VPWR sky130_fd_sc_hd__decap_3
XFILLER_98_115 VGND VGND VPWR VPWR sky130_fd_sc_hd__decap_3
XFILLER_113_437 VGND VGND VPWR VPWR sky130_fd_sc_hd__decap_3
XFILLER_98_148 VGND VGND VPWR VPWR sky130_fd_sc_hd__decap_3
XFILLER_79_340 VGND VGND VPWR VPWR sky130_fd_sc_hd__fill_2
XFILLER_79_362 VGND VGND VPWR VPWR sky130_fd_sc_hd__decap_3
XFILLER_67_513 VGND VGND VPWR VPWR sky130_fd_sc_hd__decap_3
XFILLER_121_481 VGND VGND VPWR VPWR sky130_fd_sc_hd__decap_3
XFILLER_39_248 VGND VGND VPWR VPWR sky130_fd_sc_hd__decap_3
XFILLER_11_3 VGND VGND VPWR VPWR sky130_fd_sc_hd__decap_3
XFILLER_94_365 VGND VGND VPWR VPWR sky130_fd_sc_hd__decap_3
XFILLER_82_505 VGND VGND VPWR VPWR sky130_fd_sc_hd__decap_3
XFILLER_48_760 VGND VGND VPWR VPWR sky130_fd_sc_hd__fill_1
X_6910_ _6910_/A _6910_/B VGND VGND VPWR VPWR _6912_/C sky130_fd_sc_hd__and2_4
XTAP_TAPCELL_ROW_89_1480 VGND VPWR sky130_fd_sc_hd__tapvpwrvgnd_1
XFILLER_47_270 VGND VGND VPWR VPWR sky130_fd_sc_hd__decap_3
X_7890_ _8017_/A _7890_/B VGND VGND VPWR VPWR _8006_/C sky130_fd_sc_hd__xnor2_2
XFILLER_47_281 VGND VGND VPWR VPWR sky130_fd_sc_hd__fill_2
XFILLER_47_292 VGND VGND VPWR VPWR sky130_fd_sc_hd__decap_3
XFILLER_35_432 VGND VGND VPWR VPWR sky130_fd_sc_hd__decap_3
XFILLER_63_752 VGND VGND VPWR VPWR sky130_fd_sc_hd__decap_3
X_6841_ _6506_/B _6842_/A2 _6505_/B VGND VGND VPWR VPWR _6841_/Y sky130_fd_sc_hd__o21bai_2
XFILLER_35_465 VGND VGND VPWR VPWR sky130_fd_sc_hd__decap_3
XFILLER_90_582 VGND VGND VPWR VPWR sky130_fd_sc_hd__decap_3
XFILLER_50_424 VGND VGND VPWR VPWR sky130_fd_sc_hd__decap_3
X_6772_ _6769_/Y _6770_/X _6912_/A _6912_/B VGND VGND VPWR VPWR _6774_/D sky130_fd_sc_hd__o211ai_2
XFILLER_23_649 VGND VGND VPWR VPWR sky130_fd_sc_hd__decap_3
X_8511_ _8511_/A _8511_/B VGND VGND VPWR VPWR _8512_/A sky130_fd_sc_hd__and2_2
X_5723_ _5861_/A _5861_/B _5723_/B1 VGND VGND VPWR VPWR _5725_/A sky130_fd_sc_hd__a21oi_2
XFILLER_31_671 VGND VGND VPWR VPWR sky130_fd_sc_hd__fill_1
XFILLER_31_682 VGND VGND VPWR VPWR sky130_fd_sc_hd__decap_3
X_8442_ _9221_/Q _8439_/Y _8441_/X VGND VGND VPWR VPWR _8442_/Y sky130_fd_sc_hd__o21ai_2
X_5654_ _6416_/B _5804_/B _5936_/A VGND VGND VPWR VPWR _5662_/B sky130_fd_sc_hd__and3_2
X_4605_ _4605_/A VGND VGND VPWR VPWR _9053_/D sky130_fd_sc_hd__buf_1
XFILLER_129_570 VGND VGND VPWR VPWR sky130_fd_sc_hd__decap_3
X_8373_ _8397_/A wire45/X _8379_/A VGND VGND VPWR VPWR _8374_/C sky130_fd_sc_hd__a21o_2
XFILLER_117_721 VGND VGND VPWR VPWR sky130_fd_sc_hd__decap_3
X_5585_ _6160_/A1 _5584_/X _7951_/A _5011_/X VGND VGND VPWR VPWR _5591_/A sky130_fd_sc_hd__a211o_2
XFILLER_117_732 VGND VGND VPWR VPWR sky130_fd_sc_hd__fill_1
X_7324_ _7324_/A _7324_/B VGND VGND VPWR VPWR _7325_/B sky130_fd_sc_hd__xnor2_2
X_4536_ hold827/X hold966/X _4544_/S VGND VGND VPWR VPWR _4537_/A sky130_fd_sc_hd__mux2_2
XFILLER_117_765 VGND VGND VPWR VPWR sky130_fd_sc_hd__decap_3
XFILLER_117_15 VGND VGND VPWR VPWR sky130_fd_sc_hd__decap_3
XFILLER_116_264 VGND VGND VPWR VPWR sky130_fd_sc_hd__decap_3
X_7255_ _7210_/A _7207_/A _7209_/B VGND VGND VPWR VPWR _7257_/A sky130_fd_sc_hd__a21o_2
XFILLER_117_48 VGND VGND VPWR VPWR sky130_fd_sc_hd__decap_3
XFILLER_116_297 VGND VGND VPWR VPWR sky130_fd_sc_hd__decap_3
X_6206_ _6206_/A _6206_/B _6206_/C VGND VGND VPWR VPWR _8779_/B sky130_fd_sc_hd__and3_2
X_7186_ _7186_/A VGND VGND VPWR VPWR _7186_/X sky130_fd_sc_hd__clkbuf_1
XFILLER_58_513 VGND VGND VPWR VPWR sky130_fd_sc_hd__decap_3
XFILLER_98_682 VGND VGND VPWR VPWR sky130_fd_sc_hd__decap_3
X_6137_ _6137_/A _6137_/B VGND VGND VPWR VPWR _6140_/A sky130_fd_sc_hd__xnor2_2
Xhold1000 _9064_/Q VGND VGND VPWR VPWR _4662_/A1 sky130_fd_sc_hd__dlygate4sd3_1
XFILLER_58_524 VGND VGND VPWR VPWR sky130_fd_sc_hd__decap_3
XTAP_TAPCELL_ROW_5_347 VGND VPWR sky130_fd_sc_hd__tapvpwrvgnd_1
Xhold1011 _8844_/X VGND VGND VPWR VPWR _8845_/A sky130_fd_sc_hd__dlygate4sd3_1
Xhold1022 _9143_/Q VGND VGND VPWR VPWR _4828_/A1 sky130_fd_sc_hd__dlygate4sd3_1
Xload_slew291 _6885_/A VGND VGND VPWR VPWR _6788_/B sky130_fd_sc_hd__buf_2
Xhold1033 _9121_/Q VGND VGND VPWR VPWR _4782_/A1 sky130_fd_sc_hd__dlygate4sd3_1
Xhold1044 _9071_/Q VGND VGND VPWR VPWR _4677_/A1 sky130_fd_sc_hd__dlygate4sd3_1
X_6068_ _6070_/A _6514_/B VGND VGND VPWR VPWR _6068_/Y sky130_fd_sc_hd__nor2_2
XFILLER_73_505 VGND VGND VPWR VPWR sky130_fd_sc_hd__fill_1
XFILLER_58_579 VGND VGND VPWR VPWR sky130_fd_sc_hd__decap_3
Xhold1055 _9105_/Q VGND VGND VPWR VPWR _4748_/A1 sky130_fd_sc_hd__dlygate4sd3_1
Xhold1066 _9343_/Q VGND VGND VPWR VPWR _9005_/A0 sky130_fd_sc_hd__dlygate4sd3_1
Xhold1077 _8896_/X VGND VGND VPWR VPWR _8897_/A sky130_fd_sc_hd__dlygate4sd3_1
X_5019_ _5743_/B VGND VGND VPWR VPWR _5019_/X sky130_fd_sc_hd__buf_2
Xhold1088 _9041_/Q VGND VGND VPWR VPWR _4613_/A1 sky130_fd_sc_hd__dlygate4sd3_1
XFILLER_26_410 VGND VGND VPWR VPWR sky130_fd_sc_hd__decap_3
Xhold1099 _8934_/X VGND VGND VPWR VPWR _8935_/A sky130_fd_sc_hd__dlygate4sd3_1
XFILLER_26_421 VGND VGND VPWR VPWR sky130_fd_sc_hd__decap_3
XTAP_TAPCELL_ROW_24_600 VGND VPWR sky130_fd_sc_hd__tapvpwrvgnd_1
XTAP_TAPCELL_ROW_24_611 VGND VPWR sky130_fd_sc_hd__tapvpwrvgnd_1
XFILLER_41_435 VGND VGND VPWR VPWR sky130_fd_sc_hd__fill_1
X_8709_ _8705_/X _8672_/B _8706_/X _8708_/Y VGND VGND VPWR VPWR _8710_/B sky130_fd_sc_hd__a211o_4
XFILLER_9_108 VGND VGND VPWR VPWR sky130_fd_sc_hd__decap_3
XFILLER_9_119 VGND VGND VPWR VPWR sky130_fd_sc_hd__fill_2
XFILLER_42_22 VGND VGND VPWR VPWR sky130_fd_sc_hd__decap_3
XTAP_TAPCELL_ROW_52_986 VGND VPWR sky130_fd_sc_hd__tapvpwrvgnd_1
XFILLER_42_66 VGND VGND VPWR VPWR sky130_fd_sc_hd__fill_1
XFILLER_42_77 VGND VGND VPWR VPWR sky130_fd_sc_hd__decap_3
XFILLER_42_88 VGND VGND VPWR VPWR sky130_fd_sc_hd__decap_3
XFILLER_21_192 VGND VGND VPWR VPWR sky130_fd_sc_hd__decap_3
XFILLER_127_518 VGND VGND VPWR VPWR sky130_fd_sc_hd__decap_3
Xrebuffer430 _5473_/D VGND VGND VPWR VPWR _5183_/B1 sky130_fd_sc_hd__buf_6
Xrebuffer441 _5627_/B VGND VGND VPWR VPWR _5692_/A1 sky130_fd_sc_hd__buf_2
Xrebuffer452 wire123/X VGND VGND VPWR VPWR _7612_/A1 sky130_fd_sc_hd__buf_2
XFILLER_5_314 VGND VGND VPWR VPWR sky130_fd_sc_hd__decap_3
Xrebuffer463 _5742_/D VGND VGND VPWR VPWR _6344_/A1 sky130_fd_sc_hd__buf_12
XFILLER_107_220 VGND VGND VPWR VPWR sky130_fd_sc_hd__decap_3
Xrebuffer474 _6717_/A VGND VGND VPWR VPWR _6588_/A sky130_fd_sc_hd__buf_6
Xrebuffer485 _7033_/A VGND VGND VPWR VPWR _7021_/B sky130_fd_sc_hd__buf_2
XFILLER_107_242 VGND VGND VPWR VPWR sky130_fd_sc_hd__decap_3
Xrebuffer496 _7062_/C VGND VGND VPWR VPWR _7358_/A1 sky130_fd_sc_hd__buf_2
XTAP_TAPCELL_ROW_114_1816 VGND VPWR sky130_fd_sc_hd__tapvpwrvgnd_1
XTAP_TAPCELL_ROW_114_1827 VGND VPWR sky130_fd_sc_hd__tapvpwrvgnd_1
XFILLER_107_275 VGND VGND VPWR VPWR sky130_fd_sc_hd__decap_3
XFILLER_123_724 VGND VGND VPWR VPWR sky130_fd_sc_hd__decap_3
XFILLER_123_735 VGND VGND VPWR VPWR sky130_fd_sc_hd__decap_3
XFILLER_122_212 VGND VGND VPWR VPWR sky130_fd_sc_hd__decap_3
XFILLER_123_768 VGND VGND VPWR VPWR sky130_fd_sc_hd__decap_3
XFILLER_3_27 VGND VGND VPWR VPWR sky130_fd_sc_hd__decap_3
XFILLER_89_660 VGND VGND VPWR VPWR sky130_fd_sc_hd__decap_3
XFILLER_122_256 VGND VGND VPWR VPWR sky130_fd_sc_hd__fill_2
XTAP_TAPCELL_ROW_73_1270 VGND VPWR sky130_fd_sc_hd__tapvpwrvgnd_1
XFILLER_110_407 VGND VGND VPWR VPWR sky130_fd_sc_hd__decap_3
XFILLER_49_502 VGND VGND VPWR VPWR sky130_fd_sc_hd__fill_2
XFILLER_89_682 VGND VGND VPWR VPWR sky130_fd_sc_hd__decap_3
XFILLER_122_289 VGND VGND VPWR VPWR sky130_fd_sc_hd__decap_3
XFILLER_49_535 VGND VGND VPWR VPWR sky130_fd_sc_hd__decap_3
XFILLER_1_597 VGND VGND VPWR VPWR sky130_fd_sc_hd__decap_3
XFILLER_49_557 VGND VGND VPWR VPWR sky130_fd_sc_hd__decap_3
XFILLER_76_365 VGND VGND VPWR VPWR sky130_fd_sc_hd__fill_1
XFILLER_67_96 VGND VGND VPWR VPWR sky130_fd_sc_hd__decap_3
XFILLER_64_516 VGND VGND VPWR VPWR sky130_fd_sc_hd__decap_3
XFILLER_91_302 VGND VGND VPWR VPWR sky130_fd_sc_hd__decap_3
XFILLER_29_270 VGND VGND VPWR VPWR sky130_fd_sc_hd__decap_3
XFILLER_91_346 VGND VGND VPWR VPWR sky130_fd_sc_hd__decap_3
XFILLER_29_292 VGND VGND VPWR VPWR sky130_fd_sc_hd__decap_3
XFILLER_91_357 VGND VGND VPWR VPWR sky130_fd_sc_hd__decap_3
XTAP_TAPCELL_ROW_125_1967 VGND VPWR sky130_fd_sc_hd__tapvpwrvgnd_1
XFILLER_72_560 VGND VGND VPWR VPWR sky130_fd_sc_hd__decap_3
XFILLER_44_262 VGND VGND VPWR VPWR sky130_fd_sc_hd__decap_3
XFILLER_72_582 VGND VGND VPWR VPWR sky130_fd_sc_hd__decap_3
XFILLER_60_733 VGND VGND VPWR VPWR sky130_fd_sc_hd__decap_3
XFILLER_17_498 VGND VGND VPWR VPWR sky130_fd_sc_hd__decap_3
XFILLER_32_468 VGND VGND VPWR VPWR sky130_fd_sc_hd__fill_1
XFILLER_9_620 VGND VGND VPWR VPWR sky130_fd_sc_hd__fill_1
XFILLER_13_682 VGND VGND VPWR VPWR sky130_fd_sc_hd__decap_3
XFILLER_40_490 VGND VGND VPWR VPWR sky130_fd_sc_hd__decap_3
XFILLER_118_507 VGND VGND VPWR VPWR sky130_fd_sc_hd__decap_3
XFILLER_8_141 VGND VGND VPWR VPWR sky130_fd_sc_hd__decap_3
XFILLER_9_697 VGND VGND VPWR VPWR sky130_fd_sc_hd__decap_3
XFILLER_8_174 VGND VGND VPWR VPWR sky130_fd_sc_hd__fill_2
X_5370_ _5303_/A _5303_/B _5369_/Y VGND VGND VPWR VPWR _5395_/A sky130_fd_sc_hd__o21ai_2
XFILLER_59_3 VGND VGND VPWR VPWR sky130_fd_sc_hd__decap_3
XFILLER_99_402 VGND VGND VPWR VPWR sky130_fd_sc_hd__decap_3
XFILLER_114_713 VGND VGND VPWR VPWR sky130_fd_sc_hd__decap_3
XFILLER_126_573 VGND VGND VPWR VPWR sky130_fd_sc_hd__decap_3
XFILLER_99_424 VGND VGND VPWR VPWR sky130_fd_sc_hd__decap_3
XFILLER_99_435 VGND VGND VPWR VPWR sky130_fd_sc_hd__decap_3
XFILLER_114_735 VGND VGND VPWR VPWR sky130_fd_sc_hd__decap_3
XFILLER_4_380 VGND VGND VPWR VPWR sky130_fd_sc_hd__decap_3
XFILLER_113_234 VGND VGND VPWR VPWR sky130_fd_sc_hd__decap_3
X_7040_ _7036_/A _7036_/B _7038_/B VGND VGND VPWR VPWR _7040_/Y sky130_fd_sc_hd__a21boi_2
XFILLER_101_407 VGND VGND VPWR VPWR sky130_fd_sc_hd__fill_2
XFILLER_113_267 VGND VGND VPWR VPWR sky130_fd_sc_hd__fill_1
XFILLER_86_118 VGND VGND VPWR VPWR sky130_fd_sc_hd__fill_2
XFILLER_86_129 VGND VGND VPWR VPWR sky130_fd_sc_hd__fill_2
XFILLER_95_641 VGND VGND VPWR VPWR sky130_fd_sc_hd__decap_3
XFILLER_67_332 VGND VGND VPWR VPWR sky130_fd_sc_hd__decap_3
XTAP_TAPCELL_ROW_2_306 VGND VPWR sky130_fd_sc_hd__tapvpwrvgnd_1
XFILLER_55_505 VGND VGND VPWR VPWR sky130_fd_sc_hd__decap_3
X_8991_ _9336_/Q hold912/X _9009_/S VGND VGND VPWR VPWR _8991_/X sky130_fd_sc_hd__mux2_2
XFILLER_94_162 VGND VGND VPWR VPWR sky130_fd_sc_hd__decap_3
X_7942_ _7942_/A _7942_/B VGND VGND VPWR VPWR _7943_/B sky130_fd_sc_hd__xor2_2
XFILLER_82_324 VGND VGND VPWR VPWR sky130_fd_sc_hd__fill_2
XFILLER_55_549 VGND VGND VPWR VPWR sky130_fd_sc_hd__decap_3
XFILLER_36_730 VGND VGND VPWR VPWR sky130_fd_sc_hd__fill_1
XFILLER_82_346 VGND VGND VPWR VPWR sky130_fd_sc_hd__decap_3
XFILLER_82_357 VGND VGND VPWR VPWR sky130_fd_sc_hd__decap_3
XFILLER_35_240 VGND VGND VPWR VPWR sky130_fd_sc_hd__decap_3
X_7873_ _8022_/S _7873_/B VGND VGND VPWR VPWR _8017_/A sky130_fd_sc_hd__xor2_2
XFILLER_51_700 VGND VGND VPWR VPWR sky130_fd_sc_hd__decap_3
XFILLER_63_582 VGND VGND VPWR VPWR sky130_fd_sc_hd__decap_3
X_6824_ _7676_/C _7181_/B VGND VGND VPWR VPWR _6825_/B sky130_fd_sc_hd__xnor2_2
XFILLER_35_284 VGND VGND VPWR VPWR sky130_fd_sc_hd__decap_3
XFILLER_11_608 VGND VGND VPWR VPWR sky130_fd_sc_hd__decap_3
X_6755_ _9017_/Q _5002_/X _6752_/X _6753_/X _6754_/X VGND VGND VPWR VPWR _6755_/X
+ sky130_fd_sc_hd__a2111o_2
X_5706_ _5604_/B _5705_/B _5605_/B VGND VGND VPWR VPWR _5861_/B sky130_fd_sc_hd__a21o_2
X_6686_ _6346_/A _6346_/B _7050_/B VGND VGND VPWR VPWR _6688_/A sky130_fd_sc_hd__a21o_2
Xclkbuf_leaf_30_clk clkload2/A VGND VGND VPWR VPWR _9227_/CLK sky130_fd_sc_hd__clkbuf_8
XFILLER_31_490 VGND VGND VPWR VPWR sky130_fd_sc_hd__decap_3
X_8425_ _4914_/Y _5283_/B _8780_/C VGND VGND VPWR VPWR _8425_/X sky130_fd_sc_hd__mux2_2
X_5637_ _5637_/A _5637_/B VGND VGND VPWR VPWR _5773_/B sky130_fd_sc_hd__xnor2_2
XFILLER_128_47 VGND VGND VPWR VPWR sky130_fd_sc_hd__decap_3
XFILLER_117_540 VGND VGND VPWR VPWR sky130_fd_sc_hd__decap_3
X_8356_ _9220_/Q _9221_/Q _8367_/B VGND VGND VPWR VPWR _8356_/X sky130_fd_sc_hd__or3_2
X_5568_ _7416_/A VGND VGND VPWR VPWR _7763_/B sky130_fd_sc_hd__clkbuf_1
XFILLER_105_713 VGND VGND VPWR VPWR sky130_fd_sc_hd__decap_3
XFILLER_88_29 VGND VGND VPWR VPWR sky130_fd_sc_hd__fill_2
X_7307_ _7307_/A _7307_/B _7307_/C VGND VGND VPWR VPWR _7467_/A sky130_fd_sc_hd__and3_4
XFILLER_104_212 VGND VGND VPWR VPWR sky130_fd_sc_hd__decap_3
X_4519_ _6232_/C _6231_/B _5119_/S VGND VGND VPWR VPWR _5175_/B sky130_fd_sc_hd__nor3_2
X_8287_ _8277_/Y _8282_/X _8285_/X _8286_/X VGND VGND VPWR VPWR _8288_/B sky130_fd_sc_hd__a211o_2
X_5499_ _5497_/Y _5499_/B VGND VGND VPWR VPWR _5649_/A sky130_fd_sc_hd__nand2b_2
XFILLER_104_245 VGND VGND VPWR VPWR sky130_fd_sc_hd__fill_1
XFILLER_78_608 VGND VGND VPWR VPWR sky130_fd_sc_hd__decap_3
XFILLER_104_256 VGND VGND VPWR VPWR sky130_fd_sc_hd__decap_3
X_7238_ _7661_/A _7659_/B VGND VGND VPWR VPWR _7239_/B sky130_fd_sc_hd__xnor2_2
XFILLER_120_716 VGND VGND VPWR VPWR sky130_fd_sc_hd__decap_3
XFILLER_104_289 VGND VGND VPWR VPWR sky130_fd_sc_hd__decap_3
XTAP_TAPCELL_ROW_129_2023 VGND VPWR sky130_fd_sc_hd__tapvpwrvgnd_1
XFILLER_120_749 VGND VGND VPWR VPWR sky130_fd_sc_hd__decap_3
X_7169_ _6872_/A _6825_/A _7170_/S VGND VGND VPWR VPWR _7169_/X sky130_fd_sc_hd__mux2_2
XFILLER_98_490 VGND VGND VPWR VPWR sky130_fd_sc_hd__decap_3
XFILLER_86_663 VGND VGND VPWR VPWR sky130_fd_sc_hd__decap_3
XFILLER_85_140 VGND VGND VPWR VPWR sky130_fd_sc_hd__fill_2
XFILLER_19_719 VGND VGND VPWR VPWR sky130_fd_sc_hd__decap_3
XFILLER_58_365 VGND VGND VPWR VPWR sky130_fd_sc_hd__decap_3
XFILLER_18_218 VGND VGND VPWR VPWR sky130_fd_sc_hd__decap_3
XFILLER_73_324 VGND VGND VPWR VPWR sky130_fd_sc_hd__decap_3
XFILLER_58_398 VGND VGND VPWR VPWR sky130_fd_sc_hd__decap_3
XFILLER_100_495 VGND VGND VPWR VPWR sky130_fd_sc_hd__fill_1
XFILLER_73_335 VGND VGND VPWR VPWR sky130_fd_sc_hd__fill_1
XFILLER_61_508 VGND VGND VPWR VPWR sky130_fd_sc_hd__decap_3
XFILLER_37_99 VGND VGND VPWR VPWR sky130_fd_sc_hd__decap_3
XFILLER_27_752 VGND VGND VPWR VPWR sky130_fd_sc_hd__decap_3
XFILLER_26_262 VGND VGND VPWR VPWR sky130_fd_sc_hd__fill_1
XFILLER_54_582 VGND VGND VPWR VPWR sky130_fd_sc_hd__decap_3
XFILLER_42_722 VGND VGND VPWR VPWR sky130_fd_sc_hd__decap_3
XTAP_TAPCELL_ROW_37_780 VGND VPWR sky130_fd_sc_hd__tapvpwrvgnd_1
XFILLER_53_21 VGND VGND VPWR VPWR sky130_fd_sc_hd__decap_3
XFILLER_14_424 VGND VGND VPWR VPWR sky130_fd_sc_hd__decap_3
XFILLER_81_390 VGND VGND VPWR VPWR sky130_fd_sc_hd__fill_2
XFILLER_53_54 VGND VGND VPWR VPWR sky130_fd_sc_hd__fill_2
XFILLER_41_265 VGND VGND VPWR VPWR sky130_fd_sc_hd__decap_3
XFILLER_53_87 VGND VGND VPWR VPWR sky130_fd_sc_hd__decap_3
XFILLER_41_276 VGND VGND VPWR VPWR sky130_fd_sc_hd__decap_3
XFILLER_41_287 VGND VGND VPWR VPWR sky130_fd_sc_hd__fill_1
XTAP_TAPCELL_ROW_120_1897 VGND VPWR sky130_fd_sc_hd__tapvpwrvgnd_1
Xclkbuf_leaf_21_clk clkbuf_leaf_9_clk/A VGND VGND VPWR VPWR _9142_/CLK sky130_fd_sc_hd__clkbuf_8
XFILLER_10_663 VGND VGND VPWR VPWR sky130_fd_sc_hd__decap_3
XFILLER_127_337 VGND VGND VPWR VPWR sky130_fd_sc_hd__decap_3
XFILLER_5_122 VGND VGND VPWR VPWR sky130_fd_sc_hd__decap_3
XFILLER_108_562 VGND VGND VPWR VPWR sky130_fd_sc_hd__decap_3
XFILLER_6_678 VGND VGND VPWR VPWR sky130_fd_sc_hd__decap_3
XFILLER_5_199 VGND VGND VPWR VPWR sky130_fd_sc_hd__decap_3
XFILLER_45_9 VGND VGND VPWR VPWR sky130_fd_sc_hd__decap_3
XFILLER_123_532 VGND VGND VPWR VPWR sky130_fd_sc_hd__decap_3
XFILLER_123_543 VGND VGND VPWR VPWR sky130_fd_sc_hd__decap_3
XFILLER_118_80 VGND VGND VPWR VPWR sky130_fd_sc_hd__decap_3
XFILLER_118_91 VGND VGND VPWR VPWR sky130_fd_sc_hd__decap_3
XFILLER_111_727 VGND VGND VPWR VPWR sky130_fd_sc_hd__fill_1
XFILLER_110_226 VGND VGND VPWR VPWR sky130_fd_sc_hd__fill_1
XFILLER_77_652 VGND VGND VPWR VPWR sky130_fd_sc_hd__fill_2
XFILLER_49_365 VGND VGND VPWR VPWR sky130_fd_sc_hd__decap_3
XFILLER_37_505 VGND VGND VPWR VPWR sky130_fd_sc_hd__decap_3
XFILLER_77_685 VGND VGND VPWR VPWR sky130_fd_sc_hd__decap_3
XFILLER_64_302 VGND VGND VPWR VPWR sky130_fd_sc_hd__decap_3
XFILLER_37_538 VGND VGND VPWR VPWR sky130_fd_sc_hd__decap_3
XFILLER_94_83 VGND VGND VPWR VPWR sky130_fd_sc_hd__fill_1
XFILLER_18_752 VGND VGND VPWR VPWR sky130_fd_sc_hd__decap_3
XFILLER_18_763 VGND VGND VPWR VPWR sky130_fd_sc_hd__decap_3
XFILLER_17_240 VGND VGND VPWR VPWR sky130_fd_sc_hd__decap_3
XFILLER_92_699 VGND VGND VPWR VPWR sky130_fd_sc_hd__fill_1
XFILLER_91_187 VGND VGND VPWR VPWR sky130_fd_sc_hd__fill_1
XFILLER_45_582 VGND VGND VPWR VPWR sky130_fd_sc_hd__decap_3
XFILLER_17_284 VGND VGND VPWR VPWR sky130_fd_sc_hd__decap_3
X_4870_ _8760_/A VGND VGND VPWR VPWR _4870_/Y sky130_fd_sc_hd__inv_2
XFILLER_60_574 VGND VGND VPWR VPWR sky130_fd_sc_hd__fill_2
XFILLER_20_405 VGND VGND VPWR VPWR sky130_fd_sc_hd__decap_3
XFILLER_60_585 VGND VGND VPWR VPWR sky130_fd_sc_hd__decap_3
XFILLER_20_427 VGND VGND VPWR VPWR sky130_fd_sc_hd__decap_3
XTAP_TAPCELL_ROW_15_485 VGND VPWR sky130_fd_sc_hd__tapvpwrvgnd_1
X_6540_ _6540_/A _6540_/B VGND VGND VPWR VPWR _6540_/Y sky130_fd_sc_hd__nor2_2
Xclkbuf_leaf_12_clk clkload0/A VGND VGND VPWR VPWR _9168_/CLK sky130_fd_sc_hd__clkbuf_8
X_6471_ _6788_/B _6845_/A VGND VGND VPWR VPWR _6472_/B sky130_fd_sc_hd__xnor2_2
X_8210_ _8210_/A _8210_/B VGND VGND VPWR VPWR _8211_/A sky130_fd_sc_hd__nand2_4
X_5422_ _5713_/A _7805_/A VGND VGND VPWR VPWR _5426_/A sky130_fd_sc_hd__nor2_2
X_9190_ _9223_/CLK _9190_/D load_slew414/X VGND VGND VPWR VPWR _9190_/Q sky130_fd_sc_hd__dfrtp_2
XTAP_TAPCELL_ROW_97_1590 VGND VPWR sky130_fd_sc_hd__tapvpwrvgnd_1
X_8141_ _8271_/A _8345_/A VGND VGND VPWR VPWR _8141_/Y sky130_fd_sc_hd__nand2_2
X_5353_ _6279_/C VGND VGND VPWR VPWR _5353_/X sky130_fd_sc_hd__clkbuf_2
X_8072_ _8072_/A _8072_/B VGND VGND VPWR VPWR _8073_/B sky130_fd_sc_hd__xor2_2
XFILLER_114_565 VGND VGND VPWR VPWR sky130_fd_sc_hd__decap_3
X_5284_ _5348_/S _5197_/A _6758_/B VGND VGND VPWR VPWR _5284_/Y sky130_fd_sc_hd__a21oi_2
X_7023_ _7279_/A _7278_/B VGND VGND VPWR VPWR _7024_/B sky130_fd_sc_hd__xnor2_2
XFILLER_87_438 VGND VGND VPWR VPWR sky130_fd_sc_hd__decap_3
XFILLER_59_129 VGND VGND VPWR VPWR sky130_fd_sc_hd__decap_3
XFILLER_87_449 VGND VGND VPWR VPWR sky130_fd_sc_hd__fill_1
XFILLER_68_663 VGND VGND VPWR VPWR sky130_fd_sc_hd__decap_3
XFILLER_114_27 VGND VGND VPWR VPWR sky130_fd_sc_hd__fill_1
XFILLER_114_38 VGND VGND VPWR VPWR sky130_fd_sc_hd__decap_3
XFILLER_68_696 VGND VGND VPWR VPWR sky130_fd_sc_hd__decap_3
XFILLER_28_538 VGND VGND VPWR VPWR sky130_fd_sc_hd__decap_3
X_8974_ _9328_/Q _8974_/A1 _8988_/S VGND VGND VPWR VPWR _8974_/X sky130_fd_sc_hd__mux2_2
XFILLER_55_346 VGND VGND VPWR VPWR sky130_fd_sc_hd__decap_3
XFILLER_43_508 VGND VGND VPWR VPWR sky130_fd_sc_hd__decap_3
X_7925_ _9217_/Q _8099_/C _7924_/X VGND VGND VPWR VPWR _7926_/B sky130_fd_sc_hd__o21ai_2
XFILLER_82_154 VGND VGND VPWR VPWR sky130_fd_sc_hd__decap_3
XFILLER_55_379 VGND VGND VPWR VPWR sky130_fd_sc_hd__decap_3
XFILLER_130_15 VGND VGND VPWR VPWR sky130_fd_sc_hd__decap_3
XFILLER_24_711 VGND VGND VPWR VPWR sky130_fd_sc_hd__decap_3
XFILLER_70_327 VGND VGND VPWR VPWR sky130_fd_sc_hd__decap_3
XFILLER_23_210 VGND VGND VPWR VPWR sky130_fd_sc_hd__decap_3
X_7856_ _7856_/A _7856_/B VGND VGND VPWR VPWR _7856_/X sky130_fd_sc_hd__and2_2
XFILLER_70_349 VGND VGND VPWR VPWR sky130_fd_sc_hd__decap_3
XFILLER_24_744 VGND VGND VPWR VPWR sky130_fd_sc_hd__decap_3
XFILLER_23_221 VGND VGND VPWR VPWR sky130_fd_sc_hd__decap_3
XFILLER_90_19 VGND VGND VPWR VPWR sky130_fd_sc_hd__fill_1
XFILLER_24_766 VGND VGND VPWR VPWR sky130_fd_sc_hd__decap_3
X_6807_ _6807_/A _6812_/S VGND VGND VPWR VPWR _6807_/X sky130_fd_sc_hd__or2_2
XFILLER_11_405 VGND VGND VPWR VPWR sky130_fd_sc_hd__decap_3
X_7787_ _8240_/A _8231_/A _7787_/C VGND VGND VPWR VPWR _7787_/X sky130_fd_sc_hd__or3_2
X_4999_ _5473_/D VGND VGND VPWR VPWR _5742_/D sky130_fd_sc_hd__buf_12
XFILLER_51_596 VGND VGND VPWR VPWR sky130_fd_sc_hd__fill_1
XFILLER_23_287 VGND VGND VPWR VPWR sky130_fd_sc_hd__fill_2
XFILLER_23_24 VGND VGND VPWR VPWR sky130_fd_sc_hd__fill_1
X_6738_ _6616_/A _6616_/B _6739_/A VGND VGND VPWR VPWR _6764_/A sky130_fd_sc_hd__a21o_2
XFILLER_11_449 VGND VGND VPWR VPWR sky130_fd_sc_hd__decap_3
XFILLER_23_57 VGND VGND VPWR VPWR sky130_fd_sc_hd__decap_3
XFILLER_23_79 VGND VGND VPWR VPWR sky130_fd_sc_hd__decap_3
XFILLER_128_6 VGND VGND VPWR VPWR sky130_fd_sc_hd__decap_3
X_6669_ _6669_/A _6669_/B _6669_/C VGND VGND VPWR VPWR _6670_/B sky130_fd_sc_hd__and3_2
X_8408_ _8408_/A _8408_/B _8408_/C _8408_/D VGND VGND VPWR VPWR _8408_/Y sky130_fd_sc_hd__nor4_2
XFILLER_3_604 VGND VGND VPWR VPWR sky130_fd_sc_hd__decap_3
XFILLER_3_626 VGND VGND VPWR VPWR sky130_fd_sc_hd__decap_3
XFILLER_2_103 VGND VGND VPWR VPWR sky130_fd_sc_hd__decap_3
X_8339_ _8254_/A _8254_/B _8338_/X VGND VGND VPWR VPWR _8353_/A sky130_fd_sc_hd__o21a_2
XTAP_TAPCELL_ROW_57_1051 VGND VPWR sky130_fd_sc_hd__tapvpwrvgnd_1
XFILLER_3_659 VGND VGND VPWR VPWR sky130_fd_sc_hd__decap_3
XFILLER_2_136 VGND VGND VPWR VPWR sky130_fd_sc_hd__decap_3
XFILLER_78_438 VGND VGND VPWR VPWR sky130_fd_sc_hd__decap_3
XFILLER_48_21 VGND VGND VPWR VPWR sky130_fd_sc_hd__decap_3
XFILLER_48_32 VGND VGND VPWR VPWR sky130_fd_sc_hd__decap_3
XFILLER_48_65 VGND VGND VPWR VPWR sky130_fd_sc_hd__decap_3
XFILLER_86_460 VGND VGND VPWR VPWR sky130_fd_sc_hd__decap_3
XFILLER_74_622 VGND VGND VPWR VPWR sky130_fd_sc_hd__decap_3
XTAP_TAPCELL_ROW_109_1748 VGND VPWR sky130_fd_sc_hd__tapvpwrvgnd_1
XFILLER_19_549 VGND VGND VPWR VPWR sky130_fd_sc_hd__decap_3
XTAP_TAPCELL_ROW_109_1759 VGND VPWR sky130_fd_sc_hd__tapvpwrvgnd_1
XFILLER_73_132 VGND VGND VPWR VPWR sky130_fd_sc_hd__decap_3
XFILLER_74_677 VGND VGND VPWR VPWR sky130_fd_sc_hd__decap_3
XFILLER_46_368 VGND VGND VPWR VPWR sky130_fd_sc_hd__decap_3
XFILLER_15_700 VGND VGND VPWR VPWR sky130_fd_sc_hd__decap_3
XFILLER_61_327 VGND VGND VPWR VPWR sky130_fd_sc_hd__decap_3
XTAP_TAPCELL_ROW_122_1926 VGND VPWR sky130_fd_sc_hd__tapvpwrvgnd_1
XFILLER_27_582 VGND VGND VPWR VPWR sky130_fd_sc_hd__decap_3
XFILLER_73_198 VGND VGND VPWR VPWR sky130_fd_sc_hd__decap_3
XFILLER_14_210 VGND VGND VPWR VPWR sky130_fd_sc_hd__decap_3
XFILLER_61_349 VGND VGND VPWR VPWR sky130_fd_sc_hd__decap_3
XFILLER_15_744 VGND VGND VPWR VPWR sky130_fd_sc_hd__decap_3
XFILLER_54_390 VGND VGND VPWR VPWR sky130_fd_sc_hd__decap_3
XTAP_TAPCELL_ROW_32_709 VGND VPWR sky130_fd_sc_hd__tapvpwrvgnd_1
XFILLER_9_15 VGND VGND VPWR VPWR sky130_fd_sc_hd__decap_3
XFILLER_9_48 VGND VGND VPWR VPWR sky130_fd_sc_hd__decap_3
XFILLER_30_736 VGND VGND VPWR VPWR sky130_fd_sc_hd__decap_3
XFILLER_14_287 VGND VGND VPWR VPWR sky130_fd_sc_hd__decap_3
XTAP_TAPCELL_ROW_81_1380 VGND VPWR sky130_fd_sc_hd__tapvpwrvgnd_1
XFILLER_30_769 VGND VGND VPWR VPWR sky130_fd_sc_hd__decap_3
XTAP_TAPCELL_ROW_12_444 VGND VPWR sky130_fd_sc_hd__tapvpwrvgnd_1
XFILLER_128_613 VGND VGND VPWR VPWR sky130_fd_sc_hd__decap_3
XFILLER_80_96 VGND VGND VPWR VPWR sky130_fd_sc_hd__fill_2
XFILLER_128_657 VGND VGND VPWR VPWR sky130_fd_sc_hd__decap_3
XFILLER_127_134 VGND VGND VPWR VPWR sky130_fd_sc_hd__decap_3
XFILLER_6_442 VGND VGND VPWR VPWR sky130_fd_sc_hd__decap_3
XFILLER_127_167 VGND VGND VPWR VPWR sky130_fd_sc_hd__fill_1
XFILLER_129_90 VGND VGND VPWR VPWR sky130_fd_sc_hd__decap_3
XFILLER_127_178 VGND VGND VPWR VPWR sky130_fd_sc_hd__decap_3
XFILLER_123_340 VGND VGND VPWR VPWR sky130_fd_sc_hd__decap_3
XFILLER_2_681 VGND VGND VPWR VPWR sky130_fd_sc_hd__decap_3
XFILLER_96_235 VGND VGND VPWR VPWR sky130_fd_sc_hd__decap_3
XFILLER_69_449 VGND VGND VPWR VPWR sky130_fd_sc_hd__decap_3
XFILLER_96_268 VGND VGND VPWR VPWR sky130_fd_sc_hd__fill_1
Xclkbuf_leaf_1_clk clkload0/A VGND VGND VPWR VPWR _9338_/CLK sky130_fd_sc_hd__clkbuf_8
XFILLER_37_313 VGND VGND VPWR VPWR sky130_fd_sc_hd__decap_3
XFILLER_65_644 VGND VGND VPWR VPWR sky130_fd_sc_hd__decap_3
XFILLER_37_357 VGND VGND VPWR VPWR sky130_fd_sc_hd__decap_3
XTAP_TAPCELL_ROW_84_1409 VGND VPWR sky130_fd_sc_hd__tapvpwrvgnd_1
XFILLER_25_508 VGND VGND VPWR VPWR sky130_fd_sc_hd__fill_2
X_5971_ _5973_/A _5973_/B _5820_/B VGND VGND VPWR VPWR _5971_/X sky130_fd_sc_hd__o21a_2
XFILLER_92_474 VGND VGND VPWR VPWR sky130_fd_sc_hd__fill_2
X_7710_ _7893_/A _7893_/C VGND VGND VPWR VPWR _7710_/X sky130_fd_sc_hd__or2_2
X_4922_ _5879_/B VGND VGND VPWR VPWR _5262_/B sky130_fd_sc_hd__buf_4
X_8690_ _8690_/A _8755_/B VGND VGND VPWR VPWR _8690_/Y sky130_fd_sc_hd__nand2_2
XFILLER_80_669 VGND VGND VPWR VPWR sky130_fd_sc_hd__fill_2
XFILLER_45_390 VGND VGND VPWR VPWR sky130_fd_sc_hd__fill_2
XFILLER_33_552 VGND VGND VPWR VPWR sky130_fd_sc_hd__decap_3
XFILLER_100_18 VGND VGND VPWR VPWR sky130_fd_sc_hd__fill_2
X_7641_ _7484_/A _7643_/B _7640_/X _9214_/Q VGND VGND VPWR VPWR _7641_/X sky130_fd_sc_hd__o211a_2
XFILLER_21_714 VGND VGND VPWR VPWR sky130_fd_sc_hd__decap_3
X_4853_ hold950/X _9155_/Q _4861_/S VGND VGND VPWR VPWR _4853_/X sky130_fd_sc_hd__mux2_2
XFILLER_60_360 VGND VGND VPWR VPWR sky130_fd_sc_hd__decap_3
XFILLER_21_747 VGND VGND VPWR VPWR sky130_fd_sc_hd__decap_3
XFILLER_60_393 VGND VGND VPWR VPWR sky130_fd_sc_hd__fill_2
X_7572_ wire88/X _7449_/A _7805_/A VGND VGND VPWR VPWR _7572_/X sky130_fd_sc_hd__a21o_2
X_4784_ _9138_/Q hold880/X _4798_/S VGND VGND VPWR VPWR _4784_/X sky130_fd_sc_hd__mux2_2
X_9311_ _9343_/CLK _9311_/D load_slew397/X VGND VGND VPWR VPWR _9311_/Q sky130_fd_sc_hd__dfrtp_2
X_6523_ _6523_/A _6523_/B _6384_/B1 VGND VGND VPWR VPWR _6523_/X sky130_fd_sc_hd__or3b_4
XFILLER_118_112 VGND VGND VPWR VPWR sky130_fd_sc_hd__decap_3
XFILLER_109_27 VGND VGND VPWR VPWR sky130_fd_sc_hd__decap_3
X_9242_ clkload3/A _9242_/D load_slew374/X VGND VGND VPWR VPWR _9242_/Q sky130_fd_sc_hd__dfrtp_2
XFILLER_119_679 VGND VGND VPWR VPWR sky130_fd_sc_hd__fill_2
X_6454_ _6455_/A _6455_/B VGND VGND VPWR VPWR _6456_/A sky130_fd_sc_hd__nor2_2
X_5405_ _5307_/A _5307_/B _5404_/X VGND VGND VPWR VPWR _5405_/Y sky130_fd_sc_hd__o21ai_2
X_9173_ _9313_/CLK _9173_/D fanout387/X VGND VGND VPWR VPWR _9173_/Q sky130_fd_sc_hd__dfrtp_2
X_6385_ _6385_/A _6385_/B _6385_/C VGND VGND VPWR VPWR _6385_/X sky130_fd_sc_hd__or3_4
X_8124_ _8248_/B VGND VGND VPWR VPWR _8350_/B sky130_fd_sc_hd__clkbuf_2
XFILLER_0_607 VGND VGND VPWR VPWR sky130_fd_sc_hd__decap_3
X_5336_ _5525_/A _5525_/B VGND VGND VPWR VPWR _5337_/B sky130_fd_sc_hd__and2_2
XFILLER_114_351 VGND VGND VPWR VPWR sky130_fd_sc_hd__decap_3
XFILLER_102_502 VGND VGND VPWR VPWR sky130_fd_sc_hd__decap_3
XFILLER_114_362 VGND VGND VPWR VPWR sky130_fd_sc_hd__fill_2
XFILLER_0_629 VGND VGND VPWR VPWR sky130_fd_sc_hd__decap_3
XFILLER_102_513 VGND VGND VPWR VPWR sky130_fd_sc_hd__decap_3
XFILLER_125_15 VGND VGND VPWR VPWR sky130_fd_sc_hd__decap_3
XPHY_EDGE_ROW_10_Left_141 VGND VGND VPWR VPWR sky130_fd_sc_hd__decap_3
XFILLER_88_747 VGND VGND VPWR VPWR sky130_fd_sc_hd__decap_3
X_8055_ _8405_/A wire88/X VGND VGND VPWR VPWR _8057_/B sky130_fd_sc_hd__nand2_2
XFILLER_125_48 VGND VGND VPWR VPWR sky130_fd_sc_hd__decap_3
XFILLER_114_395 VGND VGND VPWR VPWR sky130_fd_sc_hd__decap_3
XFILLER_102_546 VGND VGND VPWR VPWR sky130_fd_sc_hd__decap_3
X_5267_ _5267_/A _5267_/B VGND VGND VPWR VPWR _5267_/X sky130_fd_sc_hd__and2_2
X_7006_ _6690_/A _6690_/B _7003_/X _7004_/X VGND VGND VPWR VPWR _7006_/X sky130_fd_sc_hd__o211a_2
XFILLER_87_279 VGND VGND VPWR VPWR sky130_fd_sc_hd__fill_1
X_5198_ _5197_/A _5283_/B VGND VGND VPWR VPWR _5198_/X sky130_fd_sc_hd__and2b_2
XFILLER_18_24 VGND VGND VPWR VPWR sky130_fd_sc_hd__decap_3
XFILLER_56_633 VGND VGND VPWR VPWR sky130_fd_sc_hd__decap_3
XFILLER_28_368 VGND VGND VPWR VPWR sky130_fd_sc_hd__decap_3
XFILLER_56_688 VGND VGND VPWR VPWR sky130_fd_sc_hd__decap_3
X_8957_ hold912/X _8957_/A1 _8967_/S VGND VGND VPWR VPWR _8958_/A sky130_fd_sc_hd__mux2_2
XFILLER_83_485 VGND VGND VPWR VPWR sky130_fd_sc_hd__decap_3
X_7908_ _7908_/A VGND VGND VPWR VPWR _7908_/X sky130_fd_sc_hd__clkbuf_1
XFILLER_43_349 VGND VGND VPWR VPWR sky130_fd_sc_hd__decap_3
X_8888_ _8921_/A1 _8888_/A1 _8904_/S VGND VGND VPWR VPWR _8889_/A sky130_fd_sc_hd__mux2_2
XFILLER_24_552 VGND VGND VPWR VPWR sky130_fd_sc_hd__decap_3
XFILLER_70_168 VGND VGND VPWR VPWR sky130_fd_sc_hd__decap_3
X_7839_ _7913_/A _7836_/C _7924_/A VGND VGND VPWR VPWR _7839_/X sky130_fd_sc_hd__mux2_2
XFILLER_24_574 VGND VGND VPWR VPWR sky130_fd_sc_hd__decap_3
XTAP_TAPCELL_ROW_104_1689 VGND VPWR sky130_fd_sc_hd__tapvpwrvgnd_1
XFILLER_12_725 VGND VGND VPWR VPWR sky130_fd_sc_hd__decap_3
XFILLER_51_393 VGND VGND VPWR VPWR sky130_fd_sc_hd__decap_3
XFILLER_8_707 VGND VGND VPWR VPWR sky130_fd_sc_hd__decap_3
XFILLER_12_769 VGND VGND VPWR VPWR sky130_fd_sc_hd__decap_3
Xclkload0 clkload0/A VGND VGND VPWR VPWR clkload0/Y sky130_fd_sc_hd__clkinvlp_4
Xwire126 _7043_/A VGND VGND VPWR VPWR _6010_/A sky130_fd_sc_hd__buf_6
XFILLER_7_217 VGND VGND VPWR VPWR sky130_fd_sc_hd__decap_3
XFILLER_7_228 VGND VGND VPWR VPWR sky130_fd_sc_hd__decap_3
Xwire148 _5890_/Y VGND VGND VPWR VPWR wire148/X sky130_fd_sc_hd__buf_6
XFILLER_7_239 VGND VGND VPWR VPWR sky130_fd_sc_hd__decap_3
XFILLER_126_3 VGND VGND VPWR VPWR sky130_fd_sc_hd__decap_3
XFILLER_50_44 VGND VGND VPWR VPWR sky130_fd_sc_hd__decap_3
Xwire159 wire160/X VGND VGND VPWR VPWR _5165_/A sky130_fd_sc_hd__buf_1
XFILLER_124_115 VGND VGND VPWR VPWR sky130_fd_sc_hd__decap_3
XFILLER_3_445 VGND VGND VPWR VPWR sky130_fd_sc_hd__decap_3
XFILLER_124_159 VGND VGND VPWR VPWR sky130_fd_sc_hd__decap_3
XFILLER_105_351 VGND VGND VPWR VPWR sky130_fd_sc_hd__fill_1
XFILLER_105_384 VGND VGND VPWR VPWR sky130_fd_sc_hd__decap_3
XFILLER_79_747 VGND VGND VPWR VPWR sky130_fd_sc_hd__decap_3
XFILLER_66_408 VGND VGND VPWR VPWR sky130_fd_sc_hd__decap_3
XFILLER_120_365 VGND VGND VPWR VPWR sky130_fd_sc_hd__fill_2
XFILLER_93_205 VGND VGND VPWR VPWR sky130_fd_sc_hd__decap_3
Xfanout270 _9222_/Q VGND VGND VPWR VPWR _8446_/A sky130_fd_sc_hd__clkdlybuf4s25_1
XFILLER_47_611 VGND VGND VPWR VPWR sky130_fd_sc_hd__decap_3
XFILLER_19_302 VGND VGND VPWR VPWR sky130_fd_sc_hd__decap_3
Xfanout292 _7729_/C1 VGND VGND VPWR VPWR _6501_/A sky130_fd_sc_hd__dlymetal6s4s_1
XFILLER_115_81 VGND VGND VPWR VPWR sky130_fd_sc_hd__decap_3
XFILLER_75_52 VGND VGND VPWR VPWR sky130_fd_sc_hd__decap_3
XFILLER_46_121 VGND VGND VPWR VPWR sky130_fd_sc_hd__decap_3
XFILLER_19_335 VGND VGND VPWR VPWR sky130_fd_sc_hd__fill_1
XFILLER_46_154 VGND VGND VPWR VPWR sky130_fd_sc_hd__fill_2
XTAP_TAPCELL_ROW_17_514 VGND VPWR sky130_fd_sc_hd__tapvpwrvgnd_1
XFILLER_61_113 VGND VGND VPWR VPWR sky130_fd_sc_hd__decap_3
XFILLER_62_658 VGND VGND VPWR VPWR sky130_fd_sc_hd__decap_3
XFILLER_15_552 VGND VGND VPWR VPWR sky130_fd_sc_hd__decap_3
XTAP_TAPCELL_ROW_45_889 VGND VPWR sky130_fd_sc_hd__tapvpwrvgnd_1
XFILLER_70_680 VGND VGND VPWR VPWR sky130_fd_sc_hd__decap_3
XFILLER_42_371 VGND VGND VPWR VPWR sky130_fd_sc_hd__decap_3
XFILLER_30_511 VGND VGND VPWR VPWR sky130_fd_sc_hd__decap_3
XFILLER_15_596 VGND VGND VPWR VPWR sky130_fd_sc_hd__decap_3
XFILLER_30_533 VGND VGND VPWR VPWR sky130_fd_sc_hd__fill_2
XFILLER_30_555 VGND VGND VPWR VPWR sky130_fd_sc_hd__decap_3
XFILLER_7_762 VGND VGND VPWR VPWR sky130_fd_sc_hd__decap_3
XFILLER_6_250 VGND VGND VPWR VPWR sky130_fd_sc_hd__fill_2
XFILLER_115_104 VGND VGND VPWR VPWR sky130_fd_sc_hd__decap_3
XFILLER_41_3 VGND VGND VPWR VPWR sky130_fd_sc_hd__decap_3
X_6170_ _6169_/B _6172_/C _6172_/A VGND VGND VPWR VPWR _6170_/X sky130_fd_sc_hd__a21o_2
XFILLER_97_500 VGND VGND VPWR VPWR sky130_fd_sc_hd__decap_3
XFILLER_97_511 VGND VGND VPWR VPWR sky130_fd_sc_hd__decap_3
XFILLER_69_213 VGND VGND VPWR VPWR sky130_fd_sc_hd__decap_3
X_5121_ _9165_/Q _4516_/A _5117_/Y _5118_/X _5120_/X VGND VGND VPWR VPWR _5123_/C
+ sky130_fd_sc_hd__a221o_2
XFILLER_97_544 VGND VGND VPWR VPWR sky130_fd_sc_hd__decap_3
XFILLER_123_181 VGND VGND VPWR VPWR sky130_fd_sc_hd__decap_3
XFILLER_111_332 VGND VGND VPWR VPWR sky130_fd_sc_hd__fill_1
XFILLER_69_257 VGND VGND VPWR VPWR sky130_fd_sc_hd__decap_3
X_5052_ _9052_/Q _5875_/B _5878_/C _9288_/Q VGND VGND VPWR VPWR _5052_/X sky130_fd_sc_hd__a22o_2
XPHY_EDGE_ROW_127_Right_127 VGND VGND VPWR VPWR sky130_fd_sc_hd__decap_3
XFILLER_84_205 VGND VGND VPWR VPWR sky130_fd_sc_hd__decap_3
XFILLER_69_279 VGND VGND VPWR VPWR sky130_fd_sc_hd__fill_1
XFILLER_38_611 VGND VGND VPWR VPWR sky130_fd_sc_hd__decap_3
XFILLER_38_655 VGND VGND VPWR VPWR sky130_fd_sc_hd__decap_3
XFILLER_1_60 VGND VGND VPWR VPWR sky130_fd_sc_hd__decap_3
X_8811_ _8811_/A VGND VGND VPWR VPWR _9250_/D sky130_fd_sc_hd__buf_1
XFILLER_65_474 VGND VGND VPWR VPWR sky130_fd_sc_hd__decap_3
XFILLER_38_688 VGND VGND VPWR VPWR sky130_fd_sc_hd__decap_3
XFILLER_37_165 VGND VGND VPWR VPWR sky130_fd_sc_hd__decap_3
XFILLER_1_82 VGND VGND VPWR VPWR sky130_fd_sc_hd__decap_3
XFILLER_38_699 VGND VGND VPWR VPWR sky130_fd_sc_hd__fill_1
XFILLER_92_271 VGND VGND VPWR VPWR sky130_fd_sc_hd__decap_3
XFILLER_52_113 VGND VGND VPWR VPWR sky130_fd_sc_hd__fill_1
X_8742_ _8753_/A _8742_/B VGND VGND VPWR VPWR _8768_/B sky130_fd_sc_hd__xnor2_2
X_5954_ _6094_/B _6083_/B VGND VGND VPWR VPWR _5954_/Y sky130_fd_sc_hd__nand2_2
XFILLER_111_39 VGND VGND VPWR VPWR sky130_fd_sc_hd__decap_3
XFILLER_80_466 VGND VGND VPWR VPWR sky130_fd_sc_hd__decap_3
XFILLER_52_157 VGND VGND VPWR VPWR sky130_fd_sc_hd__decap_3
X_4905_ _9224_/Q _4907_/B VGND VGND VPWR VPWR _4905_/Y sky130_fd_sc_hd__nor2_2
XFILLER_80_488 VGND VGND VPWR VPWR sky130_fd_sc_hd__decap_3
X_8673_ _8676_/B _8676_/C VGND VGND VPWR VPWR _8673_/Y sky130_fd_sc_hd__nor2_2
X_5885_ _5990_/A _5885_/B _5885_/C VGND VGND VPWR VPWR _5890_/C sky130_fd_sc_hd__and3_2
X_7624_ _7624_/A _7624_/B _7624_/C VGND VGND VPWR VPWR _7626_/A sky130_fd_sc_hd__and3_4
XFILLER_33_393 VGND VGND VPWR VPWR sky130_fd_sc_hd__fill_1
X_4836_ hold974/X _9147_/Q _4840_/S VGND VGND VPWR VPWR _4836_/X sky130_fd_sc_hd__mux2_2
X_7555_ _7556_/A _7556_/B _7556_/C VGND VGND VPWR VPWR _7558_/A sky130_fd_sc_hd__a21o_2
X_4767_ _9130_/Q hold998/X _4777_/S VGND VGND VPWR VPWR _4767_/X sky130_fd_sc_hd__mux2_2
X_6506_ _6506_/A _6506_/B VGND VGND VPWR VPWR _6506_/Y sky130_fd_sc_hd__xnor2_4
X_7486_ _7486_/A _7486_/B _7486_/C _7486_/D VGND VGND VPWR VPWR _7639_/B sky130_fd_sc_hd__nand4_2
X_4698_ _9097_/Q hold890/X _4714_/S VGND VGND VPWR VPWR _4698_/X sky130_fd_sc_hd__mux2_2
XFILLER_119_487 VGND VGND VPWR VPWR sky130_fd_sc_hd__decap_3
XFILLER_112_9 VGND VGND VPWR VPWR sky130_fd_sc_hd__decap_3
X_9225_ _9227_/CLK _9225_/D load_slew416/X VGND VGND VPWR VPWR _9225_/Q sky130_fd_sc_hd__dfrtp_2
X_6437_ _5034_/A _6436_/Y _5950_/X _5034_/B _6807_/A VGND VGND VPWR VPWR _6437_/X
+ sky130_fd_sc_hd__a221o_2
XFILLER_20_47 VGND VGND VPWR VPWR sky130_fd_sc_hd__decap_3
X_9156_ _9296_/CLK _9156_/D load_slew386/X VGND VGND VPWR VPWR _9156_/Q sky130_fd_sc_hd__dfrtp_2
X_6368_ _6368_/A _6368_/B VGND VGND VPWR VPWR _6370_/A sky130_fd_sc_hd__and2_2
XTAP_TAPCELL_ROW_54_1010 VGND VPWR sky130_fd_sc_hd__tapvpwrvgnd_1
XFILLER_96_29 VGND VGND VPWR VPWR sky130_fd_sc_hd__decap_3
XFILLER_88_522 VGND VGND VPWR VPWR sky130_fd_sc_hd__decap_3
X_8107_ wire66/A _8098_/X _8101_/X _8102_/X _8106_/Y VGND VGND VPWR VPWR wire44/A
+ sky130_fd_sc_hd__a2111oi_2
X_5319_ _5949_/B _5656_/A VGND VGND VPWR VPWR _5319_/Y sky130_fd_sc_hd__nand2_2
XFILLER_114_181 VGND VGND VPWR VPWR sky130_fd_sc_hd__decap_3
X_9087_ _9135_/CLK _9087_/D load_slew396/X VGND VGND VPWR VPWR _9087_/Q sky130_fd_sc_hd__dfrtp_2
XFILLER_130_641 VGND VGND VPWR VPWR sky130_fd_sc_hd__decap_3
X_6299_ _6290_/A _6203_/A _6203_/B VGND VGND VPWR VPWR _6299_/X sky130_fd_sc_hd__o21a_2
XFILLER_88_555 VGND VGND VPWR VPWR sky130_fd_sc_hd__fill_2
XFILLER_29_34 VGND VGND VPWR VPWR sky130_fd_sc_hd__decap_3
XFILLER_130_663 VGND VGND VPWR VPWR sky130_fd_sc_hd__decap_3
XFILLER_102_365 VGND VGND VPWR VPWR sky130_fd_sc_hd__decap_3
X_8038_ _8038_/A _8038_/B VGND VGND VPWR VPWR _8039_/B sky130_fd_sc_hd__xnor2_2
XFILLER_102_376 VGND VGND VPWR VPWR sky130_fd_sc_hd__fill_2
XFILLER_76_739 VGND VGND VPWR VPWR sky130_fd_sc_hd__decap_3
XFILLER_130_685 VGND VGND VPWR VPWR sky130_fd_sc_hd__decap_3
XFILLER_29_611 VGND VGND VPWR VPWR sky130_fd_sc_hd__decap_3
XFILLER_56_430 VGND VGND VPWR VPWR sky130_fd_sc_hd__decap_3
XTAP_TAPCELL_ROW_106_1707 VGND VPWR sky130_fd_sc_hd__tapvpwrvgnd_1
XTAP_TAPCELL_ROW_106_1718 VGND VPWR sky130_fd_sc_hd__tapvpwrvgnd_1
XFILLER_56_474 VGND VGND VPWR VPWR sky130_fd_sc_hd__fill_2
XFILLER_28_165 VGND VGND VPWR VPWR sky130_fd_sc_hd__decap_3
XFILLER_45_33 VGND VGND VPWR VPWR sky130_fd_sc_hd__decap_3
XFILLER_44_625 VGND VGND VPWR VPWR sky130_fd_sc_hd__decap_3
XFILLER_29_699 VGND VGND VPWR VPWR sky130_fd_sc_hd__decap_3
XFILLER_71_422 VGND VGND VPWR VPWR sky130_fd_sc_hd__decap_3
XFILLER_16_327 VGND VGND VPWR VPWR sky130_fd_sc_hd__decap_3
XFILLER_45_55 VGND VGND VPWR VPWR sky130_fd_sc_hd__fill_1
XFILLER_43_146 VGND VGND VPWR VPWR sky130_fd_sc_hd__decap_3
XFILLER_31_308 VGND VGND VPWR VPWR sky130_fd_sc_hd__decap_3
XTAP_TAPCELL_ROW_65_1161 VGND VPWR sky130_fd_sc_hd__tapvpwrvgnd_1
XFILLER_24_360 VGND VGND VPWR VPWR sky130_fd_sc_hd__decap_3
XFILLER_12_500 VGND VGND VPWR VPWR sky130_fd_sc_hd__decap_3
XFILLER_71_499 VGND VGND VPWR VPWR sky130_fd_sc_hd__decap_3
XFILLER_24_371 VGND VGND VPWR VPWR sky130_fd_sc_hd__decap_3
XTAP_TAPCELL_ROW_42_848 VGND VPWR sky130_fd_sc_hd__tapvpwrvgnd_1
XFILLER_52_691 VGND VGND VPWR VPWR sky130_fd_sc_hd__decap_3
XFILLER_61_21 VGND VGND VPWR VPWR sky130_fd_sc_hd__decap_3
XFILLER_12_533 VGND VGND VPWR VPWR sky130_fd_sc_hd__decap_3
XFILLER_12_566 VGND VGND VPWR VPWR sky130_fd_sc_hd__decap_3
XFILLER_8_526 VGND VGND VPWR VPWR sky130_fd_sc_hd__decap_3
XFILLER_61_65 VGND VGND VPWR VPWR sky130_fd_sc_hd__decap_3
XTAP_TAPCELL_ROW_22_572 VGND VPWR sky130_fd_sc_hd__tapvpwrvgnd_1
XFILLER_8_548 VGND VGND VPWR VPWR sky130_fd_sc_hd__decap_3
XTAP_TAPCELL_ROW_22_583 VGND VPWR sky130_fd_sc_hd__tapvpwrvgnd_1
XFILLER_6_27 VGND VGND VPWR VPWR sky130_fd_sc_hd__fill_1
XFILLER_6_38 VGND VGND VPWR VPWR sky130_fd_sc_hd__decap_3
XFILLER_4_710 VGND VGND VPWR VPWR sky130_fd_sc_hd__decap_3
XTAP_TAPCELL_ROW_117_1858 VGND VPWR sky130_fd_sc_hd__tapvpwrvgnd_1
XFILLER_4_743 VGND VGND VPWR VPWR sky130_fd_sc_hd__decap_3
XFILLER_3_220 VGND VGND VPWR VPWR sky130_fd_sc_hd__decap_3
XFILLER_3_231 VGND VGND VPWR VPWR sky130_fd_sc_hd__decap_3
XFILLER_79_511 VGND VGND VPWR VPWR sky130_fd_sc_hd__decap_3
XFILLER_106_693 VGND VGND VPWR VPWR sky130_fd_sc_hd__decap_3
XFILLER_79_544 VGND VGND VPWR VPWR sky130_fd_sc_hd__decap_3
XFILLER_126_80 VGND VGND VPWR VPWR sky130_fd_sc_hd__decap_3
XFILLER_86_40 VGND VGND VPWR VPWR sky130_fd_sc_hd__decap_3
XFILLER_39_408 VGND VGND VPWR VPWR sky130_fd_sc_hd__decap_3
XFILLER_126_91 VGND VGND VPWR VPWR sky130_fd_sc_hd__decap_3
XFILLER_79_588 VGND VGND VPWR VPWR sky130_fd_sc_hd__decap_3
XFILLER_120_162 VGND VGND VPWR VPWR sky130_fd_sc_hd__decap_3
XFILLER_94_536 VGND VGND VPWR VPWR sky130_fd_sc_hd__decap_3
XFILLER_120_195 VGND VGND VPWR VPWR sky130_fd_sc_hd__fill_1
XFILLER_75_761 VGND VGND VPWR VPWR sky130_fd_sc_hd__decap_3
XFILLER_47_474 VGND VGND VPWR VPWR sky130_fd_sc_hd__decap_3
XFILLER_35_614 VGND VGND VPWR VPWR sky130_fd_sc_hd__fill_2
XFILLER_19_165 VGND VGND VPWR VPWR sky130_fd_sc_hd__decap_3
XFILLER_34_102 VGND VGND VPWR VPWR sky130_fd_sc_hd__decap_3
XFILLER_35_636 VGND VGND VPWR VPWR sky130_fd_sc_hd__decap_3
XFILLER_34_113 VGND VGND VPWR VPWR sky130_fd_sc_hd__decap_3
XFILLER_62_433 VGND VGND VPWR VPWR sky130_fd_sc_hd__decap_3
XFILLER_50_606 VGND VGND VPWR VPWR sky130_fd_sc_hd__decap_3
XFILLER_62_466 VGND VGND VPWR VPWR sky130_fd_sc_hd__decap_3
XFILLER_62_477 VGND VGND VPWR VPWR sky130_fd_sc_hd__decap_3
XFILLER_62_499 VGND VGND VPWR VPWR sky130_fd_sc_hd__decap_3
XFILLER_15_360 VGND VGND VPWR VPWR sky130_fd_sc_hd__fill_1
XFILLER_43_691 VGND VGND VPWR VPWR sky130_fd_sc_hd__decap_3
XFILLER_15_393 VGND VGND VPWR VPWR sky130_fd_sc_hd__decap_3
X_5670_ _5671_/A _5671_/B VGND VGND VPWR VPWR _5670_/Y sky130_fd_sc_hd__nor2_2
XFILLER_30_341 VGND VGND VPWR VPWR sky130_fd_sc_hd__decap_3
XFILLER_89_3 VGND VGND VPWR VPWR sky130_fd_sc_hd__decap_3
XFILLER_30_363 VGND VGND VPWR VPWR sky130_fd_sc_hd__fill_1
X_4621_ hold956/X _4621_/A1 _4629_/S VGND VGND VPWR VPWR _4622_/A sky130_fd_sc_hd__mux2_2
XFILLER_30_374 VGND VGND VPWR VPWR sky130_fd_sc_hd__decap_3
XFILLER_129_741 VGND VGND VPWR VPWR sky130_fd_sc_hd__decap_3
X_7340_ _7337_/Y _7340_/B _7340_/C VGND VGND VPWR VPWR _7342_/A sky130_fd_sc_hd__nand3b_2
XFILLER_129_774 VGND VGND VPWR VPWR sky130_fd_sc_hd__decap_3
X_4552_ hold983/X _9007_/A0 _4566_/S VGND VGND VPWR VPWR _4553_/A sky130_fd_sc_hd__mux2_2
Xmax_cap201 _5952_/A VGND VGND VPWR VPWR _6091_/A sky130_fd_sc_hd__buf_6
Xmax_cap212 _5718_/B VGND VGND VPWR VPWR _5464_/A1 sky130_fd_sc_hd__buf_2
X_7271_ hold807/X _7270_/Y _7560_/S VGND VGND VPWR VPWR _7271_/X sky130_fd_sc_hd__mux2_2
XTAP_TAPCELL_ROW_92_1519 VGND VPWR sky130_fd_sc_hd__tapvpwrvgnd_1
XFILLER_116_457 VGND VGND VPWR VPWR sky130_fd_sc_hd__decap_3
X_9010_ _9010_/A VGND VGND VPWR VPWR _9345_/D sky130_fd_sc_hd__buf_1
X_6222_ _6221_/B _6221_/A _6158_/B VGND VGND VPWR VPWR _6260_/B sky130_fd_sc_hd__a21o_2
X_6153_ _6151_/A _6054_/X _6058_/X VGND VGND VPWR VPWR _6153_/Y sky130_fd_sc_hd__a21oi_2
XFILLER_124_490 VGND VGND VPWR VPWR sky130_fd_sc_hd__decap_3
X_5104_ _9238_/Q _9239_/Q _5019_/X VGND VGND VPWR VPWR _5105_/C sky130_fd_sc_hd__a21o_2
XFILLER_97_374 VGND VGND VPWR VPWR sky130_fd_sc_hd__decap_3
XFILLER_85_514 VGND VGND VPWR VPWR sky130_fd_sc_hd__fill_1
X_6084_ _6084_/A _6406_/B VGND VGND VPWR VPWR _6085_/A sky130_fd_sc_hd__and2_2
Xhold1204 _9345_/Q VGND VGND VPWR VPWR _9009_/A0 sky130_fd_sc_hd__dlygate4sd3_1
XFILLER_57_216 VGND VGND VPWR VPWR sky130_fd_sc_hd__decap_3
Xhold1215 _9252_/Q VGND VGND VPWR VPWR _8848_/A1 sky130_fd_sc_hd__dlygate4sd3_1
Xhold1226 _6510_/S VGND VGND VPWR VPWR _6459_/A sky130_fd_sc_hd__dlygate4sd3_1
Xhold1237 _5811_/Y VGND VGND VPWR VPWR _5812_/A sky130_fd_sc_hd__dlygate4sd3_1
XFILLER_85_547 VGND VGND VPWR VPWR sky130_fd_sc_hd__fill_2
X_5035_ hold772/X _4968_/S _5028_/X _5034_/Y _4631_/A VGND VGND VPWR VPWR _5035_/X
+ sky130_fd_sc_hd__a32o_2
Xhold1248 _9218_/Q VGND VGND VPWR VPWR _7898_/A0 sky130_fd_sc_hd__dlygate4sd3_1
XFILLER_111_195 VGND VGND VPWR VPWR sky130_fd_sc_hd__fill_2
XFILLER_38_430 VGND VGND VPWR VPWR sky130_fd_sc_hd__fill_1
Xhold1259 _5685_/X VGND VGND VPWR VPWR _5814_/A sky130_fd_sc_hd__dlygate4sd3_1
XFILLER_38_441 VGND VGND VPWR VPWR sky130_fd_sc_hd__decap_3
XFILLER_66_772 VGND VGND VPWR VPWR sky130_fd_sc_hd__decap_3
XFILLER_122_27 VGND VGND VPWR VPWR sky130_fd_sc_hd__fill_1
XFILLER_38_474 VGND VGND VPWR VPWR sky130_fd_sc_hd__fill_2
XFILLER_122_38 VGND VGND VPWR VPWR sky130_fd_sc_hd__decap_3
XFILLER_65_260 VGND VGND VPWR VPWR sky130_fd_sc_hd__decap_3
XFILLER_53_422 VGND VGND VPWR VPWR sky130_fd_sc_hd__decap_3
XFILLER_25_113 VGND VGND VPWR VPWR sky130_fd_sc_hd__decap_3
XTAP_TAPCELL_ROW_0_267 VGND VPWR sky130_fd_sc_hd__tapvpwrvgnd_1
XFILLER_26_669 VGND VGND VPWR VPWR sky130_fd_sc_hd__decap_3
X_6986_ _7050_/A _8406_/A VGND VGND VPWR VPWR _6990_/B sky130_fd_sc_hd__nand2_2
XTAP_TAPCELL_ROW_0_278 VGND VPWR sky130_fd_sc_hd__tapvpwrvgnd_1
XFILLER_41_617 VGND VGND VPWR VPWR sky130_fd_sc_hd__fill_2
XFILLER_53_488 VGND VGND VPWR VPWR sky130_fd_sc_hd__decap_3
X_5937_ _5940_/A1 _6817_/A _6826_/A1 _8020_/A VGND VGND VPWR VPWR _5937_/X sky130_fd_sc_hd__a31o_2
X_8725_ _8681_/A _8737_/B _8704_/B VGND VGND VPWR VPWR _8725_/Y sky130_fd_sc_hd__o21ai_2
XFILLER_34_691 VGND VGND VPWR VPWR sky130_fd_sc_hd__decap_3
XFILLER_40_138 VGND VGND VPWR VPWR sky130_fd_sc_hd__fill_2
XFILLER_15_69 VGND VGND VPWR VPWR sky130_fd_sc_hd__decap_3
X_8656_ _8656_/A VGND VGND VPWR VPWR _8657_/B sky130_fd_sc_hd__clkbuf_1
XTAP_TAPCELL_ROW_101_1648 VGND VPWR sky130_fd_sc_hd__tapvpwrvgnd_1
X_5868_ _9205_/Q _7604_/A VGND VGND VPWR VPWR _5868_/Y sky130_fd_sc_hd__nand2_2
XFILLER_21_352 VGND VGND VPWR VPWR sky130_fd_sc_hd__fill_2
X_7607_ _7607_/A _7607_/B VGND VGND VPWR VPWR _7608_/B sky130_fd_sc_hd__or2_2
X_4819_ _4819_/A0 _9139_/Q _4819_/S VGND VGND VPWR VPWR _4819_/X sky130_fd_sc_hd__mux2_2
Xrebuffer601 _5975_/B VGND VGND VPWR VPWR _6996_/A2 sky130_fd_sc_hd__buf_2
X_8587_ _8587_/A _8587_/B VGND VGND VPWR VPWR _8605_/A sky130_fd_sc_hd__nand2_2
Xrebuffer612 _5673_/B VGND VGND VPWR VPWR _5782_/A1 sky130_fd_sc_hd__buf_2
XFILLER_21_385 VGND VGND VPWR VPWR sky130_fd_sc_hd__decap_3
X_5799_ _5923_/S _5799_/B VGND VGND VPWR VPWR _5800_/B sky130_fd_sc_hd__xnor2_2
XFILLER_21_396 VGND VGND VPWR VPWR sky130_fd_sc_hd__fill_2
XFILLER_31_35 VGND VGND VPWR VPWR sky130_fd_sc_hd__decap_3
Xrebuffer634 _6117_/B2 VGND VGND VPWR VPWR _6420_/A sky130_fd_sc_hd__buf_2
XFILLER_119_240 VGND VGND VPWR VPWR sky130_fd_sc_hd__fill_1
X_7538_ _8022_/S _7538_/B VGND VGND VPWR VPWR _7539_/B sky130_fd_sc_hd__xnor2_2
XTAP_TAPCELL_ROW_60_1091 VGND VPWR sky130_fd_sc_hd__tapvpwrvgnd_1
Xrebuffer656 fanout350/X VGND VGND VPWR VPWR rebuffer656/X sky130_fd_sc_hd__buf_2
XFILLER_5_518 VGND VGND VPWR VPWR sky130_fd_sc_hd__decap_3
XFILLER_107_413 VGND VGND VPWR VPWR sky130_fd_sc_hd__decap_3
XFILLER_110_6 VGND VGND VPWR VPWR sky130_fd_sc_hd__decap_3
Xrebuffer678 _7510_/A VGND VGND VPWR VPWR _7268_/S sky130_fd_sc_hd__buf_2
X_7469_ _7468_/C _7469_/B _7469_/C VGND VGND VPWR VPWR _7486_/C sky130_fd_sc_hd__nand3b_2
Xoutput24 _9193_/Q VGND VGND VPWR VPWR wire230/A sky130_fd_sc_hd__buf_1
X_9208_ _9209_/CLK _9208_/D fanout418/X VGND VGND VPWR VPWR _9208_/Q sky130_fd_sc_hd__dfrtp_2
Xoutput35 _9189_/Q VGND VGND VPWR VPWR wire219/A sky130_fd_sc_hd__buf_1
XFILLER_1_724 VGND VGND VPWR VPWR sky130_fd_sc_hd__decap_3
XFILLER_122_438 VGND VGND VPWR VPWR sky130_fd_sc_hd__decap_3
XFILLER_0_212 VGND VGND VPWR VPWR sky130_fd_sc_hd__decap_3
XFILLER_1_735 VGND VGND VPWR VPWR sky130_fd_sc_hd__decap_3
X_9139_ _9171_/CLK _9139_/D load_slew393/X VGND VGND VPWR VPWR _9139_/Q sky130_fd_sc_hd__dfrtp_2
XFILLER_0_234 VGND VGND VPWR VPWR sky130_fd_sc_hd__decap_3
XFILLER_1_768 VGND VGND VPWR VPWR sky130_fd_sc_hd__decap_3
XFILLER_103_652 VGND VGND VPWR VPWR sky130_fd_sc_hd__decap_3
XFILLER_0_256 VGND VGND VPWR VPWR sky130_fd_sc_hd__decap_3
XTAP_TAPCELL_ROW_8_389 VGND VPWR sky130_fd_sc_hd__tapvpwrvgnd_1
XTAP_TAPCELL_ROW_112_1788 VGND VPWR sky130_fd_sc_hd__tapvpwrvgnd_1
XFILLER_88_363 VGND VGND VPWR VPWR sky130_fd_sc_hd__fill_1
XTAP_TAPCELL_ROW_112_1799 VGND VPWR sky130_fd_sc_hd__tapvpwrvgnd_1
XFILLER_76_514 VGND VGND VPWR VPWR sky130_fd_sc_hd__fill_1
XFILLER_76_536 VGND VGND VPWR VPWR sky130_fd_sc_hd__decap_3
XFILLER_48_227 VGND VGND VPWR VPWR sky130_fd_sc_hd__decap_3
XFILLER_102_184 VGND VGND VPWR VPWR sky130_fd_sc_hd__decap_3
XFILLER_76_547 VGND VGND VPWR VPWR sky130_fd_sc_hd__decap_3
XFILLER_64_709 VGND VGND VPWR VPWR sky130_fd_sc_hd__decap_3
XFILLER_56_32 VGND VGND VPWR VPWR sky130_fd_sc_hd__decap_3
XFILLER_29_430 VGND VGND VPWR VPWR sky130_fd_sc_hd__fill_1
XFILLER_29_452 VGND VGND VPWR VPWR sky130_fd_sc_hd__decap_3
XTAP_TAPCELL_ROW_47_918 VGND VPWR sky130_fd_sc_hd__tapvpwrvgnd_1
XFILLER_91_528 VGND VGND VPWR VPWR sky130_fd_sc_hd__decap_3
XFILLER_17_614 VGND VGND VPWR VPWR sky130_fd_sc_hd__fill_2
XFILLER_29_485 VGND VGND VPWR VPWR sky130_fd_sc_hd__fill_2
XFILLER_17_636 VGND VGND VPWR VPWR sky130_fd_sc_hd__decap_3
XFILLER_16_113 VGND VGND VPWR VPWR sky130_fd_sc_hd__fill_2
XTAP_TAPCELL_ROW_27_642 VGND VPWR sky130_fd_sc_hd__tapvpwrvgnd_1
XPHY_EDGE_ROW_19_Right_19 VGND VGND VPWR VPWR sky130_fd_sc_hd__decap_3
XFILLER_72_764 VGND VGND VPWR VPWR sky130_fd_sc_hd__decap_3
XFILLER_71_241 VGND VGND VPWR VPWR sky130_fd_sc_hd__decap_3
XFILLER_17_669 VGND VGND VPWR VPWR sky130_fd_sc_hd__decap_3
XFILLER_32_606 VGND VGND VPWR VPWR sky130_fd_sc_hd__decap_3
XFILLER_16_168 VGND VGND VPWR VPWR sky130_fd_sc_hd__fill_2
XFILLER_44_488 VGND VGND VPWR VPWR sky130_fd_sc_hd__fill_1
XFILLER_72_53 VGND VGND VPWR VPWR sky130_fd_sc_hd__decap_3
XFILLER_32_639 VGND VGND VPWR VPWR sky130_fd_sc_hd__decap_3
XFILLER_8_301 VGND VGND VPWR VPWR sky130_fd_sc_hd__decap_3
XFILLER_12_363 VGND VGND VPWR VPWR sky130_fd_sc_hd__fill_1
XFILLER_40_683 VGND VGND VPWR VPWR sky130_fd_sc_hd__decap_3
XFILLER_12_374 VGND VGND VPWR VPWR sky130_fd_sc_hd__decap_3
XFILLER_8_334 VGND VGND VPWR VPWR sky130_fd_sc_hd__decap_3
XFILLER_8_356 VGND VGND VPWR VPWR sky130_fd_sc_hd__decap_3
XTAP_TAPCELL_ROW_78_1330 VGND VPWR sky130_fd_sc_hd__tapvpwrvgnd_1
XFILLER_8_389 VGND VGND VPWR VPWR sky130_fd_sc_hd__decap_3
XFILLER_126_722 VGND VGND VPWR VPWR sky130_fd_sc_hd__decap_3
XTAP_TAPCELL_ROW_78_1341 VGND VPWR sky130_fd_sc_hd__tapvpwrvgnd_1
XFILLER_126_755 VGND VGND VPWR VPWR sky130_fd_sc_hd__fill_1
XPHY_EDGE_ROW_28_Right_28 VGND VGND VPWR VPWR sky130_fd_sc_hd__decap_3
XFILLER_126_766 VGND VGND VPWR VPWR sky130_fd_sc_hd__decap_3
XFILLER_99_606 VGND VGND VPWR VPWR sky130_fd_sc_hd__fill_1
XFILLER_125_243 VGND VGND VPWR VPWR sky130_fd_sc_hd__decap_3
XFILLER_99_617 VGND VGND VPWR VPWR sky130_fd_sc_hd__decap_3
XFILLER_113_405 VGND VGND VPWR VPWR sky130_fd_sc_hd__decap_3
XFILLER_99_639 VGND VGND VPWR VPWR sky130_fd_sc_hd__decap_3
XFILLER_4_562 VGND VGND VPWR VPWR sky130_fd_sc_hd__decap_3
XFILLER_125_276 VGND VGND VPWR VPWR sky130_fd_sc_hd__decap_3
XFILLER_98_127 VGND VGND VPWR VPWR sky130_fd_sc_hd__fill_1
XFILLER_113_449 VGND VGND VPWR VPWR sky130_fd_sc_hd__decap_3
XFILLER_79_374 VGND VGND VPWR VPWR sky130_fd_sc_hd__decap_3
XFILLER_121_460 VGND VGND VPWR VPWR sky130_fd_sc_hd__decap_3
XFILLER_39_238 VGND VGND VPWR VPWR sky130_fd_sc_hd__decap_3
XFILLER_121_493 VGND VGND VPWR VPWR sky130_fd_sc_hd__decap_3
XFILLER_94_333 VGND VGND VPWR VPWR sky130_fd_sc_hd__fill_2
XFILLER_55_709 VGND VGND VPWR VPWR sky130_fd_sc_hd__decap_3
XFILLER_82_517 VGND VGND VPWR VPWR sky130_fd_sc_hd__fill_2
XFILLER_94_377 VGND VGND VPWR VPWR sky130_fd_sc_hd__decap_3
XPHY_EDGE_ROW_37_Right_37 VGND VGND VPWR VPWR sky130_fd_sc_hd__decap_3
XFILLER_82_539 VGND VGND VPWR VPWR sky130_fd_sc_hd__decap_3
XFILLER_63_720 VGND VGND VPWR VPWR sky130_fd_sc_hd__decap_3
XFILLER_35_411 VGND VGND VPWR VPWR sky130_fd_sc_hd__decap_3
XTAP_TAPCELL_ROW_89_1481 VGND VPWR sky130_fd_sc_hd__tapvpwrvgnd_1
X_6840_ _6894_/A _6840_/B VGND VGND VPWR VPWR _6849_/A sky130_fd_sc_hd__nor2_2
XFILLER_35_444 VGND VGND VPWR VPWR sky130_fd_sc_hd__decap_3
XFILLER_90_550 VGND VGND VPWR VPWR sky130_fd_sc_hd__decap_3
XFILLER_63_775 VGND VGND VPWR VPWR sky130_fd_sc_hd__fill_2
XFILLER_35_477 VGND VGND VPWR VPWR sky130_fd_sc_hd__decap_3
XFILLER_23_617 VGND VGND VPWR VPWR sky130_fd_sc_hd__decap_3
XFILLER_62_274 VGND VGND VPWR VPWR sky130_fd_sc_hd__decap_3
X_6771_ _6912_/A _6912_/B _6769_/Y _6770_/X VGND VGND VPWR VPWR _6774_/C sky130_fd_sc_hd__a211o_2
X_8510_ _8511_/A _8511_/B _8510_/B1_N VGND VGND VPWR VPWR _8512_/B sky130_fd_sc_hd__o21ba_4
XFILLER_22_138 VGND VGND VPWR VPWR sky130_fd_sc_hd__fill_2
X_5722_ _5712_/X _5715_/X _5721_/X VGND VGND VPWR VPWR _5724_/B sky130_fd_sc_hd__a21o_4
XFILLER_50_458 VGND VGND VPWR VPWR sky130_fd_sc_hd__decap_3
XFILLER_15_190 VGND VGND VPWR VPWR sky130_fd_sc_hd__decap_3
X_8441_ _9220_/Q _8441_/B _8441_/C VGND VGND VPWR VPWR _8441_/X sky130_fd_sc_hd__or3_2
X_5653_ _5552_/A _5552_/B _5652_/X VGND VGND VPWR VPWR _5682_/A sky130_fd_sc_hd__o21a_2
XFILLER_30_193 VGND VGND VPWR VPWR sky130_fd_sc_hd__decap_3
X_4604_ hold870/X _4604_/A1 _4608_/S VGND VGND VPWR VPWR _4605_/A sky130_fd_sc_hd__mux2_2
X_8372_ _8368_/X _8369_/X _8371_/X VGND VGND VPWR VPWR _8372_/X sky130_fd_sc_hd__o21a_2
X_5584_ _7071_/B VGND VGND VPWR VPWR _5584_/X sky130_fd_sc_hd__clkbuf_1
XPHY_EDGE_ROW_46_Right_46 VGND VGND VPWR VPWR sky130_fd_sc_hd__decap_3
XFILLER_129_582 VGND VGND VPWR VPWR sky130_fd_sc_hd__decap_3
XFILLER_116_210 VGND VGND VPWR VPWR sky130_fd_sc_hd__decap_3
X_7323_ _5975_/A _7611_/A2 _7952_/A VGND VGND VPWR VPWR _7324_/B sky130_fd_sc_hd__a21oi_2
XFILLER_117_744 VGND VGND VPWR VPWR sky130_fd_sc_hd__decap_3
X_4535_ _4535_/A VGND VGND VPWR VPWR _9020_/D sky130_fd_sc_hd__buf_1
XFILLER_117_27 VGND VGND VPWR VPWR sky130_fd_sc_hd__decap_3
X_7254_ _7254_/A _7254_/B VGND VGND VPWR VPWR _7513_/A sky130_fd_sc_hd__xnor2_2
X_6205_ _6206_/B _6206_/C VGND VGND VPWR VPWR _6302_/B sky130_fd_sc_hd__nor2_2
X_7185_ _7869_/A _5656_/B _5659_/Y VGND VGND VPWR VPWR _7716_/A sky130_fd_sc_hd__a21o_2
X_6136_ _6136_/A _6136_/B VGND VGND VPWR VPWR _6137_/B sky130_fd_sc_hd__xnor2_2
Xhold1001 _4662_/X VGND VGND VPWR VPWR _4663_/A sky130_fd_sc_hd__dlygate4sd3_1
XTAP_TAPCELL_ROW_5_348 VGND VPWR sky130_fd_sc_hd__tapvpwrvgnd_1
XFILLER_100_633 VGND VGND VPWR VPWR sky130_fd_sc_hd__decap_3
Xhold1012 _9120_/Q VGND VGND VPWR VPWR _4780_/A1 sky130_fd_sc_hd__dlygate4sd3_1
Xload_slew281 hold774/X VGND VGND VPWR VPWR _6857_/B sky130_fd_sc_hd__buf_4
Xhold1023 _9172_/Q VGND VGND VPWR VPWR _4855_/A0 sky130_fd_sc_hd__dlygate4sd3_1
X_6067_ _6387_/A _6387_/B VGND VGND VPWR VPWR _6514_/B sky130_fd_sc_hd__and2_2
Xhold1034 _4782_/X VGND VGND VPWR VPWR _4783_/A sky130_fd_sc_hd__dlygate4sd3_1
Xhold1045 _9045_/Q VGND VGND VPWR VPWR _4621_/A1 sky130_fd_sc_hd__dlygate4sd3_1
XPHY_EDGE_ROW_55_Right_55 VGND VGND VPWR VPWR sky130_fd_sc_hd__decap_3
Xhold1056 _4714_/X VGND VGND VPWR VPWR _4715_/A sky130_fd_sc_hd__dlygate4sd3_1
Xhold1067 _4550_/X VGND VGND VPWR VPWR _4551_/A sky130_fd_sc_hd__dlygate4sd3_1
XFILLER_39_772 VGND VGND VPWR VPWR sky130_fd_sc_hd__decap_3
X_5018_ _9196_/Q _7114_/B VGND VGND VPWR VPWR _5018_/Y sky130_fd_sc_hd__nor2_2
XFILLER_100_699 VGND VGND VPWR VPWR sky130_fd_sc_hd__fill_1
Xhold1078 _9283_/Q VGND VGND VPWR VPWR _8913_/A1 sky130_fd_sc_hd__dlygate4sd3_1
XFILLER_85_399 VGND VGND VPWR VPWR sky130_fd_sc_hd__decap_3
Xhold1089 _9119_/Q VGND VGND VPWR VPWR _4777_/A1 sky130_fd_sc_hd__dlygate4sd3_1
XFILLER_26_24 VGND VGND VPWR VPWR sky130_fd_sc_hd__decap_3
XFILLER_38_293 VGND VGND VPWR VPWR sky130_fd_sc_hd__decap_3
XFILLER_26_433 VGND VGND VPWR VPWR sky130_fd_sc_hd__decap_3
XFILLER_26_444 VGND VGND VPWR VPWR sky130_fd_sc_hd__decap_3
XFILLER_26_46 VGND VGND VPWR VPWR sky130_fd_sc_hd__decap_3
XFILLER_54_764 VGND VGND VPWR VPWR sky130_fd_sc_hd__decap_3
XFILLER_81_561 VGND VGND VPWR VPWR sky130_fd_sc_hd__decap_3
XFILLER_26_477 VGND VGND VPWR VPWR sky130_fd_sc_hd__decap_3
XTAP_TAPCELL_ROW_24_601 VGND VPWR sky130_fd_sc_hd__tapvpwrvgnd_1
XTAP_TAPCELL_ROW_24_612 VGND VPWR sky130_fd_sc_hd__tapvpwrvgnd_1
X_6969_ _6969_/A _6969_/B _6969_/C VGND VGND VPWR VPWR _7036_/A sky130_fd_sc_hd__nand3_2
XTAP_TAPCELL_ROW_62_1120 VGND VPWR sky130_fd_sc_hd__tapvpwrvgnd_1
X_8708_ _8771_/A _8707_/A _8685_/B _8707_/X VGND VGND VPWR VPWR _8708_/Y sky130_fd_sc_hd__o31ai_2
XTAP_TAPCELL_ROW_52_987 VGND VPWR sky130_fd_sc_hd__tapvpwrvgnd_1
XFILLER_22_672 VGND VGND VPWR VPWR sky130_fd_sc_hd__decap_3
X_8639_ _8639_/A _8639_/B VGND VGND VPWR VPWR _8639_/Y sky130_fd_sc_hd__xnor2_2
XFILLER_22_694 VGND VGND VPWR VPWR sky130_fd_sc_hd__decap_3
XPHY_EDGE_ROW_64_Right_64 VGND VGND VPWR VPWR sky130_fd_sc_hd__decap_3
Xrebuffer431 _7283_/X VGND VGND VPWR VPWR _7288_/A3 sky130_fd_sc_hd__buf_2
Xrebuffer442 max_cap135/X VGND VGND VPWR VPWR _6976_/B sky130_fd_sc_hd__buf_2
Xrebuffer453 wire148/X VGND VGND VPWR VPWR _7611_/A2 sky130_fd_sc_hd__buf_2
Xrebuffer464 _5742_/D VGND VGND VPWR VPWR _5873_/B sky130_fd_sc_hd__buf_2
Xrebuffer475 _6692_/A VGND VGND VPWR VPWR _6557_/A sky130_fd_sc_hd__buf_2
XFILLER_5_337 VGND VGND VPWR VPWR sky130_fd_sc_hd__decap_3
Xrebuffer486 _6595_/B VGND VGND VPWR VPWR _7010_/A sky130_fd_sc_hd__buf_6
XTAP_TAPCELL_ROW_114_1817 VGND VPWR sky130_fd_sc_hd__tapvpwrvgnd_1
Xrebuffer497 _6711_/X VGND VGND VPWR VPWR _7002_/B1 sky130_fd_sc_hd__buf_2
XPHY_EDGE_ROW_2_Left_133 VGND VGND VPWR VPWR sky130_fd_sc_hd__decap_3
XFILLER_107_287 VGND VGND VPWR VPWR sky130_fd_sc_hd__decap_3
XFILLER_123_747 VGND VGND VPWR VPWR sky130_fd_sc_hd__decap_3
XFILLER_1_521 VGND VGND VPWR VPWR sky130_fd_sc_hd__decap_3
XFILLER_122_224 VGND VGND VPWR VPWR sky130_fd_sc_hd__decap_3
XFILLER_96_609 VGND VGND VPWR VPWR sky130_fd_sc_hd__decap_3
XFILLER_122_246 VGND VGND VPWR VPWR sky130_fd_sc_hd__decap_3
Xhold890 _9081_/Q VGND VGND VPWR VPWR hold890/X sky130_fd_sc_hd__dlygate4sd3_1
XFILLER_3_39 VGND VGND VPWR VPWR sky130_fd_sc_hd__decap_3
XFILLER_1_554 VGND VGND VPWR VPWR sky130_fd_sc_hd__decap_3
XTAP_TAPCELL_ROW_73_1271 VGND VPWR sky130_fd_sc_hd__tapvpwrvgnd_1
XFILLER_95_108 VGND VGND VPWR VPWR sky130_fd_sc_hd__decap_3
XFILLER_95_119 VGND VGND VPWR VPWR sky130_fd_sc_hd__decap_3
XFILLER_49_514 VGND VGND VPWR VPWR sky130_fd_sc_hd__decap_3
XFILLER_110_419 VGND VGND VPWR VPWR sky130_fd_sc_hd__fill_1
XFILLER_88_160 VGND VGND VPWR VPWR sky130_fd_sc_hd__fill_1
XFILLER_89_694 VGND VGND VPWR VPWR sky130_fd_sc_hd__decap_3
XPHY_EDGE_ROW_73_Right_73 VGND VGND VPWR VPWR sky130_fd_sc_hd__decap_3
XFILLER_67_53 VGND VGND VPWR VPWR sky130_fd_sc_hd__decap_3
XFILLER_76_333 VGND VGND VPWR VPWR sky130_fd_sc_hd__fill_2
XFILLER_67_86 VGND VGND VPWR VPWR sky130_fd_sc_hd__fill_2
XFILLER_37_709 VGND VGND VPWR VPWR sky130_fd_sc_hd__decap_3
XFILLER_36_219 VGND VGND VPWR VPWR sky130_fd_sc_hd__decap_3
XFILLER_64_539 VGND VGND VPWR VPWR sky130_fd_sc_hd__decap_3
XFILLER_45_720 VGND VGND VPWR VPWR sky130_fd_sc_hd__decap_3
XFILLER_17_411 VGND VGND VPWR VPWR sky130_fd_sc_hd__decap_3
XFILLER_83_30 VGND VGND VPWR VPWR sky130_fd_sc_hd__fill_2
XFILLER_17_433 VGND VGND VPWR VPWR sky130_fd_sc_hd__decap_3
XFILLER_123_81 VGND VGND VPWR VPWR sky130_fd_sc_hd__decap_3
XPHY_EDGE_ROW_48_Left_179 VGND VGND VPWR VPWR sky130_fd_sc_hd__decap_3
XFILLER_45_753 VGND VGND VPWR VPWR sky130_fd_sc_hd__fill_1
XFILLER_44_230 VGND VGND VPWR VPWR sky130_fd_sc_hd__decap_3
XFILLER_17_455 VGND VGND VPWR VPWR sky130_fd_sc_hd__decap_3
XTAP_TAPCELL_ROW_125_1968 VGND VPWR sky130_fd_sc_hd__tapvpwrvgnd_1
XFILLER_60_701 VGND VGND VPWR VPWR sky130_fd_sc_hd__decap_3
XFILLER_45_775 VGND VGND VPWR VPWR sky130_fd_sc_hd__fill_2
XFILLER_17_477 VGND VGND VPWR VPWR sky130_fd_sc_hd__decap_3
XFILLER_60_745 VGND VGND VPWR VPWR sky130_fd_sc_hd__decap_3
XFILLER_60_767 VGND VGND VPWR VPWR sky130_fd_sc_hd__decap_3
XPHY_EDGE_ROW_82_Right_82 VGND VGND VPWR VPWR sky130_fd_sc_hd__decap_3
XFILLER_9_643 VGND VGND VPWR VPWR sky130_fd_sc_hd__decap_3
XFILLER_13_694 VGND VGND VPWR VPWR sky130_fd_sc_hd__decap_3
XFILLER_12_182 VGND VGND VPWR VPWR sky130_fd_sc_hd__decap_3
XPHY_EDGE_ROW_57_Left_188 VGND VGND VPWR VPWR sky130_fd_sc_hd__decap_3
XFILLER_126_530 VGND VGND VPWR VPWR sky130_fd_sc_hd__fill_2
XFILLER_99_447 VGND VGND VPWR VPWR sky130_fd_sc_hd__fill_1
XFILLER_114_747 VGND VGND VPWR VPWR sky130_fd_sc_hd__decap_3
XFILLER_99_458 VGND VGND VPWR VPWR sky130_fd_sc_hd__decap_3
XFILLER_4_392 VGND VGND VPWR VPWR sky130_fd_sc_hd__decap_3
XFILLER_113_246 VGND VGND VPWR VPWR sky130_fd_sc_hd__fill_1
XPHY_EDGE_ROW_91_Right_91 VGND VGND VPWR VPWR sky130_fd_sc_hd__decap_3
XFILLER_95_620 VGND VGND VPWR VPWR sky130_fd_sc_hd__decap_3
XFILLER_67_322 VGND VGND VPWR VPWR sky130_fd_sc_hd__fill_2
XFILLER_79_193 VGND VGND VPWR VPWR sky130_fd_sc_hd__fill_1
XFILLER_121_290 VGND VGND VPWR VPWR sky130_fd_sc_hd__decap_3
XTAP_TAPCELL_ROW_2_307 VGND VPWR sky130_fd_sc_hd__tapvpwrvgnd_1
X_8990_ _8990_/A VGND VGND VPWR VPWR _9009_/S sky130_fd_sc_hd__clkbuf_2
XFILLER_82_303 VGND VGND VPWR VPWR sky130_fd_sc_hd__decap_3
XPHY_EDGE_ROW_66_Left_197 VGND VGND VPWR VPWR sky130_fd_sc_hd__decap_3
X_7941_ _8231_/A _8242_/A VGND VGND VPWR VPWR _7942_/B sky130_fd_sc_hd__nor2_2
XFILLER_36_753 VGND VGND VPWR VPWR sky130_fd_sc_hd__decap_3
X_7872_ _6817_/A _7868_/X _7871_/Y VGND VGND VPWR VPWR _7873_/B sky130_fd_sc_hd__a21bo_2
XFILLER_35_252 VGND VGND VPWR VPWR sky130_fd_sc_hd__decap_3
XFILLER_51_723 VGND VGND VPWR VPWR sky130_fd_sc_hd__decap_3
X_6823_ _6884_/A _6823_/B VGND VGND VPWR VPWR _6865_/A sky130_fd_sc_hd__xnor2_2
XFILLER_63_594 VGND VGND VPWR VPWR sky130_fd_sc_hd__decap_3
XFILLER_23_425 VGND VGND VPWR VPWR sky130_fd_sc_hd__fill_2
XFILLER_51_745 VGND VGND VPWR VPWR sky130_fd_sc_hd__decap_3
XFILLER_35_296 VGND VGND VPWR VPWR sky130_fd_sc_hd__decap_3
XFILLER_23_447 VGND VGND VPWR VPWR sky130_fd_sc_hd__fill_1
X_6754_ _9161_/Q _6754_/B _6756_/C VGND VGND VPWR VPWR _6754_/X sky130_fd_sc_hd__and3_2
XFILLER_50_277 VGND VGND VPWR VPWR sky130_fd_sc_hd__decap_3
X_5705_ _5705_/A _5705_/B VGND VGND VPWR VPWR _5861_/A sky130_fd_sc_hd__or2_4
X_6685_ _6685_/A _7043_/B VGND VGND VPWR VPWR _6689_/A sky130_fd_sc_hd__nand2_2
XFILLER_12_15 VGND VGND VPWR VPWR sky130_fd_sc_hd__decap_3
XFILLER_109_519 VGND VGND VPWR VPWR sky130_fd_sc_hd__decap_3
X_5636_ _5765_/A _5766_/B VGND VGND VPWR VPWR _5637_/B sky130_fd_sc_hd__xnor2_2
X_8424_ _9221_/Q _8446_/A _8398_/B _8423_/X _8398_/A VGND VGND VPWR VPWR _8432_/A
+ sky130_fd_sc_hd__a311o_2
XFILLER_128_15 VGND VGND VPWR VPWR sky130_fd_sc_hd__decap_3
X_8355_ _8350_/A _8218_/B _8216_/A VGND VGND VPWR VPWR _8367_/B sky130_fd_sc_hd__o21a_2
X_5567_ _7071_/A VGND VGND VPWR VPWR _7416_/A sky130_fd_sc_hd__clkbuf_1
XFILLER_128_59 VGND VGND VPWR VPWR sky130_fd_sc_hd__decap_3
XFILLER_105_703 VGND VGND VPWR VPWR sky130_fd_sc_hd__decap_3
X_7306_ _7303_/Y _7304_/Y _7301_/X _7302_/X VGND VGND VPWR VPWR _7307_/C sky130_fd_sc_hd__o211ai_2
X_4518_ _5880_/B VGND VGND VPWR VPWR _6758_/B sky130_fd_sc_hd__buf_6
X_8286_ _8283_/X _8281_/Y _8286_/S VGND VGND VPWR VPWR _8286_/X sky130_fd_sc_hd__mux2_2
XFILLER_2_318 VGND VGND VPWR VPWR sky130_fd_sc_hd__decap_3
X_5498_ _5499_/B _5497_/Y VGND VGND VPWR VPWR _5498_/X sky130_fd_sc_hd__or2b_2
XFILLER_5_9 VGND VGND VPWR VPWR sky130_fd_sc_hd__decap_3
X_7237_ _7682_/A _7176_/B _7236_/X VGND VGND VPWR VPWR _7659_/B sky130_fd_sc_hd__a21o_2
XFILLER_104_268 VGND VGND VPWR VPWR sky130_fd_sc_hd__decap_3
XFILLER_77_108 VGND VGND VPWR VPWR sky130_fd_sc_hd__decap_3
XFILLER_120_728 VGND VGND VPWR VPWR sky130_fd_sc_hd__decap_3
XTAP_TAPCELL_ROW_129_2024 VGND VPWR sky130_fd_sc_hd__tapvpwrvgnd_1
XFILLER_77_119 VGND VGND VPWR VPWR sky130_fd_sc_hd__decap_3
X_7168_ _7263_/B VGND VGND VPWR VPWR _7215_/A sky130_fd_sc_hd__inv_2
XFILLER_98_480 VGND VGND VPWR VPWR sky130_fd_sc_hd__decap_3
XFILLER_86_631 VGND VGND VPWR VPWR sky130_fd_sc_hd__decap_3
XFILLER_58_322 VGND VGND VPWR VPWR sky130_fd_sc_hd__decap_3
XFILLER_100_430 VGND VGND VPWR VPWR sky130_fd_sc_hd__fill_1
X_6119_ _6426_/A _7530_/B VGND VGND VPWR VPWR _6120_/B sky130_fd_sc_hd__xnor2_2
XFILLER_58_344 VGND VGND VPWR VPWR sky130_fd_sc_hd__decap_3
XFILLER_100_452 VGND VGND VPWR VPWR sky130_fd_sc_hd__decap_3
X_7099_ _7099_/A _7099_/B _7099_/C VGND VGND VPWR VPWR _7099_/X sky130_fd_sc_hd__or3_2
XFILLER_37_23 VGND VGND VPWR VPWR sky130_fd_sc_hd__decap_3
XFILLER_86_675 VGND VGND VPWR VPWR sky130_fd_sc_hd__decap_3
XFILLER_58_377 VGND VGND VPWR VPWR sky130_fd_sc_hd__decap_3
XFILLER_46_539 VGND VGND VPWR VPWR sky130_fd_sc_hd__decap_3
XFILLER_73_358 VGND VGND VPWR VPWR sky130_fd_sc_hd__decap_3
XFILLER_54_550 VGND VGND VPWR VPWR sky130_fd_sc_hd__decap_3
XFILLER_27_764 VGND VGND VPWR VPWR sky130_fd_sc_hd__decap_3
XFILLER_26_241 VGND VGND VPWR VPWR sky130_fd_sc_hd__decap_3
XFILLER_42_701 VGND VGND VPWR VPWR sky130_fd_sc_hd__fill_2
XTAP_TAPCELL_ROW_37_781 VGND VPWR sky130_fd_sc_hd__tapvpwrvgnd_1
XFILLER_53_33 VGND VGND VPWR VPWR sky130_fd_sc_hd__decap_3
XFILLER_41_211 VGND VGND VPWR VPWR sky130_fd_sc_hd__decap_3
XFILLER_26_285 VGND VGND VPWR VPWR sky130_fd_sc_hd__decap_3
XFILLER_42_745 VGND VGND VPWR VPWR sky130_fd_sc_hd__decap_3
XFILLER_14_436 VGND VGND VPWR VPWR sky130_fd_sc_hd__decap_3
XFILLER_22_480 VGND VGND VPWR VPWR sky130_fd_sc_hd__decap_3
XTAP_TAPCELL_ROW_120_1898 VGND VPWR sky130_fd_sc_hd__tapvpwrvgnd_1
XFILLER_5_101 VGND VGND VPWR VPWR sky130_fd_sc_hd__decap_3
XFILLER_127_349 VGND VGND VPWR VPWR sky130_fd_sc_hd__decap_3
XFILLER_5_134 VGND VGND VPWR VPWR sky130_fd_sc_hd__decap_3
XTAP_TAPCELL_ROW_75_1300 VGND VPWR sky130_fd_sc_hd__tapvpwrvgnd_1
XFILLER_5_156 VGND VGND VPWR VPWR sky130_fd_sc_hd__fill_1
XFILLER_108_574 VGND VGND VPWR VPWR sky130_fd_sc_hd__decap_3
XFILLER_123_511 VGND VGND VPWR VPWR sky130_fd_sc_hd__decap_3
XFILLER_108_596 VGND VGND VPWR VPWR sky130_fd_sc_hd__decap_3
XFILLER_78_41 VGND VGND VPWR VPWR sky130_fd_sc_hd__decap_3
XFILLER_69_609 VGND VGND VPWR VPWR sky130_fd_sc_hd__decap_3
XFILLER_111_706 VGND VGND VPWR VPWR sky130_fd_sc_hd__decap_3
XFILLER_68_119 VGND VGND VPWR VPWR sky130_fd_sc_hd__decap_3
XFILLER_89_480 VGND VGND VPWR VPWR sky130_fd_sc_hd__decap_3
XFILLER_1_373 VGND VGND VPWR VPWR sky130_fd_sc_hd__fill_1
XFILLER_49_322 VGND VGND VPWR VPWR sky130_fd_sc_hd__fill_1
XFILLER_103_290 VGND VGND VPWR VPWR sky130_fd_sc_hd__decap_3
XFILLER_77_664 VGND VGND VPWR VPWR sky130_fd_sc_hd__decap_3
XFILLER_76_141 VGND VGND VPWR VPWR sky130_fd_sc_hd__decap_3
XFILLER_49_377 VGND VGND VPWR VPWR sky130_fd_sc_hd__decap_3
XFILLER_77_697 VGND VGND VPWR VPWR sky130_fd_sc_hd__decap_3
XFILLER_91_111 VGND VGND VPWR VPWR sky130_fd_sc_hd__fill_1
XFILLER_92_645 VGND VGND VPWR VPWR sky130_fd_sc_hd__decap_3
XFILLER_91_122 VGND VGND VPWR VPWR sky130_fd_sc_hd__decap_3
XFILLER_18_731 VGND VGND VPWR VPWR sky130_fd_sc_hd__decap_3
XFILLER_64_347 VGND VGND VPWR VPWR sky130_fd_sc_hd__decap_3
XTAP_TAPCELL_ROW_86_1440 VGND VPWR sky130_fd_sc_hd__tapvpwrvgnd_1
XFILLER_91_166 VGND VGND VPWR VPWR sky130_fd_sc_hd__fill_2
XFILLER_45_561 VGND VGND VPWR VPWR sky130_fd_sc_hd__fill_1
XFILLER_18_775 VGND VGND VPWR VPWR sky130_fd_sc_hd__fill_2
XFILLER_17_252 VGND VGND VPWR VPWR sky130_fd_sc_hd__decap_3
XFILLER_33_723 VGND VGND VPWR VPWR sky130_fd_sc_hd__decap_3
XFILLER_32_211 VGND VGND VPWR VPWR sky130_fd_sc_hd__decap_3
XFILLER_60_531 VGND VGND VPWR VPWR sky130_fd_sc_hd__fill_1
XFILLER_60_542 VGND VGND VPWR VPWR sky130_fd_sc_hd__decap_3
XFILLER_60_553 VGND VGND VPWR VPWR sky130_fd_sc_hd__fill_1
XFILLER_32_244 VGND VGND VPWR VPWR sky130_fd_sc_hd__decap_3
XFILLER_32_288 VGND VGND VPWR VPWR sky130_fd_sc_hd__decap_3
XTAP_TAPCELL_ROW_15_486 VGND VPWR sky130_fd_sc_hd__tapvpwrvgnd_1
XFILLER_13_480 VGND VGND VPWR VPWR sky130_fd_sc_hd__decap_3
X_6470_ _6470_/A _7877_/A VGND VGND VPWR VPWR _6845_/A sky130_fd_sc_hd__nand2_2
XFILLER_71_3 VGND VGND VPWR VPWR sky130_fd_sc_hd__decap_3
XFILLER_118_338 VGND VGND VPWR VPWR sky130_fd_sc_hd__decap_3
X_5421_ _5418_/A _5416_/Y _5417_/A VGND VGND VPWR VPWR _5499_/B sky130_fd_sc_hd__a21o_2
XTAP_TAPCELL_ROW_97_1591 VGND VPWR sky130_fd_sc_hd__tapvpwrvgnd_1
X_8140_ _8268_/S _8364_/B VGND VGND VPWR VPWR _8271_/C sky130_fd_sc_hd__nand2_2
X_5352_ _5143_/B _5348_/X _5351_/X _8175_/A VGND VGND VPWR VPWR _5352_/Y sky130_fd_sc_hd__a211oi_2
XFILLER_114_511 VGND VGND VPWR VPWR sky130_fd_sc_hd__decap_3
XFILLER_126_371 VGND VGND VPWR VPWR sky130_fd_sc_hd__decap_3
XFILLER_114_533 VGND VGND VPWR VPWR sky130_fd_sc_hd__fill_1
X_8071_ _7953_/A _8069_/X _8070_/X VGND VGND VPWR VPWR _8072_/B sky130_fd_sc_hd__a21o_2
XFILLER_99_244 VGND VGND VPWR VPWR sky130_fd_sc_hd__decap_3
X_5283_ _5283_/A _5283_/B VGND VGND VPWR VPWR _6033_/A sky130_fd_sc_hd__nor2_2
XFILLER_114_577 VGND VGND VPWR VPWR sky130_fd_sc_hd__decap_3
XFILLER_102_728 VGND VGND VPWR VPWR sky130_fd_sc_hd__decap_3
X_7022_ _7033_/B _7022_/B VGND VGND VPWR VPWR _7278_/B sky130_fd_sc_hd__xnor2_2
XFILLER_59_119 VGND VGND VPWR VPWR sky130_fd_sc_hd__fill_2
XFILLER_68_620 VGND VGND VPWR VPWR sky130_fd_sc_hd__fill_2
XPHY_EDGE_ROW_74_Left_205 VGND VGND VPWR VPWR sky130_fd_sc_hd__decap_3
XFILLER_68_642 VGND VGND VPWR VPWR sky130_fd_sc_hd__fill_2
XFILLER_28_506 VGND VGND VPWR VPWR sky130_fd_sc_hd__decap_3
XFILLER_95_461 VGND VGND VPWR VPWR sky130_fd_sc_hd__fill_1
XFILLER_55_303 VGND VGND VPWR VPWR sky130_fd_sc_hd__decap_3
XFILLER_28_528 VGND VGND VPWR VPWR sky130_fd_sc_hd__decap_3
XFILLER_95_494 VGND VGND VPWR VPWR sky130_fd_sc_hd__decap_3
XFILLER_83_634 VGND VGND VPWR VPWR sky130_fd_sc_hd__decap_3
XFILLER_82_111 VGND VGND VPWR VPWR sky130_fd_sc_hd__fill_2
X_8973_ _8973_/A VGND VGND VPWR VPWR _9327_/D sky130_fd_sc_hd__buf_1
XFILLER_83_667 VGND VGND VPWR VPWR sky130_fd_sc_hd__decap_3
XFILLER_82_144 VGND VGND VPWR VPWR sky130_fd_sc_hd__decap_3
XFILLER_55_358 VGND VGND VPWR VPWR sky130_fd_sc_hd__decap_3
X_7924_ _7924_/A _7924_/B _7915_/Y VGND VGND VPWR VPWR _7924_/X sky130_fd_sc_hd__or3b_2
XFILLER_70_306 VGND VGND VPWR VPWR sky130_fd_sc_hd__fill_2
XFILLER_24_701 VGND VGND VPWR VPWR sky130_fd_sc_hd__fill_2
XFILLER_36_572 VGND VGND VPWR VPWR sky130_fd_sc_hd__fill_2
XFILLER_130_27 VGND VGND VPWR VPWR sky130_fd_sc_hd__fill_1
XFILLER_24_723 VGND VGND VPWR VPWR sky130_fd_sc_hd__decap_3
XFILLER_130_38 VGND VGND VPWR VPWR sky130_fd_sc_hd__decap_3
X_7855_ _7857_/A _7857_/B _7856_/A VGND VGND VPWR VPWR _7855_/X sky130_fd_sc_hd__and3_2
XFILLER_51_520 VGND VGND VPWR VPWR sky130_fd_sc_hd__fill_1
XFILLER_51_531 VGND VGND VPWR VPWR sky130_fd_sc_hd__fill_2
XTAP_TAPCELL_ROW_34_740 VGND VPWR sky130_fd_sc_hd__tapvpwrvgnd_1
X_6806_ _6084_/A _6805_/B _6805_/X _6809_/A VGND VGND VPWR VPWR _6806_/X sky130_fd_sc_hd__a22o_2
XFILLER_23_255 VGND VGND VPWR VPWR sky130_fd_sc_hd__decap_3
X_4998_ _4998_/A _6232_/C VGND VGND VPWR VPWR _5473_/D sky130_fd_sc_hd__xnor2_4
X_7786_ _7613_/A _7787_/C VGND VGND VPWR VPWR _7786_/X sky130_fd_sc_hd__and2b_2
XFILLER_51_575 VGND VGND VPWR VPWR sky130_fd_sc_hd__decap_3
XFILLER_23_277 VGND VGND VPWR VPWR sky130_fd_sc_hd__decap_3
XPHY_EDGE_ROW_83_Left_214 VGND VGND VPWR VPWR sky130_fd_sc_hd__decap_3
X_6737_ _9210_/Q VGND VGND VPWR VPWR _6739_/A sky130_fd_sc_hd__inv_2
XFILLER_23_47 VGND VGND VPWR VPWR sky130_fd_sc_hd__decap_3
X_6668_ _6668_/A _6668_/B VGND VGND VPWR VPWR _6669_/C sky130_fd_sc_hd__and2_2
XFILLER_99_18 VGND VGND VPWR VPWR sky130_fd_sc_hd__fill_1
X_5619_ _9042_/Q _9106_/Q _5989_/S VGND VGND VPWR VPWR _5619_/X sky130_fd_sc_hd__mux2_2
X_8407_ _8313_/B _8406_/C _8406_/B VGND VGND VPWR VPWR _8408_/D sky130_fd_sc_hd__a21oi_2
X_6599_ _6599_/A _6599_/B VGND VGND VPWR VPWR _6658_/A sky130_fd_sc_hd__xnor2_4
XFILLER_105_511 VGND VGND VPWR VPWR sky130_fd_sc_hd__fill_2
X_8338_ _8254_/A _8254_/B _8336_/X _8337_/Y VGND VGND VPWR VPWR _8338_/X sky130_fd_sc_hd__a22o_2
XFILLER_3_638 VGND VGND VPWR VPWR sky130_fd_sc_hd__decap_3
XFILLER_2_115 VGND VGND VPWR VPWR sky130_fd_sc_hd__decap_3
XFILLER_117_382 VGND VGND VPWR VPWR sky130_fd_sc_hd__decap_3
XFILLER_105_544 VGND VGND VPWR VPWR sky130_fd_sc_hd__fill_1
XTAP_TAPCELL_ROW_57_1052 VGND VPWR sky130_fd_sc_hd__tapvpwrvgnd_1
XFILLER_3_6 VGND VGND VPWR VPWR sky130_fd_sc_hd__decap_3
X_8269_ _8271_/A _8267_/X _8268_/X VGND VGND VPWR VPWR _8269_/Y sky130_fd_sc_hd__a21oi_2
XFILLER_78_417 VGND VGND VPWR VPWR sky130_fd_sc_hd__decap_3
XFILLER_105_599 VGND VGND VPWR VPWR sky130_fd_sc_hd__decap_3
XPHY_EDGE_ROW_92_Left_223 VGND VGND VPWR VPWR sky130_fd_sc_hd__decap_3
XFILLER_59_620 VGND VGND VPWR VPWR sky130_fd_sc_hd__decap_3
XTAP_TAPCELL_ROW_70_1230 VGND VPWR sky130_fd_sc_hd__tapvpwrvgnd_1
XFILLER_120_536 VGND VGND VPWR VPWR sky130_fd_sc_hd__decap_3
XFILLER_59_653 VGND VGND VPWR VPWR sky130_fd_sc_hd__fill_1
XFILLER_101_750 VGND VGND VPWR VPWR sky130_fd_sc_hd__decap_3
XFILLER_93_409 VGND VGND VPWR VPWR sky130_fd_sc_hd__decap_3
XFILLER_58_141 VGND VGND VPWR VPWR sky130_fd_sc_hd__decap_3
XFILLER_74_601 VGND VGND VPWR VPWR sky130_fd_sc_hd__decap_3
XFILLER_48_77 VGND VGND VPWR VPWR sky130_fd_sc_hd__decap_3
XFILLER_86_472 VGND VGND VPWR VPWR sky130_fd_sc_hd__decap_3
XFILLER_48_88 VGND VGND VPWR VPWR sky130_fd_sc_hd__decap_3
XFILLER_86_483 VGND VGND VPWR VPWR sky130_fd_sc_hd__decap_3
XFILLER_19_528 VGND VGND VPWR VPWR sky130_fd_sc_hd__decap_3
XFILLER_0_18 VGND VGND VPWR VPWR sky130_fd_sc_hd__decap_3
XFILLER_0_29 VGND VGND VPWR VPWR sky130_fd_sc_hd__decap_3
XFILLER_100_282 VGND VGND VPWR VPWR sky130_fd_sc_hd__decap_3
XFILLER_104_50 VGND VGND VPWR VPWR sky130_fd_sc_hd__decap_3
XTAP_TAPCELL_ROW_109_1749 VGND VPWR sky130_fd_sc_hd__tapvpwrvgnd_1
XFILLER_74_645 VGND VGND VPWR VPWR sky130_fd_sc_hd__decap_3
XFILLER_46_347 VGND VGND VPWR VPWR sky130_fd_sc_hd__decap_3
XFILLER_27_550 VGND VGND VPWR VPWR sky130_fd_sc_hd__decap_3
XFILLER_27_561 VGND VGND VPWR VPWR sky130_fd_sc_hd__decap_3
XFILLER_15_712 VGND VGND VPWR VPWR sky130_fd_sc_hd__decap_3
XTAP_TAPCELL_ROW_122_1927 VGND VPWR sky130_fd_sc_hd__tapvpwrvgnd_1
XFILLER_54_380 VGND VGND VPWR VPWR sky130_fd_sc_hd__decap_3
XFILLER_27_594 VGND VGND VPWR VPWR sky130_fd_sc_hd__decap_3
XFILLER_42_531 VGND VGND VPWR VPWR sky130_fd_sc_hd__fill_1
XFILLER_15_756 VGND VGND VPWR VPWR sky130_fd_sc_hd__decap_3
XFILLER_14_233 VGND VGND VPWR VPWR sky130_fd_sc_hd__decap_3
XFILLER_42_553 VGND VGND VPWR VPWR sky130_fd_sc_hd__decap_3
XFILLER_9_27 VGND VGND VPWR VPWR sky130_fd_sc_hd__decap_3
XFILLER_42_575 VGND VGND VPWR VPWR sky130_fd_sc_hd__decap_3
XFILLER_120_71 VGND VGND VPWR VPWR sky130_fd_sc_hd__decap_3
XTAP_TAPCELL_ROW_81_1370 VGND VPWR sky130_fd_sc_hd__tapvpwrvgnd_1
XTAP_TAPCELL_ROW_81_1381 VGND VPWR sky130_fd_sc_hd__tapvpwrvgnd_1
XFILLER_14_299 VGND VGND VPWR VPWR sky130_fd_sc_hd__decap_3
XFILLER_80_64 VGND VGND VPWR VPWR sky130_fd_sc_hd__decap_3
XTAP_TAPCELL_ROW_12_445 VGND VPWR sky130_fd_sc_hd__tapvpwrvgnd_1
XFILLER_128_625 VGND VGND VPWR VPWR sky130_fd_sc_hd__decap_3
XFILLER_127_102 VGND VGND VPWR VPWR sky130_fd_sc_hd__decap_3
XFILLER_10_450 VGND VGND VPWR VPWR sky130_fd_sc_hd__fill_1
XFILLER_127_113 VGND VGND VPWR VPWR sky130_fd_sc_hd__decap_3
XFILLER_6_421 VGND VGND VPWR VPWR sky130_fd_sc_hd__decap_3
XFILLER_10_472 VGND VGND VPWR VPWR sky130_fd_sc_hd__decap_3
XFILLER_128_669 VGND VGND VPWR VPWR sky130_fd_sc_hd__decap_3
XFILLER_10_483 VGND VGND VPWR VPWR sky130_fd_sc_hd__decap_3
XFILLER_13_91 VGND VGND VPWR VPWR sky130_fd_sc_hd__decap_3
XFILLER_127_146 VGND VGND VPWR VPWR sky130_fd_sc_hd__decap_3
XFILLER_6_454 VGND VGND VPWR VPWR sky130_fd_sc_hd__fill_1
XPHY_EDGE_ROW_108_Right_108 VGND VGND VPWR VPWR sky130_fd_sc_hd__decap_3
XFILLER_108_382 VGND VGND VPWR VPWR sky130_fd_sc_hd__decap_3
XFILLER_123_352 VGND VGND VPWR VPWR sky130_fd_sc_hd__decap_3
XFILLER_97_726 VGND VGND VPWR VPWR sky130_fd_sc_hd__fill_2
XFILLER_96_203 VGND VGND VPWR VPWR sky130_fd_sc_hd__decap_3
XFILLER_2_660 VGND VGND VPWR VPWR sky130_fd_sc_hd__decap_3
XFILLER_69_428 VGND VGND VPWR VPWR sky130_fd_sc_hd__decap_3
XFILLER_111_514 VGND VGND VPWR VPWR sky130_fd_sc_hd__decap_3
XFILLER_123_385 VGND VGND VPWR VPWR sky130_fd_sc_hd__decap_3
XFILLER_2_693 VGND VGND VPWR VPWR sky130_fd_sc_hd__decap_3
XFILLER_96_247 VGND VGND VPWR VPWR sky130_fd_sc_hd__decap_3
XFILLER_77_461 VGND VGND VPWR VPWR sky130_fd_sc_hd__decap_3
XFILLER_65_623 VGND VGND VPWR VPWR sky130_fd_sc_hd__decap_3
XFILLER_64_111 VGND VGND VPWR VPWR sky130_fd_sc_hd__decap_3
XFILLER_37_325 VGND VGND VPWR VPWR sky130_fd_sc_hd__decap_3
XFILLER_49_196 VGND VGND VPWR VPWR sky130_fd_sc_hd__decap_3
XFILLER_65_656 VGND VGND VPWR VPWR sky130_fd_sc_hd__decap_3
XFILLER_64_144 VGND VGND VPWR VPWR sky130_fd_sc_hd__fill_1
X_5970_ _5914_/A _6514_/A _5969_/X VGND VGND VPWR VPWR _6070_/A sky130_fd_sc_hd__o21a_2
XFILLER_52_328 VGND VGND VPWR VPWR sky130_fd_sc_hd__decap_3
X_4921_ _6342_/B _4921_/B VGND VGND VPWR VPWR _5879_/B sky130_fd_sc_hd__and2_4
XFILLER_64_188 VGND VGND VPWR VPWR sky130_fd_sc_hd__decap_3
XFILLER_80_648 VGND VGND VPWR VPWR sky130_fd_sc_hd__fill_1
XFILLER_33_520 VGND VGND VPWR VPWR sky130_fd_sc_hd__decap_3
X_4852_ _4852_/A VGND VGND VPWR VPWR _9170_/D sky130_fd_sc_hd__buf_1
X_7640_ _7365_/A _7364_/B _7484_/A _7643_/B VGND VGND VPWR VPWR _7640_/X sky130_fd_sc_hd__a22o_2
XFILLER_21_726 VGND VGND VPWR VPWR sky130_fd_sc_hd__fill_2
X_7571_ _7571_/A VGND VGND VPWR VPWR wire88/A sky130_fd_sc_hd__clkbuf_2
XFILLER_20_225 VGND VGND VPWR VPWR sky130_fd_sc_hd__decap_3
X_4783_ _4783_/A VGND VGND VPWR VPWR _9137_/D sky130_fd_sc_hd__buf_1
XFILLER_21_759 VGND VGND VPWR VPWR sky130_fd_sc_hd__decap_3
XTAP_TAPCELL_ROW_99_1620 VGND VPWR sky130_fd_sc_hd__tapvpwrvgnd_1
X_6522_ _6522_/A _6523_/A _6518_/Y VGND VGND VPWR VPWR _6522_/X sky130_fd_sc_hd__or3b_2
X_9310_ _9344_/CLK _9310_/D load_slew380/X VGND VGND VPWR VPWR _9310_/Q sky130_fd_sc_hd__dfrtp_2
XFILLER_119_614 VGND VGND VPWR VPWR sky130_fd_sc_hd__fill_2
XFILLER_9_270 VGND VGND VPWR VPWR sky130_fd_sc_hd__decap_3
XFILLER_118_124 VGND VGND VPWR VPWR sky130_fd_sc_hd__decap_3
X_6453_ _6885_/A _6449_/A _7228_/A _6452_/X _6446_/A VGND VGND VPWR VPWR _6455_/B
+ sky130_fd_sc_hd__a32o_2
X_9241_ clkload3/A _9241_/D load_slew374/X VGND VGND VPWR VPWR _9241_/Q sky130_fd_sc_hd__dfrtp_2
XFILLER_119_669 VGND VGND VPWR VPWR sky130_fd_sc_hd__decap_3
XFILLER_109_39 VGND VGND VPWR VPWR sky130_fd_sc_hd__decap_3
XFILLER_118_168 VGND VGND VPWR VPWR sky130_fd_sc_hd__decap_3
X_5404_ _5307_/A _5307_/B _5247_/X VGND VGND VPWR VPWR _5404_/X sky130_fd_sc_hd__a21o_2
X_9172_ _9296_/CLK _9172_/D load_slew386/X VGND VGND VPWR VPWR _9172_/Q sky130_fd_sc_hd__dfrtp_2
X_6384_ _6385_/B _6385_/C _6384_/B1 VGND VGND VPWR VPWR _6524_/B sky130_fd_sc_hd__o21a_2
XFILLER_127_691 VGND VGND VPWR VPWR sky130_fd_sc_hd__decap_3
X_8123_ _7440_/X _8080_/B _7569_/A VGND VGND VPWR VPWR _8123_/X sky130_fd_sc_hd__a21o_2
XFILLER_114_330 VGND VGND VPWR VPWR sky130_fd_sc_hd__decap_3
X_5335_ _5525_/A _5525_/B VGND VGND VPWR VPWR _5335_/Y sky130_fd_sc_hd__nor2_2
XFILLER_88_715 VGND VGND VPWR VPWR sky130_fd_sc_hd__fill_1
XFILLER_125_27 VGND VGND VPWR VPWR sky130_fd_sc_hd__decap_3
XFILLER_114_374 VGND VGND VPWR VPWR sky130_fd_sc_hd__decap_3
XFILLER_102_525 VGND VGND VPWR VPWR sky130_fd_sc_hd__fill_2
X_8054_ _8313_/A _8322_/A VGND VGND VPWR VPWR _8058_/B sky130_fd_sc_hd__nand2_2
X_5266_ _9307_/Q _9103_/Q _5266_/S VGND VGND VPWR VPWR _5267_/B sky130_fd_sc_hd__mux2_2
XFILLER_87_225 VGND VGND VPWR VPWR sky130_fd_sc_hd__decap_3
X_7005_ _6690_/A _6690_/B _7003_/X _7004_/X VGND VGND VPWR VPWR _7110_/B sky130_fd_sc_hd__a22oi_2
X_5197_ _5197_/A _5283_/B VGND VGND VPWR VPWR _5197_/Y sky130_fd_sc_hd__nor2_2
XFILLER_56_601 VGND VGND VPWR VPWR sky130_fd_sc_hd__decap_3
XFILLER_68_461 VGND VGND VPWR VPWR sky130_fd_sc_hd__decap_3
XTAP_TAPCELL_ROW_39_810 VGND VPWR sky130_fd_sc_hd__tapvpwrvgnd_1
XFILLER_56_645 VGND VGND VPWR VPWR sky130_fd_sc_hd__fill_2
XFILLER_56_667 VGND VGND VPWR VPWR sky130_fd_sc_hd__decap_3
XFILLER_55_144 VGND VGND VPWR VPWR sky130_fd_sc_hd__decap_3
XFILLER_83_464 VGND VGND VPWR VPWR sky130_fd_sc_hd__decap_3
X_8956_ _8956_/A VGND VGND VPWR VPWR _9319_/D sky130_fd_sc_hd__buf_1
X_7907_ _7924_/A _9217_/Q _7824_/A _7905_/X wire71/A VGND VGND VPWR VPWR _7907_/X
+ sky130_fd_sc_hd__o32a_2
X_8887_ _8887_/A VGND VGND VPWR VPWR _9286_/D sky130_fd_sc_hd__buf_1
XFILLER_12_704 VGND VGND VPWR VPWR sky130_fd_sc_hd__decap_3
X_7838_ _8083_/B VGND VGND VPWR VPWR _7913_/A sky130_fd_sc_hd__clkbuf_1
XTAP_TAPCELL_ROW_104_1679 VGND VPWR sky130_fd_sc_hd__tapvpwrvgnd_1
XFILLER_51_361 VGND VGND VPWR VPWR sky130_fd_sc_hd__decap_3
XFILLER_24_586 VGND VGND VPWR VPWR sky130_fd_sc_hd__fill_2
XFILLER_51_383 VGND VGND VPWR VPWR sky130_fd_sc_hd__decap_3
XFILLER_12_737 VGND VGND VPWR VPWR sky130_fd_sc_hd__decap_3
XFILLER_11_225 VGND VGND VPWR VPWR sky130_fd_sc_hd__fill_1
X_7769_ _8240_/A _8231_/B VGND VGND VPWR VPWR _7770_/B sky130_fd_sc_hd__nor2_2
XFILLER_8_719 VGND VGND VPWR VPWR sky130_fd_sc_hd__decap_3
XFILLER_11_247 VGND VGND VPWR VPWR sky130_fd_sc_hd__decap_3
Xclkload1 clkload1/A VGND VGND VPWR VPWR clkload1/Y sky130_fd_sc_hd__inv_8
XFILLER_50_12 VGND VGND VPWR VPWR sky130_fd_sc_hd__fill_2
XFILLER_109_113 VGND VGND VPWR VPWR sky130_fd_sc_hd__decap_3
XFILLER_109_146 VGND VGND VPWR VPWR sky130_fd_sc_hd__decap_3
XFILLER_50_56 VGND VGND VPWR VPWR sky130_fd_sc_hd__decap_3
XFILLER_119_3 VGND VGND VPWR VPWR sky130_fd_sc_hd__decap_3
XFILLER_124_127 VGND VGND VPWR VPWR sky130_fd_sc_hd__decap_3
XFILLER_118_691 VGND VGND VPWR VPWR sky130_fd_sc_hd__decap_3
XFILLER_1_3 VGND VGND VPWR VPWR sky130_fd_sc_hd__decap_3
XFILLER_3_468 VGND VGND VPWR VPWR sky130_fd_sc_hd__decap_3
XFILLER_79_726 VGND VGND VPWR VPWR sky130_fd_sc_hd__fill_2
XFILLER_105_396 VGND VGND VPWR VPWR sky130_fd_sc_hd__fill_1
XFILLER_59_76 VGND VGND VPWR VPWR sky130_fd_sc_hd__decap_3
Xfanout271 _9216_/Q VGND VGND VPWR VPWR _7924_/A sky130_fd_sc_hd__clkdlybuf4s25_1
XFILLER_115_60 VGND VGND VPWR VPWR sky130_fd_sc_hd__decap_3
Xfanout282 input7/X VGND VGND VPWR VPWR _7893_/A sky130_fd_sc_hd__clkdlybuf4s25_1
XFILLER_59_472 VGND VGND VPWR VPWR sky130_fd_sc_hd__decap_3
XFILLER_19_314 VGND VGND VPWR VPWR sky130_fd_sc_hd__decap_3
XFILLER_47_634 VGND VGND VPWR VPWR sky130_fd_sc_hd__decap_3
XFILLER_74_464 VGND VGND VPWR VPWR sky130_fd_sc_hd__decap_3
XFILLER_47_689 VGND VGND VPWR VPWR sky130_fd_sc_hd__decap_3
XFILLER_34_306 VGND VGND VPWR VPWR sky130_fd_sc_hd__fill_2
XFILLER_74_486 VGND VGND VPWR VPWR sky130_fd_sc_hd__decap_3
XFILLER_62_626 VGND VGND VPWR VPWR sky130_fd_sc_hd__decap_3
XFILLER_61_103 VGND VGND VPWR VPWR sky130_fd_sc_hd__decap_3
XTAP_TAPCELL_ROW_17_515 VGND VPWR sky130_fd_sc_hd__tapvpwrvgnd_1
XFILLER_62_637 VGND VGND VPWR VPWR sky130_fd_sc_hd__decap_3
XFILLER_61_169 VGND VGND VPWR VPWR sky130_fd_sc_hd__fill_2
XFILLER_91_52 VGND VGND VPWR VPWR sky130_fd_sc_hd__decap_3
XFILLER_15_564 VGND VGND VPWR VPWR sky130_fd_sc_hd__fill_2
XFILLER_91_63 VGND VGND VPWR VPWR sky130_fd_sc_hd__fill_2
XFILLER_42_361 VGND VGND VPWR VPWR sky130_fd_sc_hd__decap_3
XFILLER_15_575 VGND VGND VPWR VPWR sky130_fd_sc_hd__decap_3
XFILLER_91_74 VGND VGND VPWR VPWR sky130_fd_sc_hd__decap_3
XFILLER_42_383 VGND VGND VPWR VPWR sky130_fd_sc_hd__decap_3
XFILLER_91_96 VGND VGND VPWR VPWR sky130_fd_sc_hd__decap_3
XFILLER_7_741 VGND VGND VPWR VPWR sky130_fd_sc_hd__decap_3
XFILLER_116_606 VGND VGND VPWR VPWR sky130_fd_sc_hd__fill_1
XFILLER_128_477 VGND VGND VPWR VPWR sky130_fd_sc_hd__decap_3
XFILLER_7_774 VGND VGND VPWR VPWR sky130_fd_sc_hd__decap_3
XFILLER_115_116 VGND VGND VPWR VPWR sky130_fd_sc_hd__decap_3
XFILLER_109_691 VGND VGND VPWR VPWR sky130_fd_sc_hd__decap_3
XTAP_TAPCELL_ROW_94_1550 VGND VPWR sky130_fd_sc_hd__tapvpwrvgnd_1
XFILLER_130_119 VGND VGND VPWR VPWR sky130_fd_sc_hd__decap_3
X_5120_ _5990_/A _5878_/C _5120_/C VGND VGND VPWR VPWR _5120_/X sky130_fd_sc_hd__and3_2
XFILLER_69_225 VGND VGND VPWR VPWR sky130_fd_sc_hd__decap_3
XFILLER_69_236 VGND VGND VPWR VPWR sky130_fd_sc_hd__decap_3
XFILLER_123_193 VGND VGND VPWR VPWR sky130_fd_sc_hd__decap_3
XFILLER_97_567 VGND VGND VPWR VPWR sky130_fd_sc_hd__decap_3
XFILLER_85_707 VGND VGND VPWR VPWR sky130_fd_sc_hd__decap_3
X_5051_ _9320_/Q _9020_/Q _6206_/B VGND VGND VPWR VPWR _5051_/X sky130_fd_sc_hd__mux2_2
XFILLER_111_355 VGND VGND VPWR VPWR sky130_fd_sc_hd__decap_3
XFILLER_85_729 VGND VGND VPWR VPWR sky130_fd_sc_hd__decap_3
XFILLER_78_770 VGND VGND VPWR VPWR sky130_fd_sc_hd__decap_3
XFILLER_111_377 VGND VGND VPWR VPWR sky130_fd_sc_hd__fill_2
XFILLER_38_634 VGND VGND VPWR VPWR sky130_fd_sc_hd__decap_3
XFILLER_37_111 VGND VGND VPWR VPWR sky130_fd_sc_hd__fill_1
XFILLER_65_431 VGND VGND VPWR VPWR sky130_fd_sc_hd__decap_3
XFILLER_38_645 VGND VGND VPWR VPWR sky130_fd_sc_hd__decap_3
XFILLER_37_122 VGND VGND VPWR VPWR sky130_fd_sc_hd__decap_3
XFILLER_38_667 VGND VGND VPWR VPWR sky130_fd_sc_hd__decap_3
X_8810_ _8810_/A0 _6788_/B _8820_/S VGND VGND VPWR VPWR _8810_/X sky130_fd_sc_hd__mux2_2
XFILLER_37_144 VGND VGND VPWR VPWR sky130_fd_sc_hd__decap_3
XFILLER_92_250 VGND VGND VPWR VPWR sky130_fd_sc_hd__fill_2
XFILLER_65_464 VGND VGND VPWR VPWR sky130_fd_sc_hd__fill_2
XFILLER_53_615 VGND VGND VPWR VPWR sky130_fd_sc_hd__fill_1
XFILLER_65_486 VGND VGND VPWR VPWR sky130_fd_sc_hd__decap_3
XFILLER_1_94 VGND VGND VPWR VPWR sky130_fd_sc_hd__decap_3
XFILLER_53_637 VGND VGND VPWR VPWR sky130_fd_sc_hd__fill_1
XFILLER_37_188 VGND VGND VPWR VPWR sky130_fd_sc_hd__decap_3
XFILLER_111_18 VGND VGND VPWR VPWR sky130_fd_sc_hd__decap_3
X_8741_ _8741_/A _8741_/B VGND VGND VPWR VPWR _8742_/B sky130_fd_sc_hd__xnor2_2
XFILLER_18_380 VGND VGND VPWR VPWR sky130_fd_sc_hd__decap_3
X_5953_ _5953_/A _5953_/B VGND VGND VPWR VPWR _5960_/A sky130_fd_sc_hd__xnor2_2
XFILLER_80_445 VGND VGND VPWR VPWR sky130_fd_sc_hd__decap_3
XFILLER_52_136 VGND VGND VPWR VPWR sky130_fd_sc_hd__fill_1
X_4904_ _4876_/A _4903_/Y _4878_/A hold814/X VGND VGND VPWR VPWR _4904_/X sky130_fd_sc_hd__a2bb2o_2
XFILLER_52_169 VGND VGND VPWR VPWR sky130_fd_sc_hd__decap_3
X_5884_ _9124_/Q _6607_/B _6027_/B VGND VGND VPWR VPWR _5885_/C sky130_fd_sc_hd__a21o_2
X_8672_ _8707_/A _8672_/B VGND VGND VPWR VPWR _8714_/A sky130_fd_sc_hd__nor2_2
XFILLER_33_361 VGND VGND VPWR VPWR sky130_fd_sc_hd__decap_3
XFILLER_33_383 VGND VGND VPWR VPWR sky130_fd_sc_hd__decap_3
X_7623_ _7623_/A _7623_/B VGND VGND VPWR VPWR _7634_/B sky130_fd_sc_hd__xnor2_2
X_4835_ _4835_/A VGND VGND VPWR VPWR _9162_/D sky130_fd_sc_hd__buf_1
XFILLER_60_180 VGND VGND VPWR VPWR sky130_fd_sc_hd__decap_3
XFILLER_119_411 VGND VGND VPWR VPWR sky130_fd_sc_hd__decap_3
X_4766_ _4766_/A VGND VGND VPWR VPWR _9129_/D sky130_fd_sc_hd__buf_1
X_7554_ _7554_/A _7554_/B VGND VGND VPWR VPWR _7556_/C sky130_fd_sc_hd__xnor2_2
X_6505_ _6505_/A _6505_/B VGND VGND VPWR VPWR _6506_/A sky130_fd_sc_hd__xnor2_4
XFILLER_119_455 VGND VGND VPWR VPWR sky130_fd_sc_hd__decap_3
X_7485_ _7486_/B _7467_/X _7486_/C _7486_/D VGND VGND VPWR VPWR _7489_/A sky130_fd_sc_hd__a31o_4
XFILLER_107_617 VGND VGND VPWR VPWR sky130_fd_sc_hd__decap_3
X_4697_ _4697_/A VGND VGND VPWR VPWR _9096_/D sky130_fd_sc_hd__buf_1
XFILLER_119_477 VGND VGND VPWR VPWR sky130_fd_sc_hd__fill_2
XFILLER_20_15 VGND VGND VPWR VPWR sky130_fd_sc_hd__decap_3
XFILLER_106_105 VGND VGND VPWR VPWR sky130_fd_sc_hd__decap_3
XFILLER_106_116 VGND VGND VPWR VPWR sky130_fd_sc_hd__decap_3
X_9224_ _9227_/CLK _9224_/D load_slew416/X VGND VGND VPWR VPWR _9224_/Q sky130_fd_sc_hd__dfrtp_2
XFILLER_119_499 VGND VGND VPWR VPWR sky130_fd_sc_hd__decap_3
X_6436_ _6436_/A _6436_/B VGND VGND VPWR VPWR _6436_/Y sky130_fd_sc_hd__nor2_2
XFILLER_105_9 VGND VGND VPWR VPWR sky130_fd_sc_hd__decap_3
X_6367_ _6369_/A _6369_/B VGND VGND VPWR VPWR _6367_/Y sky130_fd_sc_hd__nor2_2
X_9155_ _9171_/CLK _9155_/D load_slew396/X VGND VGND VPWR VPWR _9155_/Q sky130_fd_sc_hd__dfrtp_2
XTAP_TAPCELL_ROW_54_1011 VGND VPWR sky130_fd_sc_hd__tapvpwrvgnd_1
XFILLER_0_405 VGND VGND VPWR VPWR sky130_fd_sc_hd__decap_3
XFILLER_121_108 VGND VGND VPWR VPWR sky130_fd_sc_hd__decap_3
XFILLER_121_119 VGND VGND VPWR VPWR sky130_fd_sc_hd__decap_3
XFILLER_0_427 VGND VGND VPWR VPWR sky130_fd_sc_hd__decap_3
X_5318_ _5803_/A VGND VGND VPWR VPWR _5656_/A sky130_fd_sc_hd__inv_2
X_8106_ _9216_/Q _8106_/B VGND VGND VPWR VPWR _8106_/Y sky130_fd_sc_hd__nor2_2
XFILLER_115_694 VGND VGND VPWR VPWR sky130_fd_sc_hd__decap_3
XFILLER_130_620 VGND VGND VPWR VPWR sky130_fd_sc_hd__decap_3
X_6298_ _6291_/A _6291_/B _6297_/C _6298_/B2 VGND VGND VPWR VPWR _6298_/X sky130_fd_sc_hd__a22o_2
X_9086_ _9338_/CLK _9086_/D fanout367/X VGND VGND VPWR VPWR _9086_/Q sky130_fd_sc_hd__dfrtp_2
XFILLER_0_449 VGND VGND VPWR VPWR sky130_fd_sc_hd__decap_3
XFILLER_102_344 VGND VGND VPWR VPWR sky130_fd_sc_hd__decap_3
XFILLER_76_718 VGND VGND VPWR VPWR sky130_fd_sc_hd__decap_3
X_5249_ _5249_/A VGND VGND VPWR VPWR _7764_/A sky130_fd_sc_hd__clkbuf_4
X_8037_ _8037_/A _8037_/B VGND VGND VPWR VPWR _8038_/B sky130_fd_sc_hd__xor2_2
XFILLER_29_46 VGND VGND VPWR VPWR sky130_fd_sc_hd__decap_3
XFILLER_29_57 VGND VGND VPWR VPWR sky130_fd_sc_hd__decap_3
XFILLER_130_697 VGND VGND VPWR VPWR sky130_fd_sc_hd__decap_3
XFILLER_102_399 VGND VGND VPWR VPWR sky130_fd_sc_hd__decap_3
XFILLER_75_228 VGND VGND VPWR VPWR sky130_fd_sc_hd__fill_1
XFILLER_28_100 VGND VGND VPWR VPWR sky130_fd_sc_hd__decap_3
XFILLER_29_656 VGND VGND VPWR VPWR sky130_fd_sc_hd__decap_3
XFILLER_28_144 VGND VGND VPWR VPWR sky130_fd_sc_hd__decap_3
XTAP_TAPCELL_ROW_106_1708 VGND VPWR sky130_fd_sc_hd__tapvpwrvgnd_1
XFILLER_45_12 VGND VGND VPWR VPWR sky130_fd_sc_hd__decap_3
XTAP_TAPCELL_ROW_106_1719 VGND VPWR sky130_fd_sc_hd__tapvpwrvgnd_1
XFILLER_71_401 VGND VGND VPWR VPWR sky130_fd_sc_hd__decap_3
XFILLER_28_177 VGND VGND VPWR VPWR sky130_fd_sc_hd__decap_3
XFILLER_16_339 VGND VGND VPWR VPWR sky130_fd_sc_hd__decap_3
X_8939_ _8939_/A VGND VGND VPWR VPWR _9311_/D sky130_fd_sc_hd__buf_1
XFILLER_71_456 VGND VGND VPWR VPWR sky130_fd_sc_hd__decap_3
XFILLER_43_158 VGND VGND VPWR VPWR sky130_fd_sc_hd__decap_3
XFILLER_43_169 VGND VGND VPWR VPWR sky130_fd_sc_hd__fill_1
XTAP_TAPCELL_ROW_65_1162 VGND VPWR sky130_fd_sc_hd__tapvpwrvgnd_1
XFILLER_101_40 VGND VGND VPWR VPWR sky130_fd_sc_hd__decap_3
XFILLER_52_670 VGND VGND VPWR VPWR sky130_fd_sc_hd__decap_3
XTAP_TAPCELL_ROW_42_849 VGND VPWR sky130_fd_sc_hd__tapvpwrvgnd_1
XFILLER_61_33 VGND VGND VPWR VPWR sky130_fd_sc_hd__decap_3
XFILLER_129_208 VGND VGND VPWR VPWR sky130_fd_sc_hd__decap_3
XFILLER_12_578 VGND VGND VPWR VPWR sky130_fd_sc_hd__decap_3
XFILLER_12_589 VGND VGND VPWR VPWR sky130_fd_sc_hd__fill_1
XTAP_TAPCELL_ROW_22_573 VGND VPWR sky130_fd_sc_hd__tapvpwrvgnd_1
XTAP_TAPCELL_ROW_22_584 VGND VPWR sky130_fd_sc_hd__tapvpwrvgnd_1
XTAP_TAPCELL_ROW_117_1859 VGND VPWR sky130_fd_sc_hd__tapvpwrvgnd_1
XFILLER_4_722 VGND VGND VPWR VPWR sky130_fd_sc_hd__decap_3
XFILLER_125_447 VGND VGND VPWR VPWR sky130_fd_sc_hd__fill_1
XFILLER_4_755 VGND VGND VPWR VPWR sky130_fd_sc_hd__fill_1
XFILLER_125_469 VGND VGND VPWR VPWR sky130_fd_sc_hd__fill_2
XFILLER_98_309 VGND VGND VPWR VPWR sky130_fd_sc_hd__decap_3
XFILLER_4_766 VGND VGND VPWR VPWR sky130_fd_sc_hd__decap_3
XFILLER_3_243 VGND VGND VPWR VPWR sky130_fd_sc_hd__decap_3
XFILLER_79_501 VGND VGND VPWR VPWR sky130_fd_sc_hd__decap_3
XFILLER_3_265 VGND VGND VPWR VPWR sky130_fd_sc_hd__fill_1
XFILLER_121_620 VGND VGND VPWR VPWR sky130_fd_sc_hd__decap_3
XFILLER_79_556 VGND VGND VPWR VPWR sky130_fd_sc_hd__decap_3
XFILLER_79_567 VGND VGND VPWR VPWR sky130_fd_sc_hd__decap_3
XFILLER_120_130 VGND VGND VPWR VPWR sky130_fd_sc_hd__decap_3
XFILLER_94_504 VGND VGND VPWR VPWR sky130_fd_sc_hd__decap_3
XFILLER_67_718 VGND VGND VPWR VPWR sky130_fd_sc_hd__decap_3
XFILLER_120_141 VGND VGND VPWR VPWR sky130_fd_sc_hd__decap_3
XFILLER_94_515 VGND VGND VPWR VPWR sky130_fd_sc_hd__decap_3
XFILLER_67_729 VGND VGND VPWR VPWR sky130_fd_sc_hd__decap_3
XFILLER_66_206 VGND VGND VPWR VPWR sky130_fd_sc_hd__fill_2
XFILLER_20_9 VGND VGND VPWR VPWR sky130_fd_sc_hd__decap_3
XFILLER_121_686 VGND VGND VPWR VPWR sky130_fd_sc_hd__decap_3
XFILLER_120_174 VGND VGND VPWR VPWR sky130_fd_sc_hd__decap_3
XFILLER_94_559 VGND VGND VPWR VPWR sky130_fd_sc_hd__decap_3
XFILLER_47_420 VGND VGND VPWR VPWR sky130_fd_sc_hd__decap_3
XFILLER_75_773 VGND VGND VPWR VPWR sky130_fd_sc_hd__decap_3
XFILLER_90_721 VGND VGND VPWR VPWR sky130_fd_sc_hd__decap_3
XFILLER_62_412 VGND VGND VPWR VPWR sky130_fd_sc_hd__decap_3
XFILLER_47_497 VGND VGND VPWR VPWR sky130_fd_sc_hd__decap_3
XFILLER_19_188 VGND VGND VPWR VPWR sky130_fd_sc_hd__decap_3
XFILLER_62_445 VGND VGND VPWR VPWR sky130_fd_sc_hd__decap_3
XFILLER_34_147 VGND VGND VPWR VPWR sky130_fd_sc_hd__decap_3
XFILLER_90_776 VGND VGND VPWR VPWR sky130_fd_sc_hd__fill_1
XFILLER_50_618 VGND VGND VPWR VPWR sky130_fd_sc_hd__decap_3
XFILLER_22_309 VGND VGND VPWR VPWR sky130_fd_sc_hd__decap_3
XFILLER_50_629 VGND VGND VPWR VPWR sky130_fd_sc_hd__decap_3
XFILLER_42_180 VGND VGND VPWR VPWR sky130_fd_sc_hd__fill_2
XFILLER_30_320 VGND VGND VPWR VPWR sky130_fd_sc_hd__fill_2
X_4620_ _4620_/A VGND VGND VPWR VPWR _9060_/D sky130_fd_sc_hd__buf_1
XFILLER_30_386 VGND VGND VPWR VPWR sky130_fd_sc_hd__decap_3
XFILLER_129_753 VGND VGND VPWR VPWR sky130_fd_sc_hd__decap_3
XFILLER_128_230 VGND VGND VPWR VPWR sky130_fd_sc_hd__decap_3
X_4551_ _4551_/A VGND VGND VPWR VPWR _9027_/D sky130_fd_sc_hd__buf_1
Xmax_cap202 _5935_/X VGND VGND VPWR VPWR _6826_/A1 sky130_fd_sc_hd__clkbuf_2
X_7270_ _7508_/A _7270_/B VGND VGND VPWR VPWR _7270_/Y sky130_fd_sc_hd__xnor2_2
Xmax_cap213 _5457_/B VGND VGND VPWR VPWR _5878_/C sky130_fd_sc_hd__buf_6
X_6221_ _6221_/A _6221_/B VGND VGND VPWR VPWR _6260_/C sky130_fd_sc_hd__or2_4
XFILLER_116_469 VGND VGND VPWR VPWR sky130_fd_sc_hd__decap_3
XFILLER_103_119 VGND VGND VPWR VPWR sky130_fd_sc_hd__decap_3
XFILLER_106_18 VGND VGND VPWR VPWR sky130_fd_sc_hd__decap_3
X_6152_ _5860_/A wire62/X _6054_/X _6151_/Y VGND VGND VPWR VPWR _6152_/Y sky130_fd_sc_hd__o22ai_2
XFILLER_112_620 VGND VGND VPWR VPWR sky130_fd_sc_hd__decap_3
XFILLER_106_29 VGND VGND VPWR VPWR sky130_fd_sc_hd__fill_2
X_5103_ _5103_/A _5103_/B _5103_/C VGND VGND VPWR VPWR _5105_/B sky130_fd_sc_hd__or3_4
X_6083_ _6094_/B _6083_/B VGND VGND VPWR VPWR _6083_/X sky130_fd_sc_hd__and2_2
Xhold1205 _9009_/X VGND VGND VPWR VPWR _9010_/A sky130_fd_sc_hd__dlygate4sd3_1
Xhold1216 _9074_/Q VGND VGND VPWR VPWR _4683_/A1 sky130_fd_sc_hd__dlygate4sd3_1
XFILLER_85_537 VGND VGND VPWR VPWR sky130_fd_sc_hd__fill_1
XFILLER_57_228 VGND VGND VPWR VPWR sky130_fd_sc_hd__decap_3
X_5034_ _5034_/A _5034_/B VGND VGND VPWR VPWR _5034_/Y sky130_fd_sc_hd__nor2_2
Xhold1227 _9249_/Q VGND VGND VPWR VPWR _8841_/A1 sky130_fd_sc_hd__dlygate4sd3_1
Xhold1238 _5813_/Y VGND VGND VPWR VPWR _5814_/B sky130_fd_sc_hd__dlygate4sd3_1
Xhold1249 _4914_/Y VGND VGND VPWR VPWR _9234_/D sky130_fd_sc_hd__dlygate4sd3_1
XFILLER_85_559 VGND VGND VPWR VPWR sky130_fd_sc_hd__fill_1
XFILLER_66_740 VGND VGND VPWR VPWR sky130_fd_sc_hd__decap_3
XFILLER_38_453 VGND VGND VPWR VPWR sky130_fd_sc_hd__decap_3
XFILLER_93_570 VGND VGND VPWR VPWR sky130_fd_sc_hd__decap_3
XFILLER_81_710 VGND VGND VPWR VPWR sky130_fd_sc_hd__decap_3
XFILLER_81_732 VGND VGND VPWR VPWR sky130_fd_sc_hd__decap_3
XFILLER_26_648 VGND VGND VPWR VPWR sky130_fd_sc_hd__decap_3
XFILLER_25_125 VGND VGND VPWR VPWR sky130_fd_sc_hd__decap_3
XFILLER_53_445 VGND VGND VPWR VPWR sky130_fd_sc_hd__decap_3
X_6985_ _6985_/A _6985_/B VGND VGND VPWR VPWR _7020_/B sky130_fd_sc_hd__nand2_2
XTAP_TAPCELL_ROW_0_268 VGND VPWR sky130_fd_sc_hd__tapvpwrvgnd_1
XFILLER_81_765 VGND VGND VPWR VPWR sky130_fd_sc_hd__decap_3
XFILLER_25_147 VGND VGND VPWR VPWR sky130_fd_sc_hd__decap_3
XTAP_TAPCELL_ROW_0_279 VGND VPWR sky130_fd_sc_hd__tapvpwrvgnd_1
XFILLER_15_15 VGND VGND VPWR VPWR sky130_fd_sc_hd__decap_3
X_8724_ _8771_/A _8771_/B _8765_/B VGND VGND VPWR VPWR _8746_/A sky130_fd_sc_hd__a21oi_4
X_5936_ _5936_/A _5939_/S VGND VGND VPWR VPWR _5936_/Y sky130_fd_sc_hd__xnor2_2
XFILLER_34_670 VGND VGND VPWR VPWR sky130_fd_sc_hd__decap_3
XFILLER_15_48 VGND VGND VPWR VPWR sky130_fd_sc_hd__decap_3
XFILLER_80_286 VGND VGND VPWR VPWR sky130_fd_sc_hd__decap_3
X_8655_ _8690_/A _8655_/B VGND VGND VPWR VPWR _8700_/B sky130_fd_sc_hd__nand2_2
XTAP_TAPCELL_ROW_101_1649 VGND VPWR sky130_fd_sc_hd__tapvpwrvgnd_1
XFILLER_33_180 VGND VGND VPWR VPWR sky130_fd_sc_hd__fill_1
X_5867_ _7612_/A1 _7612_/A2 _5743_/Y VGND VGND VPWR VPWR _7604_/A sky130_fd_sc_hd__a21o_2
X_7606_ _7604_/A _8240_/A _7418_/B _8242_/A _7945_/A VGND VGND VPWR VPWR _7607_/B
+ sky130_fd_sc_hd__o32a_2
X_4818_ _4818_/A VGND VGND VPWR VPWR _9154_/D sky130_fd_sc_hd__buf_1
X_8586_ _8554_/B _8585_/Y _8572_/B _8737_/A VGND VGND VPWR VPWR _8587_/B sky130_fd_sc_hd__o22a_2
Xrebuffer602 _7285_/C VGND VGND VPWR VPWR _7279_/B sky130_fd_sc_hd__buf_2
X_5798_ _5087_/B _5669_/B _5797_/X VGND VGND VPWR VPWR _5799_/B sky130_fd_sc_hd__a21oi_2
X_7537_ _7668_/B _7537_/B VGND VGND VPWR VPWR _7538_/B sky130_fd_sc_hd__xnor2_2
XTAP_TAPCELL_ROW_60_1092 VGND VPWR sky130_fd_sc_hd__tapvpwrvgnd_1
XFILLER_5_508 VGND VGND VPWR VPWR sky130_fd_sc_hd__fill_1
X_4749_ _4749_/A VGND VGND VPWR VPWR _9121_/D sky130_fd_sc_hd__buf_1
Xrebuffer657 _6506_/Y VGND VGND VPWR VPWR _6783_/A2 sky130_fd_sc_hd__buf_2
Xrebuffer679 _7748_/S VGND VGND VPWR VPWR _7994_/A1 sky130_fd_sc_hd__buf_4
X_7468_ _7468_/A _7468_/B _7468_/C VGND VGND VPWR VPWR _7486_/B sky130_fd_sc_hd__or3_4
XFILLER_103_6 VGND VGND VPWR VPWR sky130_fd_sc_hd__decap_3
X_9207_ _9209_/CLK _9207_/D fanout418/X VGND VGND VPWR VPWR _9207_/Q sky130_fd_sc_hd__dfrtp_2
X_6419_ _5221_/A _6095_/B _6395_/Y VGND VGND VPWR VPWR _6420_/B sky130_fd_sc_hd__o21ai_2
Xoutput25 _9194_/Q VGND VGND VPWR VPWR wire229/A sky130_fd_sc_hd__buf_1
XFILLER_122_406 VGND VGND VPWR VPWR sky130_fd_sc_hd__decap_3
XFILLER_1_703 VGND VGND VPWR VPWR sky130_fd_sc_hd__decap_3
X_7399_ _7369_/A _7369_/B _7370_/A VGND VGND VPWR VPWR _7399_/X sky130_fd_sc_hd__a21o_2
Xoutput36 _9178_/Q VGND VGND VPWR VPWR wire218/A sky130_fd_sc_hd__buf_1
XFILLER_103_620 VGND VGND VPWR VPWR sky130_fd_sc_hd__decap_3
X_9138_ _9344_/CLK _9138_/D fanout379/X VGND VGND VPWR VPWR _9138_/Q sky130_fd_sc_hd__dfrtp_2
XFILLER_1_747 VGND VGND VPWR VPWR sky130_fd_sc_hd__decap_3
XFILLER_115_491 VGND VGND VPWR VPWR sky130_fd_sc_hd__decap_3
XTAP_TAPCELL_ROW_112_1789 VGND VPWR sky130_fd_sc_hd__tapvpwrvgnd_1
XFILLER_0_268 VGND VGND VPWR VPWR sky130_fd_sc_hd__decap_3
X_9069_ _9171_/CLK _9069_/D load_slew394/X VGND VGND VPWR VPWR _9069_/Q sky130_fd_sc_hd__dfrtp_2
XFILLER_49_729 VGND VGND VPWR VPWR sky130_fd_sc_hd__decap_3
XFILLER_102_163 VGND VGND VPWR VPWR sky130_fd_sc_hd__decap_3
XFILLER_103_686 VGND VGND VPWR VPWR sky130_fd_sc_hd__decap_3
XFILLER_130_483 VGND VGND VPWR VPWR sky130_fd_sc_hd__decap_3
XFILLER_76_559 VGND VGND VPWR VPWR sky130_fd_sc_hd__decap_3
XFILLER_56_44 VGND VGND VPWR VPWR sky130_fd_sc_hd__decap_3
XTAP_TAPCELL_ROW_47_919 VGND VPWR sky130_fd_sc_hd__tapvpwrvgnd_1
XFILLER_57_773 VGND VGND VPWR VPWR sky130_fd_sc_hd__decap_3
XFILLER_56_66 VGND VGND VPWR VPWR sky130_fd_sc_hd__decap_3
XFILLER_29_464 VGND VGND VPWR VPWR sky130_fd_sc_hd__fill_1
XFILLER_56_88 VGND VGND VPWR VPWR sky130_fd_sc_hd__decap_3
XFILLER_84_592 VGND VGND VPWR VPWR sky130_fd_sc_hd__decap_3
XFILLER_17_648 VGND VGND VPWR VPWR sky130_fd_sc_hd__fill_2
XTAP_TAPCELL_ROW_27_643 VGND VPWR sky130_fd_sc_hd__tapvpwrvgnd_1
XFILLER_71_231 VGND VGND VPWR VPWR sky130_fd_sc_hd__fill_1
XFILLER_112_50 VGND VGND VPWR VPWR sky130_fd_sc_hd__decap_3
XFILLER_44_456 VGND VGND VPWR VPWR sky130_fd_sc_hd__decap_3
XFILLER_16_147 VGND VGND VPWR VPWR sky130_fd_sc_hd__decap_3
XFILLER_72_776 VGND VGND VPWR VPWR sky130_fd_sc_hd__fill_1
XFILLER_32_618 VGND VGND VPWR VPWR sky130_fd_sc_hd__fill_2
XFILLER_25_670 VGND VGND VPWR VPWR sky130_fd_sc_hd__fill_2
XFILLER_112_94 VGND VGND VPWR VPWR sky130_fd_sc_hd__fill_1
XFILLER_25_692 VGND VGND VPWR VPWR sky130_fd_sc_hd__decap_3
XFILLER_24_180 VGND VGND VPWR VPWR sky130_fd_sc_hd__decap_3
XFILLER_40_651 VGND VGND VPWR VPWR sky130_fd_sc_hd__decap_3
XFILLER_40_695 VGND VGND VPWR VPWR sky130_fd_sc_hd__decap_3
XFILLER_12_386 VGND VGND VPWR VPWR sky130_fd_sc_hd__decap_3
XFILLER_8_368 VGND VGND VPWR VPWR sky130_fd_sc_hd__fill_2
XFILLER_126_701 VGND VGND VPWR VPWR sky130_fd_sc_hd__decap_3
XTAP_TAPCELL_ROW_78_1331 VGND VPWR sky130_fd_sc_hd__tapvpwrvgnd_1
XFILLER_126_734 VGND VGND VPWR VPWR sky130_fd_sc_hd__decap_3
XFILLER_125_211 VGND VGND VPWR VPWR sky130_fd_sc_hd__decap_3
XFILLER_4_552 VGND VGND VPWR VPWR sky130_fd_sc_hd__fill_1
XFILLER_125_255 VGND VGND VPWR VPWR sky130_fd_sc_hd__decap_3
XFILLER_98_106 VGND VGND VPWR VPWR sky130_fd_sc_hd__decap_3
XFILLER_4_574 VGND VGND VPWR VPWR sky130_fd_sc_hd__fill_1
XFILLER_113_417 VGND VGND VPWR VPWR sky130_fd_sc_hd__decap_3
XFILLER_106_480 VGND VGND VPWR VPWR sky130_fd_sc_hd__decap_3
XFILLER_98_139 VGND VGND VPWR VPWR sky130_fd_sc_hd__fill_1
XFILLER_97_51 VGND VGND VPWR VPWR sky130_fd_sc_hd__decap_3
XFILLER_4_596 VGND VGND VPWR VPWR sky130_fd_sc_hd__fill_2
XFILLER_79_331 VGND VGND VPWR VPWR sky130_fd_sc_hd__decap_3
XFILLER_39_206 VGND VGND VPWR VPWR sky130_fd_sc_hd__decap_3
XFILLER_121_472 VGND VGND VPWR VPWR sky130_fd_sc_hd__decap_3
XFILLER_67_537 VGND VGND VPWR VPWR sky130_fd_sc_hd__decap_3
XFILLER_39_228 VGND VGND VPWR VPWR sky130_fd_sc_hd__decap_3
XFILLER_48_773 VGND VGND VPWR VPWR sky130_fd_sc_hd__decap_3
XFILLER_94_389 VGND VGND VPWR VPWR sky130_fd_sc_hd__fill_2
XFILLER_47_261 VGND VGND VPWR VPWR sky130_fd_sc_hd__fill_2
XTAP_TAPCELL_ROW_89_1482 VGND VPWR sky130_fd_sc_hd__tapvpwrvgnd_1
XFILLER_75_581 VGND VGND VPWR VPWR sky130_fd_sc_hd__decap_3
XFILLER_63_732 VGND VGND VPWR VPWR sky130_fd_sc_hd__decap_3
XFILLER_35_423 VGND VGND VPWR VPWR sky130_fd_sc_hd__decap_3
XFILLER_90_562 VGND VGND VPWR VPWR sky130_fd_sc_hd__decap_3
XFILLER_50_404 VGND VGND VPWR VPWR sky130_fd_sc_hd__decap_3
X_6770_ _6770_/A _6770_/B _6907_/B VGND VGND VPWR VPWR _6770_/X sky130_fd_sc_hd__and3_2
XFILLER_22_106 VGND VGND VPWR VPWR sky130_fd_sc_hd__decap_3
X_5721_ _7098_/A _7099_/B _8066_/A _5720_/X VGND VGND VPWR VPWR _5721_/X sky130_fd_sc_hd__a31o_4
XFILLER_31_662 VGND VGND VPWR VPWR sky130_fd_sc_hd__fill_1
X_8440_ _8446_/A _8566_/A VGND VGND VPWR VPWR _8441_/C sky130_fd_sc_hd__nand2_2
XFILLER_31_673 VGND VGND VPWR VPWR sky130_fd_sc_hd__decap_3
XFILLER_30_150 VGND VGND VPWR VPWR sky130_fd_sc_hd__fill_2
X_5652_ _5552_/A _5552_/B _5553_/A VGND VGND VPWR VPWR _5652_/X sky130_fd_sc_hd__a21o_2
X_4603_ _4603_/A VGND VGND VPWR VPWR _9052_/D sky130_fd_sc_hd__buf_1
XFILLER_129_550 VGND VGND VPWR VPWR sky130_fd_sc_hd__decap_3
X_8371_ _8379_/A _8370_/Y _8374_/B VGND VGND VPWR VPWR _8371_/X sky130_fd_sc_hd__a21o_2
XFILLER_129_561 VGND VGND VPWR VPWR sky130_fd_sc_hd__decap_3
XFILLER_117_712 VGND VGND VPWR VPWR sky130_fd_sc_hd__decap_3
XFILLER_7_60 VGND VGND VPWR VPWR sky130_fd_sc_hd__fill_1
X_4534_ hold825/X hold969/X _4544_/S VGND VGND VPWR VPWR _4535_/A sky130_fd_sc_hd__mux2_2
X_7322_ _6250_/A _5999_/B _7951_/A VGND VGND VPWR VPWR _7324_/A sky130_fd_sc_hd__a21oi_2
XFILLER_129_594 VGND VGND VPWR VPWR sky130_fd_sc_hd__decap_3
XFILLER_117_756 VGND VGND VPWR VPWR sky130_fd_sc_hd__decap_3
XFILLER_116_244 VGND VGND VPWR VPWR sky130_fd_sc_hd__decap_3
X_7253_ _7253_/A _7253_/B VGND VGND VPWR VPWR _7254_/B sky130_fd_sc_hd__xor2_2
XFILLER_117_39 VGND VGND VPWR VPWR sky130_fd_sc_hd__decap_3
XFILLER_104_428 VGND VGND VPWR VPWR sky130_fd_sc_hd__fill_2
X_6204_ _6290_/A _6204_/B VGND VGND VPWR VPWR _6369_/B sky130_fd_sc_hd__xnor2_4
X_7184_ _7184_/A _7184_/B VGND VGND VPWR VPWR _7193_/A sky130_fd_sc_hd__xnor2_2
XFILLER_98_651 VGND VGND VPWR VPWR sky130_fd_sc_hd__decap_3
X_6135_ _6821_/S _6133_/X _6134_/X VGND VGND VPWR VPWR _6136_/B sky130_fd_sc_hd__a21oi_2
XFILLER_58_504 VGND VGND VPWR VPWR sky130_fd_sc_hd__decap_3
XFILLER_98_673 VGND VGND VPWR VPWR sky130_fd_sc_hd__decap_3
XFILLER_97_150 VGND VGND VPWR VPWR sky130_fd_sc_hd__decap_3
XFILLER_97_172 VGND VGND VPWR VPWR sky130_fd_sc_hd__fill_2
XFILLER_100_623 VGND VGND VPWR VPWR sky130_fd_sc_hd__decap_3
Xhold1002 _9083_/Q VGND VGND VPWR VPWR _4702_/A1 sky130_fd_sc_hd__dlygate4sd3_1
XTAP_TAPCELL_ROW_5_349 VGND VPWR sky130_fd_sc_hd__tapvpwrvgnd_1
Xhold1013 _4780_/X VGND VGND VPWR VPWR _4781_/A sky130_fd_sc_hd__dlygate4sd3_1
X_6066_ _6069_/B VGND VGND VPWR VPWR _6387_/B sky130_fd_sc_hd__inv_2
Xhold1024 _4855_/X VGND VGND VPWR VPWR _4856_/A sky130_fd_sc_hd__dlygate4sd3_1
Xload_slew293 _6790_/A VGND VGND VPWR VPWR _6788_/A sky130_fd_sc_hd__buf_4
Xhold1035 _9124_/Q VGND VGND VPWR VPWR _4788_/A1 sky130_fd_sc_hd__dlygate4sd3_1
XFILLER_85_345 VGND VGND VPWR VPWR sky130_fd_sc_hd__decap_3
Xhold1046 _4587_/X VGND VGND VPWR VPWR _4588_/A sky130_fd_sc_hd__dlygate4sd3_1
XFILLER_100_678 VGND VGND VPWR VPWR sky130_fd_sc_hd__decap_3
X_5017_ _5042_/A _5017_/B VGND VGND VPWR VPWR _5017_/Y sky130_fd_sc_hd__nor2_2
Xhold1057 _9118_/Q VGND VGND VPWR VPWR _4775_/A1 sky130_fd_sc_hd__dlygate4sd3_1
XFILLER_73_518 VGND VGND VPWR VPWR sky130_fd_sc_hd__decap_3
XFILLER_45_209 VGND VGND VPWR VPWR sky130_fd_sc_hd__decap_3
Xhold1068 _9133_/Q VGND VGND VPWR VPWR _4807_/A1 sky130_fd_sc_hd__dlygate4sd3_1
Xhold1079 _8879_/X VGND VGND VPWR VPWR _8880_/A sky130_fd_sc_hd__dlygate4sd3_1
XFILLER_26_401 VGND VGND VPWR VPWR sky130_fd_sc_hd__decap_3
XFILLER_66_592 VGND VGND VPWR VPWR sky130_fd_sc_hd__decap_3
XFILLER_54_732 VGND VGND VPWR VPWR sky130_fd_sc_hd__decap_3
XFILLER_81_540 VGND VGND VPWR VPWR sky130_fd_sc_hd__fill_1
XFILLER_26_456 VGND VGND VPWR VPWR sky130_fd_sc_hd__decap_3
XFILLER_54_776 VGND VGND VPWR VPWR sky130_fd_sc_hd__fill_1
XFILLER_26_69 VGND VGND VPWR VPWR sky130_fd_sc_hd__fill_2
XTAP_TAPCELL_ROW_24_602 VGND VPWR sky130_fd_sc_hd__tapvpwrvgnd_1
XFILLER_13_106 VGND VGND VPWR VPWR sky130_fd_sc_hd__decap_3
X_6968_ _7058_/B _7058_/C _6967_/A VGND VGND VPWR VPWR _6969_/C sky130_fd_sc_hd__a21o_2
XFILLER_13_117 VGND VGND VPWR VPWR sky130_fd_sc_hd__decap_3
X_8707_ _8707_/A _8707_/B VGND VGND VPWR VPWR _8707_/X sky130_fd_sc_hd__or2_2
XTAP_TAPCELL_ROW_62_1121 VGND VPWR sky130_fd_sc_hd__tapvpwrvgnd_1
X_5919_ _5808_/A _5808_/B _5918_/X VGND VGND VPWR VPWR _5965_/A sky130_fd_sc_hd__o21a_2
XFILLER_41_459 VGND VGND VPWR VPWR sky130_fd_sc_hd__decap_3
XFILLER_22_640 VGND VGND VPWR VPWR sky130_fd_sc_hd__decap_3
X_6899_ _6899_/A _6899_/B VGND VGND VPWR VPWR _7148_/B sky130_fd_sc_hd__nand2_2
XTAP_TAPCELL_ROW_52_977 VGND VPWR sky130_fd_sc_hd__tapvpwrvgnd_1
XTAP_TAPCELL_ROW_52_988 VGND VPWR sky130_fd_sc_hd__tapvpwrvgnd_1
XFILLER_42_35 VGND VGND VPWR VPWR sky130_fd_sc_hd__fill_2
X_8638_ _8605_/A _8632_/Y _8464_/Y _8633_/X _8637_/X VGND VGND VPWR VPWR _8638_/Y
+ sky130_fd_sc_hd__o221ai_4
XFILLER_21_172 VGND VGND VPWR VPWR sky130_fd_sc_hd__decap_3
Xrebuffer421 _8122_/X VGND VGND VPWR VPWR _8277_/A sky130_fd_sc_hd__buf_2
X_8569_ _8562_/A _8560_/A _8566_/Y _8568_/X VGND VGND VPWR VPWR _8570_/B sky130_fd_sc_hd__o31a_2
Xrebuffer432 _8510_/B1_N VGND VGND VPWR VPWR _8507_/A sky130_fd_sc_hd__buf_2
Xrebuffer443 _7431_/X VGND VGND VPWR VPWR _7433_/A sky130_fd_sc_hd__buf_2
XFILLER_5_305 VGND VGND VPWR VPWR sky130_fd_sc_hd__decap_3
Xrebuffer454 wire146/X VGND VGND VPWR VPWR _6250_/A sky130_fd_sc_hd__buf_2
XFILLER_107_211 VGND VGND VPWR VPWR sky130_fd_sc_hd__decap_3
XFILLER_5_327 VGND VGND VPWR VPWR sky130_fd_sc_hd__decap_3
Xrebuffer465 _7313_/C VGND VGND VPWR VPWR _7081_/A sky130_fd_sc_hd__buf_2
Xrebuffer476 _7652_/Y VGND VGND VPWR VPWR _7697_/A sky130_fd_sc_hd__buf_2
Xrebuffer487 _6352_/A VGND VGND VPWR VPWR _7043_/B sky130_fd_sc_hd__buf_4
XFILLER_5_349 VGND VGND VPWR VPWR sky130_fd_sc_hd__decap_3
Xrebuffer498 _6556_/Y VGND VGND VPWR VPWR _6557_/B sky130_fd_sc_hd__buf_4
XTAP_TAPCELL_ROW_114_1818 VGND VPWR sky130_fd_sc_hd__tapvpwrvgnd_1
XFILLER_101_3 VGND VGND VPWR VPWR sky130_fd_sc_hd__decap_3
XFILLER_123_715 VGND VGND VPWR VPWR sky130_fd_sc_hd__decap_3
XFILLER_1_500 VGND VGND VPWR VPWR sky130_fd_sc_hd__decap_3
XFILLER_122_203 VGND VGND VPWR VPWR sky130_fd_sc_hd__decap_3
XFILLER_123_759 VGND VGND VPWR VPWR sky130_fd_sc_hd__decap_3
Xhold880 _9122_/Q VGND VGND VPWR VPWR hold880/X sky130_fd_sc_hd__dlygate4sd3_1
XFILLER_3_18 VGND VGND VPWR VPWR sky130_fd_sc_hd__decap_3
Xhold891 _4698_/X VGND VGND VPWR VPWR _4699_/A sky130_fd_sc_hd__dlygate4sd3_1
XFILLER_1_544 VGND VGND VPWR VPWR sky130_fd_sc_hd__fill_1
XTAP_TAPCELL_ROW_73_1261 VGND VPWR sky130_fd_sc_hd__tapvpwrvgnd_1
XFILLER_89_651 VGND VGND VPWR VPWR sky130_fd_sc_hd__decap_3
XTAP_TAPCELL_ROW_73_1272 VGND VPWR sky130_fd_sc_hd__tapvpwrvgnd_1
XFILLER_89_673 VGND VGND VPWR VPWR sky130_fd_sc_hd__decap_3
XFILLER_103_461 VGND VGND VPWR VPWR sky130_fd_sc_hd__decap_3
XFILLER_49_526 VGND VGND VPWR VPWR sky130_fd_sc_hd__decap_3
XFILLER_1_588 VGND VGND VPWR VPWR sky130_fd_sc_hd__decap_3
XFILLER_64_507 VGND VGND VPWR VPWR sky130_fd_sc_hd__decap_3
XFILLER_76_378 VGND VGND VPWR VPWR sky130_fd_sc_hd__decap_3
XFILLER_91_326 VGND VGND VPWR VPWR sky130_fd_sc_hd__fill_1
XFILLER_123_60 VGND VGND VPWR VPWR sky130_fd_sc_hd__decap_3
XFILLER_45_732 VGND VGND VPWR VPWR sky130_fd_sc_hd__fill_1
XFILLER_123_93 VGND VGND VPWR VPWR sky130_fd_sc_hd__decap_3
XFILLER_83_53 VGND VGND VPWR VPWR sky130_fd_sc_hd__decap_3
XTAP_TAPCELL_ROW_125_1969 VGND VPWR sky130_fd_sc_hd__tapvpwrvgnd_1
XPHY_EDGE_ROW_103_Left_234 VGND VGND VPWR VPWR sky130_fd_sc_hd__decap_3
XFILLER_44_253 VGND VGND VPWR VPWR sky130_fd_sc_hd__decap_3
XFILLER_60_713 VGND VGND VPWR VPWR sky130_fd_sc_hd__fill_2
XFILLER_83_97 VGND VGND VPWR VPWR sky130_fd_sc_hd__decap_3
XFILLER_72_595 VGND VGND VPWR VPWR sky130_fd_sc_hd__fill_2
XFILLER_44_286 VGND VGND VPWR VPWR sky130_fd_sc_hd__fill_2
XFILLER_60_757 VGND VGND VPWR VPWR sky130_fd_sc_hd__decap_3
XFILLER_32_448 VGND VGND VPWR VPWR sky130_fd_sc_hd__fill_1
XFILLER_16_80 VGND VGND VPWR VPWR sky130_fd_sc_hd__decap_3
XFILLER_12_150 VGND VGND VPWR VPWR sky130_fd_sc_hd__decap_3
XFILLER_12_194 VGND VGND VPWR VPWR sky130_fd_sc_hd__fill_2
XFILLER_8_165 VGND VGND VPWR VPWR sky130_fd_sc_hd__decap_3
XFILLER_66_6 VGND VGND VPWR VPWR sky130_fd_sc_hd__fill_1
XFILLER_126_542 VGND VGND VPWR VPWR sky130_fd_sc_hd__decap_3
XPHY_EDGE_ROW_112_Left_243 VGND VGND VPWR VPWR sky130_fd_sc_hd__decap_3
XFILLER_114_704 VGND VGND VPWR VPWR sky130_fd_sc_hd__decap_3
XFILLER_126_564 VGND VGND VPWR VPWR sky130_fd_sc_hd__decap_3
XFILLER_126_597 VGND VGND VPWR VPWR sky130_fd_sc_hd__decap_3
XFILLER_4_371 VGND VGND VPWR VPWR sky130_fd_sc_hd__decap_3
XFILLER_113_258 VGND VGND VPWR VPWR sky130_fd_sc_hd__decap_3
XFILLER_86_109 VGND VGND VPWR VPWR sky130_fd_sc_hd__decap_3
XFILLER_95_632 VGND VGND VPWR VPWR sky130_fd_sc_hd__decap_3
XTAP_TAPCELL_ROW_2_308 VGND VPWR sky130_fd_sc_hd__tapvpwrvgnd_1
XFILLER_95_676 VGND VGND VPWR VPWR sky130_fd_sc_hd__decap_3
XFILLER_27_209 VGND VGND VPWR VPWR sky130_fd_sc_hd__fill_2
X_7940_ _8405_/A _7960_/C VGND VGND VPWR VPWR _7942_/A sky130_fd_sc_hd__nand2_2
XFILLER_48_581 VGND VGND VPWR VPWR sky130_fd_sc_hd__decap_3
XFILLER_36_721 VGND VGND VPWR VPWR sky130_fd_sc_hd__decap_3
XPHY_EDGE_ROW_121_Left_252 VGND VGND VPWR VPWR sky130_fd_sc_hd__decap_3
XFILLER_94_197 VGND VGND VPWR VPWR sky130_fd_sc_hd__decap_3
XFILLER_82_337 VGND VGND VPWR VPWR sky130_fd_sc_hd__decap_3
XFILLER_48_592 VGND VGND VPWR VPWR sky130_fd_sc_hd__decap_3
X_7871_ _7871_/A _7871_/B VGND VGND VPWR VPWR _7871_/Y sky130_fd_sc_hd__nand2_2
XFILLER_35_231 VGND VGND VPWR VPWR sky130_fd_sc_hd__decap_3
X_6822_ _6886_/A _6822_/B VGND VGND VPWR VPWR _6823_/B sky130_fd_sc_hd__xnor2_2
XFILLER_23_415 VGND VGND VPWR VPWR sky130_fd_sc_hd__fill_1
X_6753_ _9065_/Q _6753_/B _6757_/C VGND VGND VPWR VPWR _6753_/X sky130_fd_sc_hd__and3_2
XFILLER_50_245 VGND VGND VPWR VPWR sky130_fd_sc_hd__decap_3
XFILLER_50_256 VGND VGND VPWR VPWR sky130_fd_sc_hd__decap_3
X_5704_ _5863_/A _5864_/S VGND VGND VPWR VPWR _5726_/A sky130_fd_sc_hd__xor2_2
XFILLER_31_470 VGND VGND VPWR VPWR sky130_fd_sc_hd__decap_3
X_6684_ _6684_/A _6684_/B VGND VGND VPWR VPWR _6690_/A sky130_fd_sc_hd__xnor2_2
X_8423_ _8344_/A _8361_/Y _8389_/Y VGND VGND VPWR VPWR _8423_/X sky130_fd_sc_hd__o21a_2
X_5635_ _5635_/A _5635_/B VGND VGND VPWR VPWR _5766_/B sky130_fd_sc_hd__xnor2_2
XFILLER_12_27 VGND VGND VPWR VPWR sky130_fd_sc_hd__fill_1
XFILLER_12_38 VGND VGND VPWR VPWR sky130_fd_sc_hd__decap_3
XPHY_EDGE_ROW_130_Left_261 VGND VGND VPWR VPWR sky130_fd_sc_hd__decap_3
XFILLER_128_27 VGND VGND VPWR VPWR sky130_fd_sc_hd__fill_1
XFILLER_117_520 VGND VGND VPWR VPWR sky130_fd_sc_hd__fill_1
X_8354_ _8397_/B _8354_/B VGND VGND VPWR VPWR _8383_/A sky130_fd_sc_hd__xnor2_2
XFILLER_129_391 VGND VGND VPWR VPWR sky130_fd_sc_hd__fill_1
XFILLER_128_38 VGND VGND VPWR VPWR sky130_fd_sc_hd__decap_3
X_5566_ _5566_/A VGND VGND VPWR VPWR _7071_/A sky130_fd_sc_hd__buf_4
X_7305_ _7301_/X _7302_/X _7304_/Y _7303_/Y VGND VGND VPWR VPWR _7307_/B sky130_fd_sc_hd__a211o_4
XFILLER_117_564 VGND VGND VPWR VPWR sky130_fd_sc_hd__decap_3
X_4517_ _5463_/C _6342_/B VGND VGND VPWR VPWR _6603_/B sky130_fd_sc_hd__nor2_4
X_5497_ _5497_/A _5497_/B VGND VGND VPWR VPWR _5497_/Y sky130_fd_sc_hd__xnor2_2
X_8285_ _8283_/X _8284_/Y _8277_/A VGND VGND VPWR VPWR _8285_/X sky130_fd_sc_hd__o21a_2
XFILLER_105_737 VGND VGND VPWR VPWR sky130_fd_sc_hd__decap_3
XFILLER_104_236 VGND VGND VPWR VPWR sky130_fd_sc_hd__decap_3
X_7236_ _7682_/A _7176_/B _7176_/A VGND VGND VPWR VPWR _7236_/X sky130_fd_sc_hd__o21a_2
XFILLER_120_707 VGND VGND VPWR VPWR sky130_fd_sc_hd__decap_3
X_7167_ _6892_/A _6892_/B _7166_/X VGND VGND VPWR VPWR _7263_/B sky130_fd_sc_hd__o21a_2
XTAP_TAPCELL_ROW_129_2025 VGND VPWR sky130_fd_sc_hd__tapvpwrvgnd_1
X_6118_ _7174_/B _7229_/A VGND VGND VPWR VPWR _7530_/B sky130_fd_sc_hd__xnor2_2
XFILLER_86_643 VGND VGND VPWR VPWR sky130_fd_sc_hd__fill_1
X_7098_ _7098_/A _7099_/A _7098_/C _7311_/A VGND VGND VPWR VPWR _7098_/X sky130_fd_sc_hd__or4_2
XFILLER_86_654 VGND VGND VPWR VPWR sky130_fd_sc_hd__decap_3
XFILLER_58_356 VGND VGND VPWR VPWR sky130_fd_sc_hd__decap_3
XFILLER_86_687 VGND VGND VPWR VPWR sky130_fd_sc_hd__decap_3
XFILLER_46_518 VGND VGND VPWR VPWR sky130_fd_sc_hd__decap_3
XFILLER_18_209 VGND VGND VPWR VPWR sky130_fd_sc_hd__decap_3
XFILLER_100_475 VGND VGND VPWR VPWR sky130_fd_sc_hd__fill_1
XFILLER_46_529 VGND VGND VPWR VPWR sky130_fd_sc_hd__decap_3
X_6049_ _6049_/A _6049_/B VGND VGND VPWR VPWR _6050_/B sky130_fd_sc_hd__nand2_2
XFILLER_85_175 VGND VGND VPWR VPWR sky130_fd_sc_hd__fill_2
XFILLER_58_389 VGND VGND VPWR VPWR sky130_fd_sc_hd__fill_1
XFILLER_100_486 VGND VGND VPWR VPWR sky130_fd_sc_hd__decap_3
XFILLER_37_57 VGND VGND VPWR VPWR sky130_fd_sc_hd__fill_2
XFILLER_27_721 VGND VGND VPWR VPWR sky130_fd_sc_hd__decap_3
XFILLER_73_337 VGND VGND VPWR VPWR sky130_fd_sc_hd__decap_3
XFILLER_37_68 VGND VGND VPWR VPWR sky130_fd_sc_hd__decap_3
XFILLER_39_592 VGND VGND VPWR VPWR sky130_fd_sc_hd__fill_2
XFILLER_27_743 VGND VGND VPWR VPWR sky130_fd_sc_hd__decap_3
XFILLER_27_776 VGND VGND VPWR VPWR sky130_fd_sc_hd__fill_1
XFILLER_54_562 VGND VGND VPWR VPWR sky130_fd_sc_hd__decap_3
XFILLER_26_253 VGND VGND VPWR VPWR sky130_fd_sc_hd__decap_3
XFILLER_54_573 VGND VGND VPWR VPWR sky130_fd_sc_hd__decap_3
XFILLER_14_415 VGND VGND VPWR VPWR sky130_fd_sc_hd__decap_3
XTAP_TAPCELL_ROW_37_782 VGND VPWR sky130_fd_sc_hd__tapvpwrvgnd_1
XFILLER_53_45 VGND VGND VPWR VPWR sky130_fd_sc_hd__decap_3
XFILLER_41_223 VGND VGND VPWR VPWR sky130_fd_sc_hd__fill_1
XFILLER_42_757 VGND VGND VPWR VPWR sky130_fd_sc_hd__decap_3
XFILLER_14_459 VGND VGND VPWR VPWR sky130_fd_sc_hd__fill_2
XFILLER_41_256 VGND VGND VPWR VPWR sky130_fd_sc_hd__decap_3
XFILLER_53_78 VGND VGND VPWR VPWR sky130_fd_sc_hd__decap_3
XTAP_TAPCELL_ROW_120_1899 VGND VPWR sky130_fd_sc_hd__tapvpwrvgnd_1
XFILLER_127_328 VGND VGND VPWR VPWR sky130_fd_sc_hd__fill_1
XFILLER_5_113 VGND VGND VPWR VPWR sky130_fd_sc_hd__decap_3
XFILLER_10_698 VGND VGND VPWR VPWR sky130_fd_sc_hd__fill_2
XFILLER_108_542 VGND VGND VPWR VPWR sky130_fd_sc_hd__fill_1
XFILLER_6_669 VGND VGND VPWR VPWR sky130_fd_sc_hd__decap_3
XFILLER_5_146 VGND VGND VPWR VPWR sky130_fd_sc_hd__decap_3
XFILLER_123_523 VGND VGND VPWR VPWR sky130_fd_sc_hd__decap_3
XFILLER_118_71 VGND VGND VPWR VPWR sky130_fd_sc_hd__decap_3
XFILLER_96_418 VGND VGND VPWR VPWR sky130_fd_sc_hd__fill_2
XFILLER_123_578 VGND VGND VPWR VPWR sky130_fd_sc_hd__decap_3
XFILLER_111_718 VGND VGND VPWR VPWR sky130_fd_sc_hd__decap_3
XFILLER_111_729 VGND VGND VPWR VPWR sky130_fd_sc_hd__decap_3
XFILLER_110_217 VGND VGND VPWR VPWR sky130_fd_sc_hd__decap_3
XFILLER_89_492 VGND VGND VPWR VPWR sky130_fd_sc_hd__decap_3
XFILLER_49_334 VGND VGND VPWR VPWR sky130_fd_sc_hd__fill_2
XFILLER_1_396 VGND VGND VPWR VPWR sky130_fd_sc_hd__decap_3
XFILLER_49_345 VGND VGND VPWR VPWR sky130_fd_sc_hd__decap_3
XFILLER_92_613 VGND VGND VPWR VPWR sky130_fd_sc_hd__decap_3
XFILLER_49_389 VGND VGND VPWR VPWR sky130_fd_sc_hd__decap_3
XFILLER_37_529 VGND VGND VPWR VPWR sky130_fd_sc_hd__decap_3
XFILLER_18_710 VGND VGND VPWR VPWR sky130_fd_sc_hd__decap_3
XFILLER_76_186 VGND VGND VPWR VPWR sky130_fd_sc_hd__fill_1
XFILLER_94_74 VGND VGND VPWR VPWR sky130_fd_sc_hd__decap_3
XFILLER_94_85 VGND VGND VPWR VPWR sky130_fd_sc_hd__decap_3
XFILLER_92_657 VGND VGND VPWR VPWR sky130_fd_sc_hd__decap_3
XFILLER_91_134 VGND VGND VPWR VPWR sky130_fd_sc_hd__decap_3
XFILLER_18_743 VGND VGND VPWR VPWR sky130_fd_sc_hd__decap_3
XTAP_TAPCELL_ROW_86_1441 VGND VPWR sky130_fd_sc_hd__tapvpwrvgnd_1
XFILLER_45_540 VGND VGND VPWR VPWR sky130_fd_sc_hd__decap_3
XFILLER_33_713 VGND VGND VPWR VPWR sky130_fd_sc_hd__decap_3
XFILLER_17_264 VGND VGND VPWR VPWR sky130_fd_sc_hd__decap_3
XFILLER_33_735 VGND VGND VPWR VPWR sky130_fd_sc_hd__fill_1
XFILLER_32_223 VGND VGND VPWR VPWR sky130_fd_sc_hd__decap_3
XTAP_TAPCELL_ROW_15_487 VGND VPWR sky130_fd_sc_hd__tapvpwrvgnd_1
XFILLER_9_452 VGND VGND VPWR VPWR sky130_fd_sc_hd__decap_3
XFILLER_9_463 VGND VGND VPWR VPWR sky130_fd_sc_hd__decap_3
XFILLER_9_485 VGND VGND VPWR VPWR sky130_fd_sc_hd__decap_3
X_5420_ _5420_/A VGND VGND VPWR VPWR _9202_/D sky130_fd_sc_hd__buf_1
XFILLER_64_3 VGND VGND VPWR VPWR sky130_fd_sc_hd__decap_3
X_5351_ _6206_/A _5349_/X _5350_/Y _8780_/C VGND VGND VPWR VPWR _5351_/X sky130_fd_sc_hd__o211a_2
XTAP_TAPCELL_ROW_97_1592 VGND VPWR sky130_fd_sc_hd__tapvpwrvgnd_1
XFILLER_126_361 VGND VGND VPWR VPWR sky130_fd_sc_hd__decap_3
XFILLER_99_234 VGND VGND VPWR VPWR sky130_fd_sc_hd__decap_3
XFILLER_5_691 VGND VGND VPWR VPWR sky130_fd_sc_hd__decap_3
XFILLER_126_394 VGND VGND VPWR VPWR sky130_fd_sc_hd__decap_3
X_5282_ _5412_/B VGND VGND VPWR VPWR _5307_/A sky130_fd_sc_hd__inv_2
X_8070_ _8070_/A wire88/X _8070_/C VGND VGND VPWR VPWR _8070_/X sky130_fd_sc_hd__and3_2
XFILLER_114_556 VGND VGND VPWR VPWR sky130_fd_sc_hd__decap_3
XFILLER_99_267 VGND VGND VPWR VPWR sky130_fd_sc_hd__fill_1
XFILLER_4_50 VGND VGND VPWR VPWR sky130_fd_sc_hd__decap_3
X_7021_ _7021_/A _7021_/B VGND VGND VPWR VPWR _7022_/B sky130_fd_sc_hd__xor2_2
XFILLER_4_72 VGND VGND VPWR VPWR sky130_fd_sc_hd__fill_2
XFILLER_4_83 VGND VGND VPWR VPWR sky130_fd_sc_hd__fill_1
XFILLER_114_18 VGND VGND VPWR VPWR sky130_fd_sc_hd__decap_3
XFILLER_114_29 VGND VGND VPWR VPWR sky130_fd_sc_hd__decap_3
XFILLER_67_142 VGND VGND VPWR VPWR sky130_fd_sc_hd__decap_3
XFILLER_83_602 VGND VGND VPWR VPWR sky130_fd_sc_hd__decap_3
XFILLER_68_676 VGND VGND VPWR VPWR sky130_fd_sc_hd__decap_3
XFILLER_68_687 VGND VGND VPWR VPWR sky130_fd_sc_hd__decap_3
X_8972_ _9005_/A1 _8972_/A1 _8988_/S VGND VGND VPWR VPWR _8973_/A sky130_fd_sc_hd__mux2_2
XFILLER_55_337 VGND VGND VPWR VPWR sky130_fd_sc_hd__decap_3
X_7923_ _7809_/A _7809_/B _7922_/X VGND VGND VPWR VPWR _8104_/C sky130_fd_sc_hd__a21o_2
XFILLER_82_134 VGND VGND VPWR VPWR sky130_fd_sc_hd__decap_3
X_7854_ _7994_/A1 _7856_/B _7742_/Y VGND VGND VPWR VPWR _7854_/X sky130_fd_sc_hd__a21o_4
XFILLER_36_584 VGND VGND VPWR VPWR sky130_fd_sc_hd__decap_3
XFILLER_24_735 VGND VGND VPWR VPWR sky130_fd_sc_hd__decap_3
XFILLER_24_757 VGND VGND VPWR VPWR sky130_fd_sc_hd__decap_3
X_6805_ _6805_/A _6805_/B VGND VGND VPWR VPWR _6805_/X sky130_fd_sc_hd__or2_2
XFILLER_23_234 VGND VGND VPWR VPWR sky130_fd_sc_hd__decap_3
XTAP_TAPCELL_ROW_34_741 VGND VPWR sky130_fd_sc_hd__tapvpwrvgnd_1
X_7785_ _7599_/A _7783_/X _7784_/X VGND VGND VPWR VPWR _7789_/A sky130_fd_sc_hd__a21o_2
X_4997_ _9163_/Q _5709_/A _4515_/B _4995_/X _4996_/X VGND VGND VPWR VPWR _4997_/X
+ sky130_fd_sc_hd__a32o_2
XFILLER_51_587 VGND VGND VPWR VPWR sky130_fd_sc_hd__decap_3
XFILLER_23_15 VGND VGND VPWR VPWR sky130_fd_sc_hd__decap_3
XFILLER_11_429 VGND VGND VPWR VPWR sky130_fd_sc_hd__decap_3
X_6736_ _8421_/A _6736_/B _6736_/C VGND VGND VPWR VPWR _6924_/C sky130_fd_sc_hd__nand3_4
Xwire309 _5968_/S VGND VGND VPWR VPWR _5530_/S sky130_fd_sc_hd__clkbuf_4
X_6667_ _6669_/A _6566_/B _6564_/X VGND VGND VPWR VPWR _6907_/A sky130_fd_sc_hd__a21oi_2
X_8406_ _8406_/A _8406_/B _8406_/C VGND VGND VPWR VPWR _8408_/C sky130_fd_sc_hd__and3_2
X_5618_ _9294_/Q _9026_/Q _5989_/S VGND VGND VPWR VPWR _5618_/X sky130_fd_sc_hd__mux2_1
X_6598_ _6666_/A _6598_/B VGND VGND VPWR VPWR _6599_/B sky130_fd_sc_hd__xnor2_2
XFILLER_124_309 VGND VGND VPWR VPWR sky130_fd_sc_hd__decap_3
XFILLER_105_501 VGND VGND VPWR VPWR sky130_fd_sc_hd__decap_3
X_8337_ _8397_/A _8337_/B VGND VGND VPWR VPWR _8337_/Y sky130_fd_sc_hd__nand2_2
XFILLER_3_617 VGND VGND VPWR VPWR sky130_fd_sc_hd__decap_3
XFILLER_117_361 VGND VGND VPWR VPWR sky130_fd_sc_hd__decap_3
X_5549_ _6807_/A _5550_/B VGND VGND VPWR VPWR _5549_/Y sky130_fd_sc_hd__nand2_2
XFILLER_105_523 VGND VGND VPWR VPWR sky130_fd_sc_hd__decap_3
XTAP_TAPCELL_ROW_57_1053 VGND VPWR sky130_fd_sc_hd__tapvpwrvgnd_1
XFILLER_2_127 VGND VGND VPWR VPWR sky130_fd_sc_hd__decap_3
X_8268_ _9220_/Q _8257_/Y _8268_/S VGND VGND VPWR VPWR _8268_/X sky130_fd_sc_hd__mux2_2
X_7219_ _7147_/Y _7218_/X _7219_/S VGND VGND VPWR VPWR _7220_/A sky130_fd_sc_hd__mux2_2
XFILLER_78_429 VGND VGND VPWR VPWR sky130_fd_sc_hd__decap_3
XTAP_TAPCELL_ROW_70_1220 VGND VPWR sky130_fd_sc_hd__tapvpwrvgnd_1
XFILLER_120_526 VGND VGND VPWR VPWR sky130_fd_sc_hd__decap_3
X_8199_ _8364_/B _8196_/C _9219_/Q VGND VGND VPWR VPWR _8200_/B sky130_fd_sc_hd__mux2_2
XTAP_TAPCELL_ROW_70_1231 VGND VPWR sky130_fd_sc_hd__tapvpwrvgnd_1
XFILLER_59_632 VGND VGND VPWR VPWR sky130_fd_sc_hd__decap_3
XFILLER_48_56 VGND VGND VPWR VPWR sky130_fd_sc_hd__decap_3
XFILLER_86_451 VGND VGND VPWR VPWR sky130_fd_sc_hd__fill_1
XFILLER_59_676 VGND VGND VPWR VPWR sky130_fd_sc_hd__decap_3
XFILLER_74_613 VGND VGND VPWR VPWR sky130_fd_sc_hd__decap_3
XFILLER_58_197 VGND VGND VPWR VPWR sky130_fd_sc_hd__decap_3
XFILLER_100_294 VGND VGND VPWR VPWR sky130_fd_sc_hd__fill_1
XFILLER_42_510 VGND VGND VPWR VPWR sky130_fd_sc_hd__decap_3
XFILLER_15_724 VGND VGND VPWR VPWR sky130_fd_sc_hd__decap_3
XFILLER_14_201 VGND VGND VPWR VPWR sky130_fd_sc_hd__fill_1
XTAP_TAPCELL_ROW_122_1928 VGND VPWR sky130_fd_sc_hd__tapvpwrvgnd_1
XFILLER_15_735 VGND VGND VPWR VPWR sky130_fd_sc_hd__decap_3
XTAP_TAPCELL_ROW_68_1193 VGND VPWR sky130_fd_sc_hd__tapvpwrvgnd_1
XFILLER_15_768 VGND VGND VPWR VPWR sky130_fd_sc_hd__decap_3
XFILLER_120_50 VGND VGND VPWR VPWR sky130_fd_sc_hd__decap_3
XFILLER_9_39 VGND VGND VPWR VPWR sky130_fd_sc_hd__decap_3
XFILLER_42_587 VGND VGND VPWR VPWR sky130_fd_sc_hd__fill_1
XFILLER_14_278 VGND VGND VPWR VPWR sky130_fd_sc_hd__decap_3
XFILLER_80_32 VGND VGND VPWR VPWR sky130_fd_sc_hd__fill_1
XFILLER_42_598 VGND VGND VPWR VPWR sky130_fd_sc_hd__decap_3
XFILLER_120_83 VGND VGND VPWR VPWR sky130_fd_sc_hd__fill_1
XTAP_TAPCELL_ROW_81_1371 VGND VPWR sky130_fd_sc_hd__tapvpwrvgnd_1
XFILLER_120_94 VGND VGND VPWR VPWR sky130_fd_sc_hd__decap_3
XFILLER_128_604 VGND VGND VPWR VPWR sky130_fd_sc_hd__decap_3
XTAP_TAPCELL_ROW_12_446 VGND VPWR sky130_fd_sc_hd__tapvpwrvgnd_1
XFILLER_80_76 VGND VGND VPWR VPWR sky130_fd_sc_hd__decap_3
XFILLER_128_637 VGND VGND VPWR VPWR sky130_fd_sc_hd__decap_3
XFILLER_6_411 VGND VGND VPWR VPWR sky130_fd_sc_hd__decap_3
XFILLER_128_648 VGND VGND VPWR VPWR sky130_fd_sc_hd__decap_3
XFILLER_127_125 VGND VGND VPWR VPWR sky130_fd_sc_hd__decap_3
XFILLER_10_495 VGND VGND VPWR VPWR sky130_fd_sc_hd__decap_3
XFILLER_127_158 VGND VGND VPWR VPWR sky130_fd_sc_hd__decap_3
XFILLER_129_81 VGND VGND VPWR VPWR sky130_fd_sc_hd__decap_3
XFILLER_127_169 VGND VGND VPWR VPWR sky130_fd_sc_hd__decap_3
XFILLER_6_477 VGND VGND VPWR VPWR sky130_fd_sc_hd__decap_3
XFILLER_50_9 VGND VGND VPWR VPWR sky130_fd_sc_hd__decap_3
XFILLER_89_63 VGND VGND VPWR VPWR sky130_fd_sc_hd__fill_1
XFILLER_108_394 VGND VGND VPWR VPWR sky130_fd_sc_hd__decap_3
XFILLER_89_85 VGND VGND VPWR VPWR sky130_fd_sc_hd__decap_3
XFILLER_123_364 VGND VGND VPWR VPWR sky130_fd_sc_hd__decap_3
XFILLER_2_672 VGND VGND VPWR VPWR sky130_fd_sc_hd__decap_3
XFILLER_97_749 VGND VGND VPWR VPWR sky130_fd_sc_hd__decap_3
XFILLER_96_259 VGND VGND VPWR VPWR sky130_fd_sc_hd__decap_3
XFILLER_29_6 VGND VGND VPWR VPWR sky130_fd_sc_hd__decap_3
XFILLER_77_473 VGND VGND VPWR VPWR sky130_fd_sc_hd__decap_3
XFILLER_65_613 VGND VGND VPWR VPWR sky130_fd_sc_hd__decap_3
XFILLER_49_164 VGND VGND VPWR VPWR sky130_fd_sc_hd__decap_3
XFILLER_65_635 VGND VGND VPWR VPWR sky130_fd_sc_hd__decap_3
XFILLER_37_337 VGND VGND VPWR VPWR sky130_fd_sc_hd__fill_1
XFILLER_65_668 VGND VGND VPWR VPWR sky130_fd_sc_hd__decap_3
XFILLER_80_627 VGND VGND VPWR VPWR sky130_fd_sc_hd__fill_1
X_4920_ _5633_/A VGND VGND VPWR VPWR _5048_/B sky130_fd_sc_hd__clkbuf_2
XFILLER_45_381 VGND VGND VPWR VPWR sky130_fd_sc_hd__decap_3
XFILLER_18_595 VGND VGND VPWR VPWR sky130_fd_sc_hd__decap_3
XFILLER_33_532 VGND VGND VPWR VPWR sky130_fd_sc_hd__fill_1
X_4851_ hold894/X _9154_/Q _4861_/S VGND VGND VPWR VPWR _4851_/X sky130_fd_sc_hd__mux2_2
XFILLER_21_705 VGND VGND VPWR VPWR sky130_fd_sc_hd__decap_3
XFILLER_33_576 VGND VGND VPWR VPWR sky130_fd_sc_hd__decap_3
XTAP_TAPCELL_ROW_31_700 VGND VPWR sky130_fd_sc_hd__tapvpwrvgnd_1
XFILLER_21_738 VGND VGND VPWR VPWR sky130_fd_sc_hd__decap_3
X_7570_ _7805_/A _7449_/A _7569_/X _8066_/B VGND VGND VPWR VPWR _7570_/X sky130_fd_sc_hd__a22o_2
X_4782_ _9137_/Q _4782_/A1 _4798_/S VGND VGND VPWR VPWR _4782_/X sky130_fd_sc_hd__mux2_2
XTAP_TAPCELL_ROW_99_1621 VGND VPWR sky130_fd_sc_hd__tapvpwrvgnd_1
X_6521_ _6516_/Y _6518_/Y _6520_/Y _6386_/B VGND VGND VPWR VPWR _6524_/A sky130_fd_sc_hd__o211a_4
XFILLER_20_259 VGND VGND VPWR VPWR sky130_fd_sc_hd__decap_3
XFILLER_118_103 VGND VGND VPWR VPWR sky130_fd_sc_hd__decap_3
X_9240_ clkload7/A _9240_/D load_slew374/X VGND VGND VPWR VPWR _9240_/Q sky130_fd_sc_hd__dfrtp_2
XFILLER_109_18 VGND VGND VPWR VPWR sky130_fd_sc_hd__decap_3
X_6452_ _6446_/B _6450_/B _6449_/X _6451_/X VGND VGND VPWR VPWR _6452_/X sky130_fd_sc_hd__a31o_2
XFILLER_118_136 VGND VGND VPWR VPWR sky130_fd_sc_hd__decap_3
Xclkload30 _9223_/CLK VGND VGND VPWR VPWR clkload30/Y sky130_fd_sc_hd__clkinv_2
XFILLER_106_309 VGND VGND VPWR VPWR sky130_fd_sc_hd__fill_2
X_5403_ _5495_/B _5403_/B VGND VGND VPWR VPWR _5416_/A sky130_fd_sc_hd__xnor2_2
X_9171_ _9171_/CLK _9171_/D fanout402/X VGND VGND VPWR VPWR _9171_/Q sky130_fd_sc_hd__dfrtp_2
X_6383_ _6383_/A _6383_/B VGND VGND VPWR VPWR _6385_/A sky130_fd_sc_hd__xnor2_4
X_8122_ _8119_/Y _7899_/Y _7566_/Y _8120_/X _8121_/Y VGND VGND VPWR VPWR _8122_/X
+ sky130_fd_sc_hd__a32o_2
XFILLER_126_180 VGND VGND VPWR VPWR sky130_fd_sc_hd__decap_3
X_5334_ _5334_/A _5334_/B VGND VGND VPWR VPWR _5525_/B sky130_fd_sc_hd__xnor2_2
XFILLER_114_342 VGND VGND VPWR VPWR sky130_fd_sc_hd__decap_3
X_8053_ _7931_/B _8046_/X _8052_/X VGND VGND VPWR VPWR _8075_/A sky130_fd_sc_hd__a21oi_2
XFILLER_88_738 VGND VGND VPWR VPWR sky130_fd_sc_hd__decap_3
XFILLER_87_215 VGND VGND VPWR VPWR sky130_fd_sc_hd__fill_1
X_5265_ _9039_/Q _6336_/B _6607_/B VGND VGND VPWR VPWR _5265_/X sky130_fd_sc_hd__and3_2
XFILLER_125_39 VGND VGND VPWR VPWR sky130_fd_sc_hd__decap_3
XFILLER_114_386 VGND VGND VPWR VPWR sky130_fd_sc_hd__decap_3
X_7004_ _6730_/A _7002_/Y _6730_/C _6727_/A _6727_/B VGND VGND VPWR VPWR _7004_/X
+ sky130_fd_sc_hd__a311o_2
X_5196_ _6206_/A _5196_/B VGND VGND VPWR VPWR _5283_/B sky130_fd_sc_hd__nor2_2
XFILLER_96_760 VGND VGND VPWR VPWR sky130_fd_sc_hd__decap_3
XFILLER_18_15 VGND VGND VPWR VPWR sky130_fd_sc_hd__decap_3
XTAP_TAPCELL_ROW_39_811 VGND VPWR sky130_fd_sc_hd__tapvpwrvgnd_1
XFILLER_28_315 VGND VGND VPWR VPWR sky130_fd_sc_hd__fill_1
XFILLER_83_410 VGND VGND VPWR VPWR sky130_fd_sc_hd__decap_3
XFILLER_68_495 VGND VGND VPWR VPWR sky130_fd_sc_hd__decap_3
XFILLER_18_48 VGND VGND VPWR VPWR sky130_fd_sc_hd__fill_1
XFILLER_110_592 VGND VGND VPWR VPWR sky130_fd_sc_hd__decap_3
XFILLER_28_359 VGND VGND VPWR VPWR sky130_fd_sc_hd__decap_3
X_8955_ _9319_/Q hold833/X _8967_/S VGND VGND VPWR VPWR _8955_/X sky130_fd_sc_hd__mux2_2
XFILLER_83_476 VGND VGND VPWR VPWR sky130_fd_sc_hd__decap_3
XFILLER_43_318 VGND VGND VPWR VPWR sky130_fd_sc_hd__decap_3
X_7906_ _8344_/A VGND VGND VPWR VPWR wire71/A sky130_fd_sc_hd__clkbuf_1
X_8886_ hold922/X _8886_/A1 _8904_/S VGND VGND VPWR VPWR _8887_/A sky130_fd_sc_hd__mux2_2
XFILLER_36_381 VGND VGND VPWR VPWR sky130_fd_sc_hd__fill_2
XFILLER_70_148 VGND VGND VPWR VPWR sky130_fd_sc_hd__fill_2
X_7837_ _9215_/Q _7835_/X _7836_/X VGND VGND VPWR VPWR _7837_/X sky130_fd_sc_hd__o21a_2
XFILLER_70_159 VGND VGND VPWR VPWR sky130_fd_sc_hd__decap_3
XFILLER_51_340 VGND VGND VPWR VPWR sky130_fd_sc_hd__decap_3
XFILLER_12_716 VGND VGND VPWR VPWR sky130_fd_sc_hd__decap_3
X_7768_ _8232_/A _8313_/A VGND VGND VPWR VPWR _7770_/A sky130_fd_sc_hd__nand2_2
XFILLER_12_749 VGND VGND VPWR VPWR sky130_fd_sc_hd__decap_3
X_6719_ _6719_/A _6965_/A VGND VGND VPWR VPWR _6719_/Y sky130_fd_sc_hd__xnor2_4
Xwire117 _6345_/Y VGND VGND VPWR VPWR wire117/X sky130_fd_sc_hd__buf_6
Xclkload2 clkload2/A VGND VGND VPWR VPWR clkload2/Y sky130_fd_sc_hd__inv_12
XFILLER_11_259 VGND VGND VPWR VPWR sky130_fd_sc_hd__fill_1
Xwire128 _5271_/Y VGND VGND VPWR VPWR _5272_/A sky130_fd_sc_hd__buf_6
XFILLER_20_760 VGND VGND VPWR VPWR sky130_fd_sc_hd__decap_3
X_7699_ _7651_/Y _7698_/X _8291_/S VGND VGND VPWR VPWR _7700_/A sky130_fd_sc_hd__mux2_2
XFILLER_50_35 VGND VGND VPWR VPWR sky130_fd_sc_hd__decap_3
XFILLER_109_158 VGND VGND VPWR VPWR sky130_fd_sc_hd__fill_2
XFILLER_124_106 VGND VGND VPWR VPWR sky130_fd_sc_hd__decap_3
XTAP_TAPCELL_ROW_119_1890 VGND VPWR sky130_fd_sc_hd__tapvpwrvgnd_1
XFILLER_3_414 VGND VGND VPWR VPWR sky130_fd_sc_hd__fill_2
XFILLER_124_139 VGND VGND VPWR VPWR sky130_fd_sc_hd__fill_1
XFILLER_59_22 VGND VGND VPWR VPWR sky130_fd_sc_hd__decap_3
XFILLER_120_312 VGND VGND VPWR VPWR sky130_fd_sc_hd__decap_3
XFILLER_78_237 VGND VGND VPWR VPWR sky130_fd_sc_hd__fill_1
XFILLER_78_259 VGND VGND VPWR VPWR sky130_fd_sc_hd__decap_3
Xfanout261 _9234_/Q VGND VGND VPWR VPWR _4930_/B_N sky130_fd_sc_hd__buf_6
XFILLER_75_10 VGND VGND VPWR VPWR sky130_fd_sc_hd__decap_3
XFILLER_115_72 VGND VGND VPWR VPWR sky130_fd_sc_hd__decap_3
XFILLER_101_570 VGND VGND VPWR VPWR sky130_fd_sc_hd__fill_2
XFILLER_59_484 VGND VGND VPWR VPWR sky130_fd_sc_hd__fill_1
XFILLER_46_101 VGND VGND VPWR VPWR sky130_fd_sc_hd__decap_3
XFILLER_74_421 VGND VGND VPWR VPWR sky130_fd_sc_hd__decap_3
XFILLER_74_443 VGND VGND VPWR VPWR sky130_fd_sc_hd__decap_3
XFILLER_47_679 VGND VGND VPWR VPWR sky130_fd_sc_hd__decap_3
XTAP_TAPCELL_ROW_17_505 VGND VPWR sky130_fd_sc_hd__tapvpwrvgnd_1
XTAP_TAPCELL_ROW_83_1400 VGND VPWR sky130_fd_sc_hd__tapvpwrvgnd_1
XTAP_TAPCELL_ROW_17_516 VGND VPWR sky130_fd_sc_hd__tapvpwrvgnd_1
XFILLER_27_370 VGND VGND VPWR VPWR sky130_fd_sc_hd__decap_3
XFILLER_55_690 VGND VGND VPWR VPWR sky130_fd_sc_hd__decap_3
XFILLER_15_543 VGND VGND VPWR VPWR sky130_fd_sc_hd__decap_3
XFILLER_42_351 VGND VGND VPWR VPWR sky130_fd_sc_hd__decap_3
XFILLER_98_9 VGND VGND VPWR VPWR sky130_fd_sc_hd__decap_3
XFILLER_15_587 VGND VGND VPWR VPWR sky130_fd_sc_hd__decap_3
XFILLER_30_579 VGND VGND VPWR VPWR sky130_fd_sc_hd__fill_2
XFILLER_11_771 VGND VGND VPWR VPWR sky130_fd_sc_hd__decap_3
XFILLER_7_753 VGND VGND VPWR VPWR sky130_fd_sc_hd__decap_3
XFILLER_6_230 VGND VGND VPWR VPWR sky130_fd_sc_hd__fill_1
XFILLER_10_292 VGND VGND VPWR VPWR sky130_fd_sc_hd__decap_3
XFILLER_128_489 VGND VGND VPWR VPWR sky130_fd_sc_hd__decap_3
XFILLER_116_629 VGND VGND VPWR VPWR sky130_fd_sc_hd__fill_1
XTAP_TAPCELL_ROW_94_1551 VGND VPWR sky130_fd_sc_hd__tapvpwrvgnd_1
XFILLER_124_640 VGND VGND VPWR VPWR sky130_fd_sc_hd__decap_3
XFILLER_130_109 VGND VGND VPWR VPWR sky130_fd_sc_hd__decap_3
XFILLER_69_204 VGND VGND VPWR VPWR sky130_fd_sc_hd__decap_3
XFILLER_123_161 VGND VGND VPWR VPWR sky130_fd_sc_hd__decap_3
XFILLER_123_172 VGND VGND VPWR VPWR sky130_fd_sc_hd__decap_3
XFILLER_2_480 VGND VGND VPWR VPWR sky130_fd_sc_hd__decap_3
X_5050_ _5050_/A _5143_/B VGND VGND VPWR VPWR _7794_/B sky130_fd_sc_hd__nor2b_2
XFILLER_69_248 VGND VGND VPWR VPWR sky130_fd_sc_hd__decap_3
XFILLER_97_579 VGND VGND VPWR VPWR sky130_fd_sc_hd__decap_3
XFILLER_27_3 VGND VGND VPWR VPWR sky130_fd_sc_hd__decap_3
XFILLER_38_602 VGND VGND VPWR VPWR sky130_fd_sc_hd__decap_3
XFILLER_111_389 VGND VGND VPWR VPWR sky130_fd_sc_hd__decap_3
XFILLER_37_134 VGND VGND VPWR VPWR sky130_fd_sc_hd__decap_3
XFILLER_1_51 VGND VGND VPWR VPWR sky130_fd_sc_hd__decap_3
XFILLER_38_679 VGND VGND VPWR VPWR sky130_fd_sc_hd__decap_3
XFILLER_37_156 VGND VGND VPWR VPWR sky130_fd_sc_hd__decap_3
Xclone596 _5892_/A VGND VGND VPWR VPWR _6249_/A sky130_fd_sc_hd__clkbuf_16
XFILLER_80_402 VGND VGND VPWR VPWR sky130_fd_sc_hd__decap_3
XFILLER_52_104 VGND VGND VPWR VPWR sky130_fd_sc_hd__decap_3
X_8740_ _8732_/B _8739_/Y _8731_/Y VGND VGND VPWR VPWR _8741_/B sky130_fd_sc_hd__o21ai_2
XFILLER_65_498 VGND VGND VPWR VPWR sky130_fd_sc_hd__decap_3
X_5952_ _5952_/A _5952_/B VGND VGND VPWR VPWR _5953_/B sky130_fd_sc_hd__xnor2_2
XFILLER_80_457 VGND VGND VPWR VPWR sky130_fd_sc_hd__decap_3
XFILLER_52_148 VGND VGND VPWR VPWR sky130_fd_sc_hd__decap_3
X_4903_ _9223_/Q _4907_/B VGND VGND VPWR VPWR _4903_/Y sky130_fd_sc_hd__nor2_2
X_8671_ _8671_/A _8716_/B VGND VGND VPWR VPWR _8672_/B sky130_fd_sc_hd__nor2_2
XFILLER_33_340 VGND VGND VPWR VPWR sky130_fd_sc_hd__fill_2
X_5883_ _9092_/Q _6754_/B _5882_/X _5446_/A _5989_/S VGND VGND VPWR VPWR _5885_/B
+ sky130_fd_sc_hd__a221o_2
XFILLER_61_660 VGND VGND VPWR VPWR sky130_fd_sc_hd__fill_2
XFILLER_61_671 VGND VGND VPWR VPWR sky130_fd_sc_hd__fill_1
X_7622_ _7622_/A _7622_/B VGND VGND VPWR VPWR _7623_/B sky130_fd_sc_hd__xnor2_2
XTAP_TAPCELL_ROW_44_880 VGND VPWR sky130_fd_sc_hd__tapvpwrvgnd_1
XFILLER_21_524 VGND VGND VPWR VPWR sky130_fd_sc_hd__decap_3
X_4834_ _9162_/Q hold819/X _4840_/S VGND VGND VPWR VPWR _4834_/X sky130_fd_sc_hd__mux2_2
XFILLER_21_557 VGND VGND VPWR VPWR sky130_fd_sc_hd__decap_3
X_7553_ _7553_/A _7553_/B VGND VGND VPWR VPWR _7554_/B sky130_fd_sc_hd__xnor2_2
X_4765_ _9129_/Q hold979/X _4777_/S VGND VGND VPWR VPWR _4765_/X sky130_fd_sc_hd__mux2_2
X_6504_ input6/X _6504_/A2 _7533_/A _6470_/A _6503_/X VGND VGND VPWR VPWR _6505_/A
+ sky130_fd_sc_hd__a32o_2
XFILLER_119_445 VGND VGND VPWR VPWR sky130_fd_sc_hd__decap_3
X_7484_ _7484_/A _7484_/B VGND VGND VPWR VPWR _7486_/D sky130_fd_sc_hd__xnor2_2
X_4696_ _4729_/A1 _4696_/A1 _4714_/S VGND VGND VPWR VPWR _4697_/A sky130_fd_sc_hd__mux2_2
X_9223_ _9223_/CLK _9223_/D input1/X VGND VGND VPWR VPWR _9223_/Q sky130_fd_sc_hd__dfrtp_2
X_6435_ _5034_/A _6096_/B _6434_/Y _5034_/B _6490_/A VGND VGND VPWR VPWR _6435_/X
+ sky130_fd_sc_hd__a221o_2
XFILLER_20_27 VGND VGND VPWR VPWR sky130_fd_sc_hd__fill_1
X_9154_ _9344_/CLK _9154_/D load_slew380/X VGND VGND VPWR VPWR _9154_/Q sky130_fd_sc_hd__dfrtp_2
XFILLER_115_640 VGND VGND VPWR VPWR sky130_fd_sc_hd__decap_3
X_6366_ _6366_/A _6366_/B VGND VGND VPWR VPWR _6369_/A sky130_fd_sc_hd__xnor2_2
XTAP_TAPCELL_ROW_54_1012 VGND VPWR sky130_fd_sc_hd__tapvpwrvgnd_1
X_8105_ _7916_/B _8103_/X _8104_/X VGND VGND VPWR VPWR _8106_/B sky130_fd_sc_hd__a21oi_2
XFILLER_115_673 VGND VGND VPWR VPWR sky130_fd_sc_hd__decap_3
XFILLER_114_150 VGND VGND VPWR VPWR sky130_fd_sc_hd__decap_3
XFILLER_0_417 VGND VGND VPWR VPWR sky130_fd_sc_hd__decap_3
X_5317_ _5317_/A VGND VGND VPWR VPWR _5535_/B sky130_fd_sc_hd__inv_2
XFILLER_130_610 VGND VGND VPWR VPWR sky130_fd_sc_hd__decap_3
X_9085_ _9171_/CLK _9085_/D load_slew394/X VGND VGND VPWR VPWR _9085_/Q sky130_fd_sc_hd__dfrtp_2
XFILLER_0_439 VGND VGND VPWR VPWR sky130_fd_sc_hd__decap_3
X_6297_ _6301_/S _6297_/B _6297_/C _6297_/D VGND VGND VPWR VPWR _6325_/C sky130_fd_sc_hd__nand4_2
XFILLER_130_632 VGND VGND VPWR VPWR sky130_fd_sc_hd__decap_3
XFILLER_29_25 VGND VGND VPWR VPWR sky130_fd_sc_hd__decap_3
X_8036_ _7702_/A _8032_/X _8034_/Y _8035_/X VGND VGND VPWR VPWR _8037_/B sky130_fd_sc_hd__o211a_2
XFILLER_88_568 VGND VGND VPWR VPWR sky130_fd_sc_hd__fill_1
XFILLER_130_654 VGND VGND VPWR VPWR sky130_fd_sc_hd__decap_3
X_5248_ _5429_/A _5429_/C _5429_/B _5273_/B _9242_/Q VGND VGND VPWR VPWR _6717_/A
+ sky130_fd_sc_hd__o32a_4
XFILLER_130_676 VGND VGND VPWR VPWR sky130_fd_sc_hd__decap_3
XFILLER_29_69 VGND VGND VPWR VPWR sky130_fd_sc_hd__decap_3
X_5179_ _9022_/Q _9150_/Q _5384_/A VGND VGND VPWR VPWR _5179_/X sky130_fd_sc_hd__mux2_2
XFILLER_56_421 VGND VGND VPWR VPWR sky130_fd_sc_hd__decap_3
XFILLER_29_635 VGND VGND VPWR VPWR sky130_fd_sc_hd__decap_3
XFILLER_56_454 VGND VGND VPWR VPWR sky130_fd_sc_hd__fill_1
XTAP_TAPCELL_ROW_106_1709 VGND VPWR sky130_fd_sc_hd__tapvpwrvgnd_1
XFILLER_84_774 VGND VGND VPWR VPWR sky130_fd_sc_hd__decap_3
XFILLER_56_465 VGND VGND VPWR VPWR sky130_fd_sc_hd__decap_3
XFILLER_28_156 VGND VGND VPWR VPWR sky130_fd_sc_hd__decap_3
XFILLER_45_24 VGND VGND VPWR VPWR sky130_fd_sc_hd__decap_3
XFILLER_56_487 VGND VGND VPWR VPWR sky130_fd_sc_hd__decap_3
XFILLER_16_318 VGND VGND VPWR VPWR sky130_fd_sc_hd__decap_3
X_8938_ _8972_/A1 _8938_/A1 _8946_/S VGND VGND VPWR VPWR _8939_/A sky130_fd_sc_hd__mux2_2
XFILLER_45_57 VGND VGND VPWR VPWR sky130_fd_sc_hd__decap_3
XFILLER_43_137 VGND VGND VPWR VPWR sky130_fd_sc_hd__decap_3
XFILLER_45_79 VGND VGND VPWR VPWR sky130_fd_sc_hd__decap_3
X_8869_ _9278_/Q hold930/X _8883_/S VGND VGND VPWR VPWR _8869_/X sky130_fd_sc_hd__mux2_2
XTAP_TAPCELL_ROW_65_1163 VGND VPWR sky130_fd_sc_hd__tapvpwrvgnd_1
XFILLER_52_682 VGND VGND VPWR VPWR sky130_fd_sc_hd__decap_3
XFILLER_101_63 VGND VGND VPWR VPWR sky130_fd_sc_hd__decap_3
XFILLER_61_12 VGND VGND VPWR VPWR sky130_fd_sc_hd__decap_3
XFILLER_12_524 VGND VGND VPWR VPWR sky130_fd_sc_hd__decap_3
XFILLER_51_181 VGND VGND VPWR VPWR sky130_fd_sc_hd__decap_3
XFILLER_61_45 VGND VGND VPWR VPWR sky130_fd_sc_hd__fill_2
XFILLER_12_557 VGND VGND VPWR VPWR sky130_fd_sc_hd__decap_3
XFILLER_8_517 VGND VGND VPWR VPWR sky130_fd_sc_hd__decap_3
XFILLER_8_539 VGND VGND VPWR VPWR sky130_fd_sc_hd__decap_3
XTAP_TAPCELL_ROW_22_574 VGND VPWR sky130_fd_sc_hd__tapvpwrvgnd_1
XTAP_TAPCELL_ROW_22_585 VGND VPWR sky130_fd_sc_hd__tapvpwrvgnd_1
XFILLER_6_18 VGND VGND VPWR VPWR sky130_fd_sc_hd__decap_3
XFILLER_6_29 VGND VGND VPWR VPWR sky130_fd_sc_hd__decap_3
XFILLER_4_701 VGND VGND VPWR VPWR sky130_fd_sc_hd__decap_3
XFILLER_4_734 VGND VGND VPWR VPWR sky130_fd_sc_hd__decap_3
XFILLER_106_662 VGND VGND VPWR VPWR sky130_fd_sc_hd__decap_3
XFILLER_106_684 VGND VGND VPWR VPWR sky130_fd_sc_hd__decap_3
XFILLER_10_71 VGND VGND VPWR VPWR sky130_fd_sc_hd__decap_3
XFILLER_105_172 VGND VGND VPWR VPWR sky130_fd_sc_hd__decap_3
XFILLER_79_535 VGND VGND VPWR VPWR sky130_fd_sc_hd__decap_3
XFILLER_121_632 VGND VGND VPWR VPWR sky130_fd_sc_hd__decap_3
XFILLER_126_71 VGND VGND VPWR VPWR sky130_fd_sc_hd__decap_3
XFILLER_79_579 VGND VGND VPWR VPWR sky130_fd_sc_hd__decap_3
XFILLER_121_676 VGND VGND VPWR VPWR sky130_fd_sc_hd__decap_3
XFILLER_120_153 VGND VGND VPWR VPWR sky130_fd_sc_hd__decap_3
XFILLER_94_527 VGND VGND VPWR VPWR sky130_fd_sc_hd__decap_3
XFILLER_121_698 VGND VGND VPWR VPWR sky130_fd_sc_hd__fill_2
XFILLER_19_101 VGND VGND VPWR VPWR sky130_fd_sc_hd__decap_3
XFILLER_86_97 VGND VGND VPWR VPWR sky130_fd_sc_hd__decap_3
XFILLER_59_281 VGND VGND VPWR VPWR sky130_fd_sc_hd__decap_3
XFILLER_13_9 VGND VGND VPWR VPWR sky130_fd_sc_hd__decap_3
XFILLER_120_186 VGND VGND VPWR VPWR sky130_fd_sc_hd__decap_3
XFILLER_120_197 VGND VGND VPWR VPWR sky130_fd_sc_hd__fill_2
XFILLER_19_80 VGND VGND VPWR VPWR sky130_fd_sc_hd__decap_3
XFILLER_19_145 VGND VGND VPWR VPWR sky130_fd_sc_hd__fill_1
XFILLER_47_465 VGND VGND VPWR VPWR sky130_fd_sc_hd__decap_3
XFILLER_35_605 VGND VGND VPWR VPWR sky130_fd_sc_hd__decap_3
XFILLER_90_733 VGND VGND VPWR VPWR sky130_fd_sc_hd__decap_3
XFILLER_62_424 VGND VGND VPWR VPWR sky130_fd_sc_hd__decap_3
XFILLER_74_295 VGND VGND VPWR VPWR sky130_fd_sc_hd__decap_3
XFILLER_90_755 VGND VGND VPWR VPWR sky130_fd_sc_hd__fill_1
XFILLER_62_457 VGND VGND VPWR VPWR sky130_fd_sc_hd__decap_3
XFILLER_15_340 VGND VGND VPWR VPWR sky130_fd_sc_hd__decap_3
XFILLER_43_671 VGND VGND VPWR VPWR sky130_fd_sc_hd__fill_1
XFILLER_43_682 VGND VGND VPWR VPWR sky130_fd_sc_hd__decap_3
XFILLER_15_384 VGND VGND VPWR VPWR sky130_fd_sc_hd__decap_3
XFILLER_129_721 VGND VGND VPWR VPWR sky130_fd_sc_hd__decap_3
XFILLER_30_365 VGND VGND VPWR VPWR sky130_fd_sc_hd__decap_3
XFILLER_129_732 VGND VGND VPWR VPWR sky130_fd_sc_hd__decap_3
X_4550_ _9027_/Q _9005_/A0 _4566_/S VGND VGND VPWR VPWR _4550_/X sky130_fd_sc_hd__mux2_2
XFILLER_129_765 VGND VGND VPWR VPWR sky130_fd_sc_hd__decap_3
XFILLER_7_550 VGND VGND VPWR VPWR sky130_fd_sc_hd__decap_3
XFILLER_128_253 VGND VGND VPWR VPWR sky130_fd_sc_hd__decap_3
Xmax_cap203 _5804_/A VGND VGND VPWR VPWR _6441_/A1 sky130_fd_sc_hd__buf_2
Xmax_cap214 _5624_/B VGND VGND VPWR VPWR _5457_/A sky130_fd_sc_hd__clkbuf_2
XFILLER_7_583 VGND VGND VPWR VPWR sky130_fd_sc_hd__decap_3
XFILLER_128_297 VGND VGND VPWR VPWR sky130_fd_sc_hd__decap_3
XFILLER_116_437 VGND VGND VPWR VPWR sky130_fd_sc_hd__decap_3
X_6220_ _6220_/A _6220_/B VGND VGND VPWR VPWR _6220_/X sky130_fd_sc_hd__or2_4
X_6151_ _6151_/A _6151_/B VGND VGND VPWR VPWR _6151_/Y sky130_fd_sc_hd__nor2_2
Xload_slew420 fanout418/X VGND VGND VPWR VPWR load_slew420/X sky130_fd_sc_hd__clkbuf_4
X_5102_ _5530_/S _5098_/X _5100_/X hold768/X VGND VGND VPWR VPWR _5102_/X sky130_fd_sc_hd__a31o_2
XFILLER_97_343 VGND VGND VPWR VPWR sky130_fd_sc_hd__fill_2
XFILLER_58_708 VGND VGND VPWR VPWR sky130_fd_sc_hd__decap_3
XFILLER_112_654 VGND VGND VPWR VPWR sky130_fd_sc_hd__decap_3
X_6082_ _6094_/B _6078_/X _6081_/X VGND VGND VPWR VPWR _6082_/X sky130_fd_sc_hd__a21bo_2
XFILLER_85_505 VGND VGND VPWR VPWR sky130_fd_sc_hd__decap_3
XFILLER_112_676 VGND VGND VPWR VPWR sky130_fd_sc_hd__decap_3
Xhold1206 _9253_/Q VGND VGND VPWR VPWR _8850_/A1 sky130_fd_sc_hd__dlygate4sd3_1
Xhold1217 _9248_/Q VGND VGND VPWR VPWR _8839_/A1 sky130_fd_sc_hd__dlygate4sd3_1
X_5033_ _5033_/A _5513_/A VGND VGND VPWR VPWR _5034_/B sky130_fd_sc_hd__nor2_2
Xhold1228 _9250_/Q VGND VGND VPWR VPWR _8810_/A0 sky130_fd_sc_hd__dlygate4sd3_1
Xhold1239 _9231_/Q VGND VGND VPWR VPWR _8755_/A sky130_fd_sc_hd__dlygate4sd3_1
XFILLER_111_186 VGND VGND VPWR VPWR sky130_fd_sc_hd__decap_3
XFILLER_38_421 VGND VGND VPWR VPWR sky130_fd_sc_hd__decap_3
XFILLER_66_752 VGND VGND VPWR VPWR sky130_fd_sc_hd__decap_3
XFILLER_66_763 VGND VGND VPWR VPWR sky130_fd_sc_hd__decap_3
XFILLER_122_18 VGND VGND VPWR VPWR sky130_fd_sc_hd__decap_3
XFILLER_38_465 VGND VGND VPWR VPWR sky130_fd_sc_hd__decap_3
XFILLER_122_29 VGND VGND VPWR VPWR sky130_fd_sc_hd__decap_3
XFILLER_53_402 VGND VGND VPWR VPWR sky130_fd_sc_hd__decap_3
XFILLER_93_582 VGND VGND VPWR VPWR sky130_fd_sc_hd__fill_2
XFILLER_53_413 VGND VGND VPWR VPWR sky130_fd_sc_hd__decap_3
XFILLER_38_487 VGND VGND VPWR VPWR sky130_fd_sc_hd__decap_3
XFILLER_93_593 VGND VGND VPWR VPWR sky130_fd_sc_hd__decap_3
X_6984_ _6981_/X _6982_/Y _6951_/X _6956_/X VGND VGND VPWR VPWR _6985_/B sky130_fd_sc_hd__a211o_2
XTAP_TAPCELL_ROW_0_269 VGND VPWR sky130_fd_sc_hd__tapvpwrvgnd_1
X_8723_ _8721_/B _8720_/X _8722_/X _8706_/C _8716_/Y VGND VGND VPWR VPWR _8765_/B
+ sky130_fd_sc_hd__o221a_2
XFILLER_53_468 VGND VGND VPWR VPWR sky130_fd_sc_hd__decap_3
X_5935_ _5935_/A VGND VGND VPWR VPWR _5935_/X sky130_fd_sc_hd__clkbuf_1
XFILLER_53_479 VGND VGND VPWR VPWR sky130_fd_sc_hd__decap_3
XFILLER_15_27 VGND VGND VPWR VPWR sky130_fd_sc_hd__decap_3
XFILLER_40_107 VGND VGND VPWR VPWR sky130_fd_sc_hd__decap_3
XFILLER_34_682 VGND VGND VPWR VPWR sky130_fd_sc_hd__decap_3
XFILLER_80_298 VGND VGND VPWR VPWR sky130_fd_sc_hd__decap_3
XFILLER_40_129 VGND VGND VPWR VPWR sky130_fd_sc_hd__decap_3
X_8654_ _6762_/D _8653_/X _8654_/S VGND VGND VPWR VPWR _8654_/X sky130_fd_sc_hd__mux2_2
XFILLER_21_310 VGND VGND VPWR VPWR sky130_fd_sc_hd__decap_3
X_5866_ _5729_/A _5729_/B _7955_/A _6942_/A _5687_/B VGND VGND VPWR VPWR _5872_/A
+ sky130_fd_sc_hd__a221o_2
XTAP_TAPCELL_ROW_101_1639 VGND VPWR sky130_fd_sc_hd__tapvpwrvgnd_1
XFILLER_21_332 VGND VGND VPWR VPWR sky130_fd_sc_hd__decap_3
X_7605_ _7946_/A _8240_/A _7418_/B VGND VGND VPWR VPWR _7607_/A sky130_fd_sc_hd__o21a_2
X_4817_ _9154_/Q _4817_/A1 _4819_/S VGND VGND VPWR VPWR _4817_/X sky130_fd_sc_hd__mux2_2
X_8585_ _8585_/A VGND VGND VPWR VPWR _8585_/Y sky130_fd_sc_hd__inv_2
X_5797_ _5087_/B _5669_/B _5667_/S VGND VGND VPWR VPWR _5797_/X sky130_fd_sc_hd__o21a_2
Xrebuffer603 _7285_/C VGND VGND VPWR VPWR _7147_/A sky130_fd_sc_hd__buf_2
XFILLER_21_376 VGND VGND VPWR VPWR sky130_fd_sc_hd__decap_3
XFILLER_31_26 VGND VGND VPWR VPWR sky130_fd_sc_hd__decap_3
X_7536_ _8035_/S _7536_/B VGND VGND VPWR VPWR _7537_/B sky130_fd_sc_hd__xnor2_2
X_4748_ _4782_/A1 _4748_/A1 _4756_/S VGND VGND VPWR VPWR _4749_/A sky130_fd_sc_hd__mux2_2
XTAP_TAPCELL_ROW_60_1093 VGND VPWR sky130_fd_sc_hd__tapvpwrvgnd_1
XFILLER_107_426 VGND VGND VPWR VPWR sky130_fd_sc_hd__fill_2
X_7467_ _7467_/A _7468_/B _7469_/C _7469_/B VGND VGND VPWR VPWR _7467_/X sky130_fd_sc_hd__or4bb_4
X_4679_ _9088_/Q hold935/X _4693_/S VGND VGND VPWR VPWR _4679_/X sky130_fd_sc_hd__mux2_2
XPHY_EDGE_ROW_1_Right_1 VGND VGND VPWR VPWR sky130_fd_sc_hd__decap_3
X_9206_ _9209_/CLK _9206_/D fanout418/X VGND VGND VPWR VPWR _9206_/Q sky130_fd_sc_hd__dfrtp_2
X_6418_ _6418_/A _6418_/B VGND VGND VPWR VPWR _6478_/S sky130_fd_sc_hd__xnor2_2
X_7398_ _7372_/A _7373_/A _7397_/X VGND VGND VPWR VPWR _7495_/B sky130_fd_sc_hd__o21ai_2
Xoutput26 _9195_/Q VGND VGND VPWR VPWR wire228/A sky130_fd_sc_hd__buf_1
XFILLER_122_418 VGND VGND VPWR VPWR sky130_fd_sc_hd__fill_2
XFILLER_1_715 VGND VGND VPWR VPWR sky130_fd_sc_hd__decap_3
XFILLER_0_203 VGND VGND VPWR VPWR sky130_fd_sc_hd__decap_3
X_9137_ _9168_/CLK _9137_/D load_slew378/X VGND VGND VPWR VPWR _9137_/Q sky130_fd_sc_hd__dfrtp_2
X_6349_ _6944_/A _6349_/B _6349_/C VGND VGND VPWR VPWR _6350_/A sky130_fd_sc_hd__or3_4
XFILLER_115_481 VGND VGND VPWR VPWR sky130_fd_sc_hd__decap_3
XFILLER_0_225 VGND VGND VPWR VPWR sky130_fd_sc_hd__fill_1
XFILLER_1_759 VGND VGND VPWR VPWR sky130_fd_sc_hd__decap_3
XFILLER_103_643 VGND VGND VPWR VPWR sky130_fd_sc_hd__decap_3
X_9068_ _9133_/CLK _9068_/D load_slew394/X VGND VGND VPWR VPWR _9068_/Q sky130_fd_sc_hd__dfrtp_2
XFILLER_76_505 VGND VGND VPWR VPWR sky130_fd_sc_hd__decap_3
XFILLER_103_676 VGND VGND VPWR VPWR sky130_fd_sc_hd__fill_2
XFILLER_102_153 VGND VGND VPWR VPWR sky130_fd_sc_hd__fill_1
XFILLER_48_218 VGND VGND VPWR VPWR sky130_fd_sc_hd__decap_3
XFILLER_102_175 VGND VGND VPWR VPWR sky130_fd_sc_hd__decap_3
XFILLER_103_698 VGND VGND VPWR VPWR sky130_fd_sc_hd__fill_2
X_8019_ _7866_/Y _7869_/X _7871_/A VGND VGND VPWR VPWR _8020_/B sky130_fd_sc_hd__a21oi_2
XFILLER_29_410 VGND VGND VPWR VPWR sky130_fd_sc_hd__decap_3
XFILLER_130_495 VGND VGND VPWR VPWR sky130_fd_sc_hd__decap_3
XFILLER_56_23 VGND VGND VPWR VPWR sky130_fd_sc_hd__decap_3
XFILLER_57_752 VGND VGND VPWR VPWR sky130_fd_sc_hd__decap_3
XFILLER_91_508 VGND VGND VPWR VPWR sky130_fd_sc_hd__decap_3
XFILLER_91_519 VGND VGND VPWR VPWR sky130_fd_sc_hd__decap_3
XFILLER_56_56 VGND VGND VPWR VPWR sky130_fd_sc_hd__decap_3
XFILLER_72_711 VGND VGND VPWR VPWR sky130_fd_sc_hd__decap_3
XFILLER_56_78 VGND VGND VPWR VPWR sky130_fd_sc_hd__decap_3
XFILLER_29_476 VGND VGND VPWR VPWR sky130_fd_sc_hd__decap_3
XFILLER_16_104 VGND VGND VPWR VPWR sky130_fd_sc_hd__decap_3
XFILLER_84_582 VGND VGND VPWR VPWR sky130_fd_sc_hd__decap_3
XFILLER_29_498 VGND VGND VPWR VPWR sky130_fd_sc_hd__decap_3
XFILLER_72_744 VGND VGND VPWR VPWR sky130_fd_sc_hd__decap_3
XFILLER_44_435 VGND VGND VPWR VPWR sky130_fd_sc_hd__decap_3
XTAP_TAPCELL_ROW_27_644 VGND VPWR sky130_fd_sc_hd__tapvpwrvgnd_1
XFILLER_16_159 VGND VGND VPWR VPWR sky130_fd_sc_hd__decap_3
XFILLER_112_62 VGND VGND VPWR VPWR sky130_fd_sc_hd__decap_3
XFILLER_71_265 VGND VGND VPWR VPWR sky130_fd_sc_hd__fill_1
XFILLER_31_107 VGND VGND VPWR VPWR sky130_fd_sc_hd__decap_3
XFILLER_25_682 VGND VGND VPWR VPWR sky130_fd_sc_hd__decap_3
XFILLER_72_88 VGND VGND VPWR VPWR sky130_fd_sc_hd__decap_3
XFILLER_12_332 VGND VGND VPWR VPWR sky130_fd_sc_hd__decap_3
XFILLER_24_192 VGND VGND VPWR VPWR sky130_fd_sc_hd__decap_3
XFILLER_12_354 VGND VGND VPWR VPWR sky130_fd_sc_hd__decap_3
XFILLER_8_314 VGND VGND VPWR VPWR sky130_fd_sc_hd__fill_1
XFILLER_12_365 VGND VGND VPWR VPWR sky130_fd_sc_hd__fill_2
XFILLER_8_325 VGND VGND VPWR VPWR sky130_fd_sc_hd__fill_2
XFILLER_126_713 VGND VGND VPWR VPWR sky130_fd_sc_hd__decap_3
XTAP_TAPCELL_ROW_78_1332 VGND VPWR sky130_fd_sc_hd__tapvpwrvgnd_1
XFILLER_126_746 VGND VGND VPWR VPWR sky130_fd_sc_hd__decap_3
XFILLER_126_757 VGND VGND VPWR VPWR sky130_fd_sc_hd__decap_3
XFILLER_125_223 VGND VGND VPWR VPWR sky130_fd_sc_hd__fill_1
XFILLER_4_531 VGND VGND VPWR VPWR sky130_fd_sc_hd__fill_1
XFILLER_125_234 VGND VGND VPWR VPWR sky130_fd_sc_hd__decap_3
XFILLER_4_542 VGND VGND VPWR VPWR sky130_fd_sc_hd__decap_3
XFILLER_125_267 VGND VGND VPWR VPWR sky130_fd_sc_hd__decap_3
XTAP_TAPCELL_ROW_91_1510 VGND VPWR sky130_fd_sc_hd__tapvpwrvgnd_1
XFILLER_98_118 VGND VGND VPWR VPWR sky130_fd_sc_hd__decap_3
XFILLER_106_492 VGND VGND VPWR VPWR sky130_fd_sc_hd__decap_3
XFILLER_79_365 VGND VGND VPWR VPWR sky130_fd_sc_hd__fill_1
XFILLER_67_516 VGND VGND VPWR VPWR sky130_fd_sc_hd__decap_3
XTAP_TAPCELL_ROW_7_380 VGND VPWR sky130_fd_sc_hd__tapvpwrvgnd_1
XFILLER_121_484 VGND VGND VPWR VPWR sky130_fd_sc_hd__decap_3
XFILLER_11_6 VGND VGND VPWR VPWR sky130_fd_sc_hd__decap_3
XFILLER_82_508 VGND VGND VPWR VPWR sky130_fd_sc_hd__decap_3
XFILLER_94_368 VGND VGND VPWR VPWR sky130_fd_sc_hd__decap_3
XFILLER_63_711 VGND VGND VPWR VPWR sky130_fd_sc_hd__decap_3
XFILLER_35_402 VGND VGND VPWR VPWR sky130_fd_sc_hd__decap_3
XTAP_TAPCELL_ROW_89_1483 VGND VPWR sky130_fd_sc_hd__tapvpwrvgnd_1
XFILLER_47_273 VGND VGND VPWR VPWR sky130_fd_sc_hd__decap_3
XFILLER_47_295 VGND VGND VPWR VPWR sky130_fd_sc_hd__fill_1
XFILLER_63_755 VGND VGND VPWR VPWR sky130_fd_sc_hd__decap_3
XFILLER_90_541 VGND VGND VPWR VPWR sky130_fd_sc_hd__decap_3
XFILLER_35_468 VGND VGND VPWR VPWR sky130_fd_sc_hd__decap_3
Xmax_cap90 _8240_/B VGND VGND VPWR VPWR _7951_/B sky130_fd_sc_hd__buf_2
XFILLER_90_585 VGND VGND VPWR VPWR sky130_fd_sc_hd__decap_3
XFILLER_50_427 VGND VGND VPWR VPWR sky130_fd_sc_hd__decap_3
X_5720_ _5720_/A1 _7952_/A _5137_/X _6953_/A _5138_/X VGND VGND VPWR VPWR _5720_/X
+ sky130_fd_sc_hd__o2111a_2
XFILLER_94_3 VGND VGND VPWR VPWR sky130_fd_sc_hd__decap_3
XFILLER_43_490 VGND VGND VPWR VPWR sky130_fd_sc_hd__fill_1
XFILLER_15_181 VGND VGND VPWR VPWR sky130_fd_sc_hd__decap_3
X_5651_ _7561_/A _5651_/A2 _5650_/X VGND VGND VPWR VPWR _9204_/D sky130_fd_sc_hd__a21o_2
XFILLER_31_685 VGND VGND VPWR VPWR sky130_fd_sc_hd__decap_3
X_4602_ _9052_/Q _4602_/A1 _4608_/S VGND VGND VPWR VPWR _4602_/X sky130_fd_sc_hd__mux2_2
X_8370_ _8402_/A wire45/A VGND VGND VPWR VPWR _8370_/Y sky130_fd_sc_hd__nand2_2
X_5582_ _6302_/A _5588_/B _5588_/C VGND VGND VPWR VPWR _7071_/B sky130_fd_sc_hd__or3_4
XFILLER_117_702 VGND VGND VPWR VPWR sky130_fd_sc_hd__decap_3
XFILLER_129_573 VGND VGND VPWR VPWR sky130_fd_sc_hd__decap_3
X_7321_ _7604_/A _8066_/A VGND VGND VPWR VPWR _7325_/A sky130_fd_sc_hd__nor2_2
XFILLER_117_724 VGND VGND VPWR VPWR sky130_fd_sc_hd__decap_3
X_4533_ _4533_/A VGND VGND VPWR VPWR _9019_/D sky130_fd_sc_hd__buf_1
XFILLER_7_391 VGND VGND VPWR VPWR sky130_fd_sc_hd__fill_1
XFILLER_117_768 VGND VGND VPWR VPWR sky130_fd_sc_hd__decap_3
X_7252_ _7243_/X _7247_/X _7248_/X _7251_/Y VGND VGND VPWR VPWR _7253_/B sky130_fd_sc_hd__o211a_2
XFILLER_117_18 VGND VGND VPWR VPWR sky130_fd_sc_hd__decap_3
X_6203_ _6203_/A _6203_/B VGND VGND VPWR VPWR _6204_/B sky130_fd_sc_hd__xnor2_2
X_7183_ _7183_/A _7183_/B VGND VGND VPWR VPWR _7184_/B sky130_fd_sc_hd__xor2_2
XFILLER_98_641 VGND VGND VPWR VPWR sky130_fd_sc_hd__decap_3
X_6134_ _6790_/A _6134_/B _7244_/B VGND VGND VPWR VPWR _6134_/X sky130_fd_sc_hd__and3_2
XFILLER_112_440 VGND VGND VPWR VPWR sky130_fd_sc_hd__decap_3
XFILLER_98_685 VGND VGND VPWR VPWR sky130_fd_sc_hd__decap_3
XFILLER_112_462 VGND VGND VPWR VPWR sky130_fd_sc_hd__decap_3
Xload_slew250 _4991_/C VGND VGND VPWR VPWR _5119_/S sky130_fd_sc_hd__buf_8
XFILLER_58_527 VGND VGND VPWR VPWR sky130_fd_sc_hd__decap_3
Xhold1003 _9039_/Q VGND VGND VPWR VPWR _4608_/A1 sky130_fd_sc_hd__dlygate4sd3_1
X_6065_ _6065_/A _6065_/B VGND VGND VPWR VPWR _6069_/B sky130_fd_sc_hd__xnor2_4
Xhold1014 _9307_/Q VGND VGND VPWR VPWR _8963_/A1 sky130_fd_sc_hd__dlygate4sd3_1
Xload_slew283 _8011_/C VGND VGND VPWR VPWR _6797_/B sky130_fd_sc_hd__clkbuf_2
Xhold1025 _9147_/Q VGND VGND VPWR VPWR _4803_/A0 sky130_fd_sc_hd__dlygate4sd3_1
Xload_slew294 _6501_/A VGND VGND VPWR VPWR _6790_/A sky130_fd_sc_hd__buf_2
Xhold1036 _4788_/X VGND VGND VPWR VPWR _4789_/A sky130_fd_sc_hd__dlygate4sd3_1
Xhold1047 _9042_/Q VGND VGND VPWR VPWR _4615_/A1 sky130_fd_sc_hd__dlygate4sd3_1
X_5016_ _5016_/A _5016_/B _5043_/B VGND VGND VPWR VPWR _5017_/B sky130_fd_sc_hd__and3_2
Xhold1058 _9305_/Q VGND VGND VPWR VPWR _8959_/A1 sky130_fd_sc_hd__dlygate4sd3_1
XFILLER_38_240 VGND VGND VPWR VPWR sky130_fd_sc_hd__decap_3
Xhold1069 _4807_/X VGND VGND VPWR VPWR _4808_/A sky130_fd_sc_hd__dlygate4sd3_1
XFILLER_66_560 VGND VGND VPWR VPWR sky130_fd_sc_hd__decap_3
XFILLER_54_711 VGND VGND VPWR VPWR sky130_fd_sc_hd__fill_2
XFILLER_66_582 VGND VGND VPWR VPWR sky130_fd_sc_hd__decap_3
XFILLER_26_413 VGND VGND VPWR VPWR sky130_fd_sc_hd__decap_3
XFILLER_26_424 VGND VGND VPWR VPWR sky130_fd_sc_hd__decap_3
X_6967_ _6967_/A _7058_/B _7058_/C VGND VGND VPWR VPWR _6969_/B sky130_fd_sc_hd__nand3_2
XTAP_TAPCELL_ROW_24_603 VGND VPWR sky130_fd_sc_hd__tapvpwrvgnd_1
X_5918_ _5808_/A _5808_/B _5809_/A VGND VGND VPWR VPWR _5918_/X sky130_fd_sc_hd__a21bo_2
X_8706_ _8706_/A _8716_/B _8706_/C _8718_/A VGND VGND VPWR VPWR _8706_/X sky130_fd_sc_hd__and4_2
XTAP_TAPCELL_ROW_62_1122 VGND VPWR sky130_fd_sc_hd__tapvpwrvgnd_1
X_6898_ _6899_/A _6899_/B VGND VGND VPWR VPWR _7150_/B sky130_fd_sc_hd__nor2_2
Xclkbuf_leaf_33_clk clkload2/A VGND VGND VPWR VPWR _9219_/CLK sky130_fd_sc_hd__clkbuf_8
XFILLER_42_25 VGND VGND VPWR VPWR sky130_fd_sc_hd__decap_3
XTAP_TAPCELL_ROW_52_978 VGND VPWR sky130_fd_sc_hd__tapvpwrvgnd_1
X_8637_ _8605_/A _8632_/Y _8635_/X _8636_/X VGND VGND VPWR VPWR _8637_/X sky130_fd_sc_hd__a22o_2
XTAP_TAPCELL_ROW_52_989 VGND VPWR sky130_fd_sc_hd__tapvpwrvgnd_1
XFILLER_22_663 VGND VGND VPWR VPWR sky130_fd_sc_hd__decap_3
XFILLER_21_140 VGND VGND VPWR VPWR sky130_fd_sc_hd__decap_3
X_5849_ _5849_/A _5849_/B VGND VGND VPWR VPWR _5851_/A sky130_fd_sc_hd__xnor2_2
X_8568_ _9225_/Q _8566_/A wire66/X _8567_/Y VGND VGND VPWR VPWR _8568_/X sky130_fd_sc_hd__o22a_2
Xrebuffer422 _6361_/B VGND VGND VPWR VPWR _6540_/A sky130_fd_sc_hd__buf_2
XFILLER_21_195 VGND VGND VPWR VPWR sky130_fd_sc_hd__decap_3
Xrebuffer433 _6281_/Y VGND VGND VPWR VPWR _6560_/A sky130_fd_sc_hd__buf_2
Xrebuffer444 _6385_/X VGND VGND VPWR VPWR _6386_/B sky130_fd_sc_hd__buf_6
X_7519_ _7659_/B _7515_/X _7517_/X _7661_/A _7518_/Y VGND VGND VPWR VPWR _7550_/A
+ sky130_fd_sc_hd__o221a_2
Xrebuffer455 _9234_/Q VGND VGND VPWR VPWR fanout265/A sky130_fd_sc_hd__buf_6
XFILLER_5_317 VGND VGND VPWR VPWR sky130_fd_sc_hd__decap_3
Xrebuffer466 _5720_/A1 VGND VGND VPWR VPWR _5713_/A sky130_fd_sc_hd__buf_4
XFILLER_107_223 VGND VGND VPWR VPWR sky130_fd_sc_hd__fill_1
XFILLER_108_746 VGND VGND VPWR VPWR sky130_fd_sc_hd__fill_2
X_8499_ _8548_/A _8515_/B VGND VGND VPWR VPWR _8500_/B sky130_fd_sc_hd__xnor2_2
Xrebuffer477 _5473_/Y VGND VGND VPWR VPWR _5830_/C sky130_fd_sc_hd__buf_6
Xrebuffer488 _6352_/A VGND VGND VPWR VPWR _6244_/C sky130_fd_sc_hd__buf_4
XTAP_TAPCELL_ROW_114_1819 VGND VPWR sky130_fd_sc_hd__tapvpwrvgnd_1
Xrebuffer499 _6976_/A VGND VGND VPWR VPWR rebuffer499/X sky130_fd_sc_hd__buf_6
XFILLER_107_278 VGND VGND VPWR VPWR sky130_fd_sc_hd__fill_2
XFILLER_123_727 VGND VGND VPWR VPWR sky130_fd_sc_hd__fill_1
XFILLER_123_738 VGND VGND VPWR VPWR sky130_fd_sc_hd__decap_3
XFILLER_122_215 VGND VGND VPWR VPWR sky130_fd_sc_hd__decap_3
Xhold870 _9053_/Q VGND VGND VPWR VPWR hold870/X sky130_fd_sc_hd__dlygate4sd3_1
XFILLER_122_237 VGND VGND VPWR VPWR sky130_fd_sc_hd__decap_3
Xhold881 _4784_/X VGND VGND VPWR VPWR _4785_/A sky130_fd_sc_hd__dlygate4sd3_1
Xhold892 _9070_/Q VGND VGND VPWR VPWR hold892/X sky130_fd_sc_hd__dlygate4sd3_1
XTAP_TAPCELL_ROW_73_1262 VGND VPWR sky130_fd_sc_hd__tapvpwrvgnd_1
XFILLER_107_73 VGND VGND VPWR VPWR sky130_fd_sc_hd__fill_2
XTAP_TAPCELL_ROW_73_1273 VGND VPWR sky130_fd_sc_hd__tapvpwrvgnd_1
XFILLER_49_505 VGND VGND VPWR VPWR sky130_fd_sc_hd__decap_3
XFILLER_88_151 VGND VGND VPWR VPWR sky130_fd_sc_hd__decap_3
XFILLER_89_685 VGND VGND VPWR VPWR sky130_fd_sc_hd__decap_3
XFILLER_67_33 VGND VGND VPWR VPWR sky130_fd_sc_hd__decap_3
XFILLER_67_44 VGND VGND VPWR VPWR sky130_fd_sc_hd__decap_3
XFILLER_49_538 VGND VGND VPWR VPWR sky130_fd_sc_hd__decap_3
XFILLER_67_99 VGND VGND VPWR VPWR sky130_fd_sc_hd__decap_3
XFILLER_64_519 VGND VGND VPWR VPWR sky130_fd_sc_hd__fill_2
XFILLER_91_305 VGND VGND VPWR VPWR sky130_fd_sc_hd__fill_2
XFILLER_57_571 VGND VGND VPWR VPWR sky130_fd_sc_hd__decap_3
XFILLER_45_711 VGND VGND VPWR VPWR sky130_fd_sc_hd__decap_3
XFILLER_123_72 VGND VGND VPWR VPWR sky130_fd_sc_hd__decap_3
XFILLER_91_349 VGND VGND VPWR VPWR sky130_fd_sc_hd__fill_2
XFILLER_44_221 VGND VGND VPWR VPWR sky130_fd_sc_hd__decap_3
XFILLER_29_295 VGND VGND VPWR VPWR sky130_fd_sc_hd__decap_3
XFILLER_72_563 VGND VGND VPWR VPWR sky130_fd_sc_hd__decap_3
XFILLER_44_265 VGND VGND VPWR VPWR sky130_fd_sc_hd__fill_2
XFILLER_72_585 VGND VGND VPWR VPWR sky130_fd_sc_hd__decap_3
XFILLER_60_736 VGND VGND VPWR VPWR sky130_fd_sc_hd__decap_3
Xclkbuf_leaf_24_clk clkload2/A VGND VGND VPWR VPWR _9317_/CLK sky130_fd_sc_hd__clkbuf_8
XFILLER_13_685 VGND VGND VPWR VPWR sky130_fd_sc_hd__decap_3
XFILLER_12_162 VGND VGND VPWR VPWR sky130_fd_sc_hd__decap_3
XFILLER_8_144 VGND VGND VPWR VPWR sky130_fd_sc_hd__decap_3
XFILLER_32_80 VGND VGND VPWR VPWR sky130_fd_sc_hd__decap_3
XFILLER_126_510 VGND VGND VPWR VPWR sky130_fd_sc_hd__decap_3
XFILLER_8_188 VGND VGND VPWR VPWR sky130_fd_sc_hd__decap_3
XFILLER_32_91 VGND VGND VPWR VPWR sky130_fd_sc_hd__decap_3
XFILLER_126_521 VGND VGND VPWR VPWR sky130_fd_sc_hd__decap_3
XFILLER_59_6 VGND VGND VPWR VPWR sky130_fd_sc_hd__fill_2
XFILLER_99_405 VGND VGND VPWR VPWR sky130_fd_sc_hd__fill_1
XFILLER_126_576 VGND VGND VPWR VPWR sky130_fd_sc_hd__fill_1
XFILLER_114_716 VGND VGND VPWR VPWR sky130_fd_sc_hd__decap_3
XFILLER_99_427 VGND VGND VPWR VPWR sky130_fd_sc_hd__fill_1
XFILLER_4_361 VGND VGND VPWR VPWR sky130_fd_sc_hd__decap_3
XFILLER_99_438 VGND VGND VPWR VPWR sky130_fd_sc_hd__decap_3
XFILLER_114_738 VGND VGND VPWR VPWR sky130_fd_sc_hd__decap_3
XFILLER_99_449 VGND VGND VPWR VPWR sky130_fd_sc_hd__decap_3
XFILLER_4_383 VGND VGND VPWR VPWR sky130_fd_sc_hd__decap_3
XFILLER_122_760 VGND VGND VPWR VPWR sky130_fd_sc_hd__decap_3
XFILLER_95_611 VGND VGND VPWR VPWR sky130_fd_sc_hd__decap_3
XFILLER_95_644 VGND VGND VPWR VPWR sky130_fd_sc_hd__decap_3
XFILLER_67_335 VGND VGND VPWR VPWR sky130_fd_sc_hd__fill_1
XFILLER_67_346 VGND VGND VPWR VPWR sky130_fd_sc_hd__decap_3
XTAP_TAPCELL_ROW_2_309 VGND VPWR sky130_fd_sc_hd__tapvpwrvgnd_1
XFILLER_94_165 VGND VGND VPWR VPWR sky130_fd_sc_hd__decap_3
XFILLER_48_560 VGND VGND VPWR VPWR sky130_fd_sc_hd__decap_3
X_7870_ _7534_/A _7869_/X _7866_/Y VGND VGND VPWR VPWR _7871_/B sky130_fd_sc_hd__o21ai_2
XFILLER_82_349 VGND VGND VPWR VPWR sky130_fd_sc_hd__fill_2
XFILLER_63_552 VGND VGND VPWR VPWR sky130_fd_sc_hd__decap_3
XFILLER_35_243 VGND VGND VPWR VPWR sky130_fd_sc_hd__decap_3
X_6821_ input6/X _6886_/B _6821_/S VGND VGND VPWR VPWR _6822_/B sky130_fd_sc_hd__mux2_2
XFILLER_51_703 VGND VGND VPWR VPWR sky130_fd_sc_hd__fill_1
XFILLER_90_360 VGND VGND VPWR VPWR sky130_fd_sc_hd__decap_3
XFILLER_63_585 VGND VGND VPWR VPWR sky130_fd_sc_hd__decap_3
XFILLER_90_371 VGND VGND VPWR VPWR sky130_fd_sc_hd__decap_3
XFILLER_51_736 VGND VGND VPWR VPWR sky130_fd_sc_hd__decap_3
XFILLER_35_287 VGND VGND VPWR VPWR sky130_fd_sc_hd__decap_3
XFILLER_23_438 VGND VGND VPWR VPWR sky130_fd_sc_hd__decap_3
X_6752_ _9113_/Q _6757_/C _6758_/C VGND VGND VPWR VPWR _6752_/X sky130_fd_sc_hd__and3_2
Xclkbuf_leaf_15_clk clkbuf_leaf_9_clk/A VGND VGND VPWR VPWR _9296_/CLK sky130_fd_sc_hd__clkbuf_8
X_5703_ _5703_/A _5703_/B VGND VGND VPWR VPWR _5864_/S sky130_fd_sc_hd__xor2_2
X_6683_ _6992_/C _6683_/B VGND VGND VPWR VPWR _6684_/B sky130_fd_sc_hd__xor2_2
X_8422_ _8352_/B _8421_/X _8337_/Y VGND VGND VPWR VPWR _8433_/A sky130_fd_sc_hd__o21a_2
XFILLER_31_493 VGND VGND VPWR VPWR sky130_fd_sc_hd__decap_3
X_5634_ _5753_/A _5634_/B VGND VGND VPWR VPWR _5635_/B sky130_fd_sc_hd__xnor2_2
X_8353_ _8353_/A _8353_/B VGND VGND VPWR VPWR _8354_/B sky130_fd_sc_hd__xnor2_2
X_5565_ _5830_/A _5830_/B _5830_/C _5474_/Y VGND VGND VPWR VPWR _5566_/A sky130_fd_sc_hd__a31oi_4
XFILLER_117_543 VGND VGND VPWR VPWR sky130_fd_sc_hd__fill_1
X_7304_ _7303_/B _7303_/A _7054_/B VGND VGND VPWR VPWR _7304_/Y sky130_fd_sc_hd__a21oi_4
X_4516_ _4516_/A VGND VGND VPWR VPWR _4516_/X sky130_fd_sc_hd__buf_12
XFILLER_105_716 VGND VGND VPWR VPWR sky130_fd_sc_hd__decap_3
X_8284_ _8286_/S _8297_/A VGND VGND VPWR VPWR _8284_/Y sky130_fd_sc_hd__nor2_2
X_5496_ _5492_/X _5495_/B _5494_/X _5495_/Y VGND VGND VPWR VPWR _5497_/B sky130_fd_sc_hd__o211a_2
XFILLER_2_309 VGND VGND VPWR VPWR sky130_fd_sc_hd__fill_2
X_7235_ _7183_/A _7184_/A _7234_/X VGND VGND VPWR VPWR _7659_/A sky130_fd_sc_hd__a21o_2
XFILLER_104_259 VGND VGND VPWR VPWR sky130_fd_sc_hd__decap_3
XFILLER_120_719 VGND VGND VPWR VPWR sky130_fd_sc_hd__decap_3
X_7166_ _6892_/A _6892_/B _6893_/A VGND VGND VPWR VPWR _7166_/X sky130_fd_sc_hd__a21o_2
XTAP_TAPCELL_ROW_129_2026 VGND VPWR sky130_fd_sc_hd__tapvpwrvgnd_1
XFILLER_98_471 VGND VGND VPWR VPWR sky130_fd_sc_hd__decap_3
XFILLER_86_622 VGND VGND VPWR VPWR sky130_fd_sc_hd__decap_3
X_6117_ _6113_/A _6805_/A _5229_/X _6117_/B2 VGND VGND VPWR VPWR _6117_/X sky130_fd_sc_hd__a22o_4
XFILLER_98_493 VGND VGND VPWR VPWR sky130_fd_sc_hd__decap_3
X_7097_ _7093_/Y _7094_/X _7095_/Y _7096_/Y _7038_/A VGND VGND VPWR VPWR _7097_/X
+ sky130_fd_sc_hd__a41o_2
XFILLER_86_666 VGND VGND VPWR VPWR sky130_fd_sc_hd__decap_3
XFILLER_85_154 VGND VGND VPWR VPWR sky130_fd_sc_hd__decap_3
XFILLER_58_368 VGND VGND VPWR VPWR sky130_fd_sc_hd__decap_3
X_6048_ _6157_/B _6161_/B wire76/X VGND VGND VPWR VPWR _6049_/B sky130_fd_sc_hd__o21ai_2
XFILLER_85_187 VGND VGND VPWR VPWR sky130_fd_sc_hd__decap_3
XFILLER_54_541 VGND VGND VPWR VPWR sky130_fd_sc_hd__decap_3
XFILLER_27_755 VGND VGND VPWR VPWR sky130_fd_sc_hd__decap_3
X_7999_ _7999_/A _7999_/B VGND VGND VPWR VPWR _7999_/Y sky130_fd_sc_hd__nand2_2
XFILLER_81_371 VGND VGND VPWR VPWR sky130_fd_sc_hd__decap_3
XFILLER_54_585 VGND VGND VPWR VPWR sky130_fd_sc_hd__decap_3
XFILLER_53_24 VGND VGND VPWR VPWR sky130_fd_sc_hd__decap_3
XFILLER_42_725 VGND VGND VPWR VPWR sky130_fd_sc_hd__decap_3
XTAP_TAPCELL_ROW_37_783 VGND VPWR sky130_fd_sc_hd__tapvpwrvgnd_1
XFILLER_14_427 VGND VGND VPWR VPWR sky130_fd_sc_hd__decap_3
XFILLER_81_393 VGND VGND VPWR VPWR sky130_fd_sc_hd__decap_3
XFILLER_42_769 VGND VGND VPWR VPWR sky130_fd_sc_hd__decap_3
XFILLER_41_279 VGND VGND VPWR VPWR sky130_fd_sc_hd__fill_1
XFILLER_10_600 VGND VGND VPWR VPWR sky130_fd_sc_hd__decap_3
XFILLER_10_666 VGND VGND VPWR VPWR sky130_fd_sc_hd__decap_3
XFILLER_6_648 VGND VGND VPWR VPWR sky130_fd_sc_hd__fill_1
XFILLER_5_125 VGND VGND VPWR VPWR sky130_fd_sc_hd__decap_3
XFILLER_108_565 VGND VGND VPWR VPWR sky130_fd_sc_hd__fill_1
XFILLER_5_169 VGND VGND VPWR VPWR sky130_fd_sc_hd__fill_1
XFILLER_118_50 VGND VGND VPWR VPWR sky130_fd_sc_hd__decap_3
XFILLER_118_83 VGND VGND VPWR VPWR sky130_fd_sc_hd__fill_1
XFILLER_123_546 VGND VGND VPWR VPWR sky130_fd_sc_hd__decap_3
XFILLER_118_94 VGND VGND VPWR VPWR sky130_fd_sc_hd__decap_3
XFILLER_89_471 VGND VGND VPWR VPWR sky130_fd_sc_hd__decap_3
XFILLER_49_368 VGND VGND VPWR VPWR sky130_fd_sc_hd__decap_3
XFILLER_37_508 VGND VGND VPWR VPWR sky130_fd_sc_hd__decap_3
XFILLER_77_688 VGND VGND VPWR VPWR sky130_fd_sc_hd__fill_1
XFILLER_64_305 VGND VGND VPWR VPWR sky130_fd_sc_hd__decap_3
XFILLER_91_113 VGND VGND VPWR VPWR sky130_fd_sc_hd__decap_3
XFILLER_18_722 VGND VGND VPWR VPWR sky130_fd_sc_hd__decap_3
XFILLER_17_210 VGND VGND VPWR VPWR sky130_fd_sc_hd__decap_3
XTAP_TAPCELL_ROW_86_1442 VGND VPWR sky130_fd_sc_hd__tapvpwrvgnd_1
XFILLER_18_755 VGND VGND VPWR VPWR sky130_fd_sc_hd__fill_1
XFILLER_18_766 VGND VGND VPWR VPWR sky130_fd_sc_hd__decap_3
XFILLER_17_243 VGND VGND VPWR VPWR sky130_fd_sc_hd__decap_3
XFILLER_27_91 VGND VGND VPWR VPWR sky130_fd_sc_hd__decap_3
XFILLER_60_511 VGND VGND VPWR VPWR sky130_fd_sc_hd__decap_3
XFILLER_45_585 VGND VGND VPWR VPWR sky130_fd_sc_hd__decap_3
XFILLER_17_287 VGND VGND VPWR VPWR sky130_fd_sc_hd__decap_3
XFILLER_60_533 VGND VGND VPWR VPWR sky130_fd_sc_hd__fill_2
XFILLER_20_408 VGND VGND VPWR VPWR sky130_fd_sc_hd__decap_3
XTAP_TAPCELL_ROW_15_488 VGND VPWR sky130_fd_sc_hd__tapvpwrvgnd_1
XFILLER_9_420 VGND VGND VPWR VPWR sky130_fd_sc_hd__decap_3
XFILLER_13_471 VGND VGND VPWR VPWR sky130_fd_sc_hd__decap_3
XFILLER_9_431 VGND VGND VPWR VPWR sky130_fd_sc_hd__decap_3
XFILLER_13_493 VGND VGND VPWR VPWR sky130_fd_sc_hd__decap_3
X_5350_ _7472_/A _5350_/B VGND VGND VPWR VPWR _5350_/Y sky130_fd_sc_hd__nand2_2
XFILLER_57_3 VGND VGND VPWR VPWR sky130_fd_sc_hd__decap_3
XTAP_TAPCELL_ROW_97_1593 VGND VPWR sky130_fd_sc_hd__tapvpwrvgnd_1
X_5281_ _5281_/A _5281_/B VGND VGND VPWR VPWR _5412_/B sky130_fd_sc_hd__xnor2_2
X_7020_ _7020_/A _7020_/B VGND VGND VPWR VPWR _7033_/A sky130_fd_sc_hd__xnor2_2
XFILLER_114_568 VGND VGND VPWR VPWR sky130_fd_sc_hd__decap_3
XFILLER_102_719 VGND VGND VPWR VPWR sky130_fd_sc_hd__decap_3
XFILLER_101_207 VGND VGND VPWR VPWR sky130_fd_sc_hd__decap_3
Xclkbuf_leaf_4_clk clkload0/A VGND VGND VPWR VPWR clkload5/A sky130_fd_sc_hd__clkbuf_8
XFILLER_68_611 VGND VGND VPWR VPWR sky130_fd_sc_hd__fill_2
X_8971_ _8971_/A VGND VGND VPWR VPWR _9326_/D sky130_fd_sc_hd__buf_1
XFILLER_82_102 VGND VGND VPWR VPWR sky130_fd_sc_hd__decap_3
XFILLER_68_699 VGND VGND VPWR VPWR sky130_fd_sc_hd__fill_1
X_7922_ _7809_/A _7809_/B _7810_/A VGND VGND VPWR VPWR _7922_/X sky130_fd_sc_hd__o21a_2
XFILLER_55_349 VGND VGND VPWR VPWR sky130_fd_sc_hd__decap_3
XFILLER_48_390 VGND VGND VPWR VPWR sky130_fd_sc_hd__fill_1
XFILLER_82_157 VGND VGND VPWR VPWR sky130_fd_sc_hd__decap_3
XFILLER_130_18 VGND VGND VPWR VPWR sky130_fd_sc_hd__decap_3
X_7853_ _7856_/A _7853_/B VGND VGND VPWR VPWR _7853_/X sky130_fd_sc_hd__or2_2
XFILLER_24_714 VGND VGND VPWR VPWR sky130_fd_sc_hd__decap_3
XFILLER_130_29 VGND VGND VPWR VPWR sky130_fd_sc_hd__decap_3
X_6804_ _7676_/C _6812_/S VGND VGND VPWR VPWR _6805_/B sky130_fd_sc_hd__and2_2
XFILLER_63_393 VGND VGND VPWR VPWR sky130_fd_sc_hd__decap_3
XFILLER_24_747 VGND VGND VPWR VPWR sky130_fd_sc_hd__decap_3
X_7784_ _8170_/A _7784_/B _7784_/C VGND VGND VPWR VPWR _7784_/X sky130_fd_sc_hd__and3_2
XTAP_TAPCELL_ROW_34_742 VGND VPWR sky130_fd_sc_hd__tapvpwrvgnd_1
XFILLER_24_769 VGND VGND VPWR VPWR sky130_fd_sc_hd__decap_3
X_4996_ _9051_/Q _9083_/Q _6206_/B VGND VGND VPWR VPWR _4996_/X sky130_fd_sc_hd__mux2_2
XFILLER_51_566 VGND VGND VPWR VPWR sky130_fd_sc_hd__decap_3
XFILLER_11_408 VGND VGND VPWR VPWR sky130_fd_sc_hd__decap_3
X_6735_ _7090_/A VGND VGND VPWR VPWR _8421_/A sky130_fd_sc_hd__buf_2
X_6666_ _6666_/A _6670_/A VGND VGND VPWR VPWR _6666_/Y sky130_fd_sc_hd__nor2_2
XFILLER_128_9 VGND VGND VPWR VPWR sky130_fd_sc_hd__decap_3
X_5617_ _9278_/Q _5065_/X _6607_/C _5616_/X VGND VGND VPWR VPWR _5617_/Y sky130_fd_sc_hd__a22oi_2
X_8405_ _8405_/A _8405_/B VGND VGND VPWR VPWR _8406_/C sky130_fd_sc_hd__xnor2_2
X_6597_ _6665_/A _6665_/B VGND VGND VPWR VPWR _6598_/B sky130_fd_sc_hd__xor2_2
X_8336_ _8397_/A _8337_/B VGND VGND VPWR VPWR _8336_/X sky130_fd_sc_hd__or2_2
XFILLER_3_607 VGND VGND VPWR VPWR sky130_fd_sc_hd__decap_3
XFILLER_117_340 VGND VGND VPWR VPWR sky130_fd_sc_hd__decap_3
X_5548_ _5548_/A _5548_/B VGND VGND VPWR VPWR _5552_/A sky130_fd_sc_hd__xnor2_2
XFILLER_3_629 VGND VGND VPWR VPWR sky130_fd_sc_hd__decap_3
XFILLER_2_106 VGND VGND VPWR VPWR sky130_fd_sc_hd__decap_3
X_8267_ _9219_/Q _8271_/B _8216_/A _8266_/Y VGND VGND VPWR VPWR _8267_/X sky130_fd_sc_hd__a31o_2
XTAP_TAPCELL_ROW_57_1054 VGND VPWR sky130_fd_sc_hd__tapvpwrvgnd_1
X_5479_ _7945_/A _5479_/B VGND VGND VPWR VPWR _5480_/B sky130_fd_sc_hd__xnor2_2
XFILLER_2_139 VGND VGND VPWR VPWR sky130_fd_sc_hd__fill_1
XFILLER_78_408 VGND VGND VPWR VPWR sky130_fd_sc_hd__decap_3
X_7218_ hold805/X _7217_/Y _7560_/S VGND VGND VPWR VPWR _7218_/X sky130_fd_sc_hd__mux2_2
X_8198_ wire66/A _8083_/Y _9219_/Q VGND VGND VPWR VPWR _8198_/X sky130_fd_sc_hd__mux2_2
Xfanout410 input1/X VGND VGND VPWR VPWR fanout410/X sky130_fd_sc_hd__clkdlybuf4s25_1
XTAP_TAPCELL_ROW_70_1221 VGND VPWR sky130_fd_sc_hd__tapvpwrvgnd_1
XFILLER_59_611 VGND VGND VPWR VPWR sky130_fd_sc_hd__decap_3
XTAP_TAPCELL_ROW_70_1232 VGND VPWR sky130_fd_sc_hd__tapvpwrvgnd_1
XFILLER_48_24 VGND VGND VPWR VPWR sky130_fd_sc_hd__decap_3
XFILLER_48_35 VGND VGND VPWR VPWR sky130_fd_sc_hd__fill_2
X_7149_ _7148_/A _7150_/B _7148_/X _7149_/B2 VGND VGND VPWR VPWR _7149_/X sky130_fd_sc_hd__o22a_2
XFILLER_98_290 VGND VGND VPWR VPWR sky130_fd_sc_hd__fill_2
XFILLER_86_430 VGND VGND VPWR VPWR sky130_fd_sc_hd__decap_3
XFILLER_48_68 VGND VGND VPWR VPWR sky130_fd_sc_hd__decap_3
XFILLER_100_240 VGND VGND VPWR VPWR sky130_fd_sc_hd__decap_3
XPHY_EDGE_ROW_122_Right_122 VGND VGND VPWR VPWR sky130_fd_sc_hd__decap_3
XFILLER_86_463 VGND VGND VPWR VPWR sky130_fd_sc_hd__decap_3
XFILLER_19_519 VGND VGND VPWR VPWR sky130_fd_sc_hd__decap_3
XFILLER_39_390 VGND VGND VPWR VPWR sky130_fd_sc_hd__fill_2
XFILLER_27_541 VGND VGND VPWR VPWR sky130_fd_sc_hd__decap_3
XFILLER_104_85 VGND VGND VPWR VPWR sky130_fd_sc_hd__decap_3
XFILLER_15_703 VGND VGND VPWR VPWR sky130_fd_sc_hd__decap_3
XTAP_TAPCELL_ROW_122_1929 VGND VPWR sky130_fd_sc_hd__tapvpwrvgnd_1
XFILLER_82_680 VGND VGND VPWR VPWR sky130_fd_sc_hd__decap_3
XFILLER_54_371 VGND VGND VPWR VPWR sky130_fd_sc_hd__decap_3
XFILLER_27_585 VGND VGND VPWR VPWR sky130_fd_sc_hd__decap_3
XFILLER_14_213 VGND VGND VPWR VPWR sky130_fd_sc_hd__decap_3
XTAP_TAPCELL_ROW_68_1194 VGND VPWR sky130_fd_sc_hd__tapvpwrvgnd_1
XFILLER_42_533 VGND VGND VPWR VPWR sky130_fd_sc_hd__decap_3
XFILLER_15_747 VGND VGND VPWR VPWR sky130_fd_sc_hd__decap_3
XFILLER_54_393 VGND VGND VPWR VPWR sky130_fd_sc_hd__decap_3
XFILLER_42_544 VGND VGND VPWR VPWR sky130_fd_sc_hd__decap_3
XFILLER_9_18 VGND VGND VPWR VPWR sky130_fd_sc_hd__decap_3
XFILLER_120_62 VGND VGND VPWR VPWR sky130_fd_sc_hd__decap_3
XFILLER_30_739 VGND VGND VPWR VPWR sky130_fd_sc_hd__decap_3
XTAP_TAPCELL_ROW_81_1372 VGND VPWR sky130_fd_sc_hd__tapvpwrvgnd_1
XTAP_TAPCELL_ROW_12_447 VGND VPWR sky130_fd_sc_hd__tapvpwrvgnd_1
XFILLER_128_616 VGND VGND VPWR VPWR sky130_fd_sc_hd__decap_3
XFILLER_13_71 VGND VGND VPWR VPWR sky130_fd_sc_hd__decap_3
XFILLER_127_137 VGND VGND VPWR VPWR sky130_fd_sc_hd__decap_3
XFILLER_6_445 VGND VGND VPWR VPWR sky130_fd_sc_hd__decap_3
XFILLER_129_60 VGND VGND VPWR VPWR sky130_fd_sc_hd__decap_3
XFILLER_89_31 VGND VGND VPWR VPWR sky130_fd_sc_hd__decap_3
XFILLER_89_42 VGND VGND VPWR VPWR sky130_fd_sc_hd__fill_1
XFILLER_129_93 VGND VGND VPWR VPWR sky130_fd_sc_hd__decap_3
XFILLER_123_332 VGND VGND VPWR VPWR sky130_fd_sc_hd__decap_3
XFILLER_2_640 VGND VGND VPWR VPWR sky130_fd_sc_hd__decap_3
XFILLER_123_343 VGND VGND VPWR VPWR sky130_fd_sc_hd__decap_3
XFILLER_97_717 VGND VGND VPWR VPWR sky130_fd_sc_hd__decap_3
XFILLER_2_651 VGND VGND VPWR VPWR sky130_fd_sc_hd__decap_3
XFILLER_69_419 VGND VGND VPWR VPWR sky130_fd_sc_hd__decap_3
XFILLER_111_505 VGND VGND VPWR VPWR sky130_fd_sc_hd__decap_3
XFILLER_2_684 VGND VGND VPWR VPWR sky130_fd_sc_hd__decap_3
XFILLER_111_538 VGND VGND VPWR VPWR sky130_fd_sc_hd__decap_3
XFILLER_96_238 VGND VGND VPWR VPWR sky130_fd_sc_hd__decap_3
XFILLER_77_452 VGND VGND VPWR VPWR sky130_fd_sc_hd__decap_3
XFILLER_49_143 VGND VGND VPWR VPWR sky130_fd_sc_hd__decap_3
XFILLER_92_411 VGND VGND VPWR VPWR sky130_fd_sc_hd__fill_1
XFILLER_77_485 VGND VGND VPWR VPWR sky130_fd_sc_hd__decap_3
XFILLER_37_316 VGND VGND VPWR VPWR sky130_fd_sc_hd__decap_3
XFILLER_65_647 VGND VGND VPWR VPWR sky130_fd_sc_hd__decap_3
XFILLER_92_455 VGND VGND VPWR VPWR sky130_fd_sc_hd__decap_3
XFILLER_92_477 VGND VGND VPWR VPWR sky130_fd_sc_hd__fill_1
XFILLER_52_319 VGND VGND VPWR VPWR sky130_fd_sc_hd__decap_3
XFILLER_33_500 VGND VGND VPWR VPWR sky130_fd_sc_hd__decap_3
XFILLER_33_511 VGND VGND VPWR VPWR sky130_fd_sc_hd__decap_3
XFILLER_45_393 VGND VGND VPWR VPWR sky130_fd_sc_hd__decap_3
X_4850_ _4850_/A VGND VGND VPWR VPWR _9169_/D sky130_fd_sc_hd__buf_1
XFILLER_60_341 VGND VGND VPWR VPWR sky130_fd_sc_hd__fill_2
XFILLER_33_555 VGND VGND VPWR VPWR sky130_fd_sc_hd__decap_3
XFILLER_21_717 VGND VGND VPWR VPWR sky130_fd_sc_hd__decap_3
XFILLER_60_363 VGND VGND VPWR VPWR sky130_fd_sc_hd__fill_1
XTAP_TAPCELL_ROW_31_701 VGND VPWR sky130_fd_sc_hd__tapvpwrvgnd_1
X_4781_ _4781_/A VGND VGND VPWR VPWR _9136_/D sky130_fd_sc_hd__buf_1
X_6520_ _6523_/A _6523_/B _6266_/A VGND VGND VPWR VPWR _6520_/Y sky130_fd_sc_hd__a21oi_2
XTAP_TAPCELL_ROW_99_1622 VGND VPWR sky130_fd_sc_hd__tapvpwrvgnd_1
XFILLER_9_261 VGND VGND VPWR VPWR sky130_fd_sc_hd__decap_3
XFILLER_118_115 VGND VGND VPWR VPWR sky130_fd_sc_hd__decap_3
X_6451_ _6449_/A _6450_/Y _6106_/B VGND VGND VPWR VPWR _6451_/X sky130_fd_sc_hd__o21ba_2
Xclkload20 _9236_/CLK VGND VGND VPWR VPWR clkload20/Y sky130_fd_sc_hd__clkinv_2
XFILLER_9_294 VGND VGND VPWR VPWR sky130_fd_sc_hd__fill_2
X_5402_ _5402_/A _5495_/C VGND VGND VPWR VPWR _5403_/B sky130_fd_sc_hd__xnor2_2
Xclkload31 _9219_/CLK VGND VGND VPWR VPWR clkload31/Y sky130_fd_sc_hd__bufinv_16
X_9170_ _9296_/CLK _9170_/D fanout379/A VGND VGND VPWR VPWR _9170_/Q sky130_fd_sc_hd__dfrtp_2
X_6382_ _6382_/A _6382_/B VGND VGND VPWR VPWR _6383_/A sky130_fd_sc_hd__xnor2_4
XFILLER_127_671 VGND VGND VPWR VPWR sky130_fd_sc_hd__fill_1
XFILLER_127_682 VGND VGND VPWR VPWR sky130_fd_sc_hd__decap_3
X_8121_ _8121_/A VGND VGND VPWR VPWR _8121_/Y sky130_fd_sc_hd__inv_2
X_5333_ _5957_/A _5664_/A VGND VGND VPWR VPWR _5334_/B sky130_fd_sc_hd__xnor2_2
XFILLER_126_192 VGND VGND VPWR VPWR sky130_fd_sc_hd__decap_3
XFILLER_88_706 VGND VGND VPWR VPWR sky130_fd_sc_hd__decap_3
X_8052_ _8050_/B _8048_/Y _8051_/X _7949_/A _8222_/A VGND VGND VPWR VPWR _8052_/X
+ sky130_fd_sc_hd__a221o_2
XFILLER_125_18 VGND VGND VPWR VPWR sky130_fd_sc_hd__decap_3
XFILLER_114_365 VGND VGND VPWR VPWR sky130_fd_sc_hd__decap_3
XFILLER_102_516 VGND VGND VPWR VPWR sky130_fd_sc_hd__decap_3
X_5264_ _9339_/Q _5002_/X _5261_/X _5262_/X _5263_/X VGND VGND VPWR VPWR _5271_/B
+ sky130_fd_sc_hd__a2111o_2
X_7003_ _6730_/A _6730_/C _7002_/Y VGND VGND VPWR VPWR _7003_/X sky130_fd_sc_hd__a21o_2
XFILLER_114_398 VGND VGND VPWR VPWR sky130_fd_sc_hd__decap_3
XFILLER_102_549 VGND VGND VPWR VPWR sky130_fd_sc_hd__decap_3
X_5195_ _5247_/A _5195_/B VGND VGND VPWR VPWR _5244_/A sky130_fd_sc_hd__xnor2_2
XFILLER_68_452 VGND VGND VPWR VPWR sky130_fd_sc_hd__decap_3
XTAP_TAPCELL_ROW_39_812 VGND VPWR sky130_fd_sc_hd__tapvpwrvgnd_1
XFILLER_18_27 VGND VGND VPWR VPWR sky130_fd_sc_hd__fill_1
XFILLER_95_271 VGND VGND VPWR VPWR sky130_fd_sc_hd__decap_3
XFILLER_56_636 VGND VGND VPWR VPWR sky130_fd_sc_hd__decap_3
XFILLER_55_113 VGND VGND VPWR VPWR sky130_fd_sc_hd__decap_3
X_8954_ _8954_/A VGND VGND VPWR VPWR _9318_/D sky130_fd_sc_hd__buf_1
XTAP_TAPCELL_ROW_108_1740 VGND VPWR sky130_fd_sc_hd__tapvpwrvgnd_1
X_7905_ _7916_/B _9215_/Q _7924_/A VGND VGND VPWR VPWR _7905_/X sky130_fd_sc_hd__or3b_2
XFILLER_24_500 VGND VGND VPWR VPWR sky130_fd_sc_hd__decap_3
X_8885_ _8969_/A VGND VGND VPWR VPWR _8904_/S sky130_fd_sc_hd__clkbuf_2
XFILLER_24_522 VGND VGND VPWR VPWR sky130_fd_sc_hd__decap_3
X_7836_ _7836_/A _7836_/B _7836_/C VGND VGND VPWR VPWR _7836_/X sky130_fd_sc_hd__or3_2
XFILLER_24_555 VGND VGND VPWR VPWR sky130_fd_sc_hd__decap_3
XFILLER_24_577 VGND VGND VPWR VPWR sky130_fd_sc_hd__decap_3
XFILLER_12_728 VGND VGND VPWR VPWR sky130_fd_sc_hd__decap_3
XFILLER_24_599 VGND VGND VPWR VPWR sky130_fd_sc_hd__decap_3
X_4979_ _6206_/A _5197_/A _8780_/C VGND VGND VPWR VPWR _4979_/X sky130_fd_sc_hd__a21o_2
X_7767_ _7757_/X _7766_/X _8421_/A VGND VGND VPWR VPWR _7792_/A sky130_fd_sc_hd__o21a_2
XFILLER_51_396 VGND VGND VPWR VPWR sky130_fd_sc_hd__decap_3
X_6718_ _6718_/A _6965_/B VGND VGND VPWR VPWR _6719_/A sky130_fd_sc_hd__xnor2_4
X_7698_ _7924_/A wire41/X _8045_/S VGND VGND VPWR VPWR _7698_/X sky130_fd_sc_hd__mux2_2
Xclkload3 clkload3/A VGND VGND VPWR VPWR clkload3/Y sky130_fd_sc_hd__clkinv_2
Xwire129 _5193_/B VGND VGND VPWR VPWR _7408_/A sky130_fd_sc_hd__buf_4
XFILLER_20_772 VGND VGND VPWR VPWR sky130_fd_sc_hd__decap_3
XFILLER_126_6 VGND VGND VPWR VPWR sky130_fd_sc_hd__decap_3
X_6649_ _6650_/B _6650_/C _6650_/A VGND VGND VPWR VPWR _6651_/A sky130_fd_sc_hd__o21ai_2
XFILLER_50_47 VGND VGND VPWR VPWR sky130_fd_sc_hd__decap_3
XFILLER_118_660 VGND VGND VPWR VPWR sky130_fd_sc_hd__decap_3
XTAP_TAPCELL_ROW_119_1891 VGND VPWR sky130_fd_sc_hd__tapvpwrvgnd_1
XFILLER_124_118 VGND VGND VPWR VPWR sky130_fd_sc_hd__decap_3
XFILLER_118_682 VGND VGND VPWR VPWR sky130_fd_sc_hd__decap_3
X_8319_ _8421_/A _8319_/B _8319_/C VGND VGND VPWR VPWR _8320_/B sky130_fd_sc_hd__and3_2
XFILLER_117_181 VGND VGND VPWR VPWR sky130_fd_sc_hd__decap_3
X_9299_ _9331_/CLK _9299_/D fanout389/X VGND VGND VPWR VPWR _9299_/Q sky130_fd_sc_hd__dfrtp_2
XFILLER_3_459 VGND VGND VPWR VPWR sky130_fd_sc_hd__decap_3
XFILLER_105_387 VGND VGND VPWR VPWR sky130_fd_sc_hd__decap_3
XFILLER_59_67 VGND VGND VPWR VPWR sky130_fd_sc_hd__decap_3
Xfanout240 wire243/A VGND VGND VPWR VPWR _5384_/A sky130_fd_sc_hd__buf_6
Xfanout262 _9234_/Q VGND VGND VPWR VPWR _5196_/B sky130_fd_sc_hd__dlymetal6s2s_1
XFILLER_115_51 VGND VGND VPWR VPWR sky130_fd_sc_hd__decap_3
XFILLER_93_208 VGND VGND VPWR VPWR sky130_fd_sc_hd__fill_2
XFILLER_93_219 VGND VGND VPWR VPWR sky130_fd_sc_hd__decap_3
XFILLER_47_614 VGND VGND VPWR VPWR sky130_fd_sc_hd__fill_2
XFILLER_19_305 VGND VGND VPWR VPWR sky130_fd_sc_hd__decap_3
XFILLER_75_22 VGND VGND VPWR VPWR sky130_fd_sc_hd__fill_1
XFILLER_74_400 VGND VGND VPWR VPWR sky130_fd_sc_hd__decap_3
Xfanout295 input4/X VGND VGND VPWR VPWR _7729_/C1 sky130_fd_sc_hd__clkdlybuf4s25_1
XFILLER_115_84 VGND VGND VPWR VPWR sky130_fd_sc_hd__decap_3
XFILLER_115_95 VGND VGND VPWR VPWR sky130_fd_sc_hd__decap_3
XFILLER_86_293 VGND VGND VPWR VPWR sky130_fd_sc_hd__fill_2
XFILLER_75_55 VGND VGND VPWR VPWR sky130_fd_sc_hd__fill_1
XFILLER_46_124 VGND VGND VPWR VPWR sky130_fd_sc_hd__decap_3
XTAP_TAPCELL_ROW_17_506 VGND VPWR sky130_fd_sc_hd__tapvpwrvgnd_1
XTAP_TAPCELL_ROW_83_1401 VGND VPWR sky130_fd_sc_hd__tapvpwrvgnd_1
XTAP_TAPCELL_ROW_17_517 VGND VPWR sky130_fd_sc_hd__tapvpwrvgnd_1
XFILLER_61_116 VGND VGND VPWR VPWR sky130_fd_sc_hd__decap_3
XFILLER_15_522 VGND VGND VPWR VPWR sky130_fd_sc_hd__decap_3
XFILLER_15_555 VGND VGND VPWR VPWR sky130_fd_sc_hd__decap_3
XFILLER_70_683 VGND VGND VPWR VPWR sky130_fd_sc_hd__decap_3
XFILLER_42_374 VGND VGND VPWR VPWR sky130_fd_sc_hd__decap_3
XFILLER_30_514 VGND VGND VPWR VPWR sky130_fd_sc_hd__decap_3
XFILLER_15_599 VGND VGND VPWR VPWR sky130_fd_sc_hd__decap_3
XFILLER_30_558 VGND VGND VPWR VPWR sky130_fd_sc_hd__decap_3
XFILLER_24_92 VGND VGND VPWR VPWR sky130_fd_sc_hd__decap_3
XFILLER_11_750 VGND VGND VPWR VPWR sky130_fd_sc_hd__decap_3
XFILLER_7_710 VGND VGND VPWR VPWR sky130_fd_sc_hd__decap_3
XFILLER_7_732 VGND VGND VPWR VPWR sky130_fd_sc_hd__decap_3
XFILLER_7_765 VGND VGND VPWR VPWR sky130_fd_sc_hd__decap_3
XFILLER_6_253 VGND VGND VPWR VPWR sky130_fd_sc_hd__fill_1
XFILLER_109_671 VGND VGND VPWR VPWR sky130_fd_sc_hd__fill_1
XFILLER_115_107 VGND VGND VPWR VPWR sky130_fd_sc_hd__decap_3
XFILLER_109_682 VGND VGND VPWR VPWR sky130_fd_sc_hd__decap_3
XTAP_TAPCELL_ROW_94_1552 VGND VPWR sky130_fd_sc_hd__tapvpwrvgnd_1
XFILLER_40_91 VGND VGND VPWR VPWR sky130_fd_sc_hd__decap_3
XFILLER_41_6 VGND VGND VPWR VPWR sky130_fd_sc_hd__decap_3
XFILLER_97_503 VGND VGND VPWR VPWR sky130_fd_sc_hd__fill_1
XFILLER_123_140 VGND VGND VPWR VPWR sky130_fd_sc_hd__decap_3
XFILLER_97_514 VGND VGND VPWR VPWR sky130_fd_sc_hd__decap_3
XFILLER_111_302 VGND VGND VPWR VPWR sky130_fd_sc_hd__decap_3
XFILLER_123_184 VGND VGND VPWR VPWR sky130_fd_sc_hd__decap_3
XFILLER_111_346 VGND VGND VPWR VPWR sky130_fd_sc_hd__decap_3
XFILLER_84_208 VGND VGND VPWR VPWR sky130_fd_sc_hd__decap_3
XFILLER_111_368 VGND VGND VPWR VPWR sky130_fd_sc_hd__decap_3
XFILLER_38_614 VGND VGND VPWR VPWR sky130_fd_sc_hd__decap_3
XFILLER_37_102 VGND VGND VPWR VPWR sky130_fd_sc_hd__decap_3
XFILLER_37_113 VGND VGND VPWR VPWR sky130_fd_sc_hd__decap_3
XFILLER_1_30 VGND VGND VPWR VPWR sky130_fd_sc_hd__decap_3
XFILLER_38_658 VGND VGND VPWR VPWR sky130_fd_sc_hd__decap_3
XFILLER_65_455 VGND VGND VPWR VPWR sky130_fd_sc_hd__decap_3
XFILLER_1_63 VGND VGND VPWR VPWR sky130_fd_sc_hd__decap_3
XFILLER_65_477 VGND VGND VPWR VPWR sky130_fd_sc_hd__decap_3
XFILLER_53_617 VGND VGND VPWR VPWR sky130_fd_sc_hd__fill_1
XFILLER_1_85 VGND VGND VPWR VPWR sky130_fd_sc_hd__decap_3
X_5951_ _6096_/B _5949_/Y _5950_/X _6825_/A VGND VGND VPWR VPWR _5952_/B sky130_fd_sc_hd__o22a_2
XFILLER_92_274 VGND VGND VPWR VPWR sky130_fd_sc_hd__fill_2
XFILLER_37_179 VGND VGND VPWR VPWR sky130_fd_sc_hd__decap_3
XFILLER_18_371 VGND VGND VPWR VPWR sky130_fd_sc_hd__decap_3
XFILLER_80_436 VGND VGND VPWR VPWR sky130_fd_sc_hd__decap_3
X_4902_ _4876_/A _4901_/Y _4878_/A hold817/X VGND VGND VPWR VPWR _4902_/X sky130_fd_sc_hd__a2bb2o_2
X_8670_ _8671_/A _8716_/B VGND VGND VPWR VPWR _8707_/A sky130_fd_sc_hd__and2_2
X_5882_ _9264_/Q _9060_/Q _6342_/B VGND VGND VPWR VPWR _5882_/X sky130_fd_sc_hd__mux2_2
XFILLER_80_469 VGND VGND VPWR VPWR sky130_fd_sc_hd__fill_2
X_4833_ _4833_/A VGND VGND VPWR VPWR _9161_/D sky130_fd_sc_hd__buf_1
X_7621_ _7621_/A _7621_/B VGND VGND VPWR VPWR _7622_/B sky130_fd_sc_hd__xnor2_2
XTAP_TAPCELL_ROW_44_870 VGND VPWR sky130_fd_sc_hd__tapvpwrvgnd_1
XTAP_TAPCELL_ROW_44_881 VGND VPWR sky130_fd_sc_hd__tapvpwrvgnd_1
XTAP_TAPCELL_ROW_103_1670 VGND VPWR sky130_fd_sc_hd__tapvpwrvgnd_1
X_7552_ _7253_/A _7253_/B _7551_/X VGND VGND VPWR VPWR _7553_/B sky130_fd_sc_hd__a21o_2
X_4764_ _4764_/A VGND VGND VPWR VPWR _9128_/D sky130_fd_sc_hd__buf_1
X_6503_ _6501_/A _6885_/B _6500_/X _6502_/X VGND VGND VPWR VPWR _6503_/X sky130_fd_sc_hd__a31o_2
X_7483_ _7643_/B _7483_/B VGND VGND VPWR VPWR _7484_/B sky130_fd_sc_hd__xnor2_2
X_4695_ _4842_/A VGND VGND VPWR VPWR _4714_/S sky130_fd_sc_hd__clkbuf_2
X_6434_ _6809_/A _6434_/B VGND VGND VPWR VPWR _6434_/Y sky130_fd_sc_hd__nor2_2
X_9222_ _9227_/CLK _9222_/D load_slew416/X VGND VGND VPWR VPWR _9222_/Q sky130_fd_sc_hd__dfrtp_2
X_9153_ _9168_/CLK _9153_/D fanout377/X VGND VGND VPWR VPWR _9153_/Q sky130_fd_sc_hd__dfrtp_2
X_6365_ _6368_/A _6368_/B VGND VGND VPWR VPWR _6529_/A sky130_fd_sc_hd__nand2_2
X_8104_ _9217_/Q _8345_/A _8104_/C VGND VGND VPWR VPWR _8104_/X sky130_fd_sc_hd__and3_2
XTAP_TAPCELL_ROW_54_1013 VGND VPWR sky130_fd_sc_hd__tapvpwrvgnd_1
X_5316_ _5538_/A _5507_/A VGND VGND VPWR VPWR _5317_/A sky130_fd_sc_hd__and2_2
X_9084_ _9133_/CLK _9084_/D fanout392/X VGND VGND VPWR VPWR _9084_/Q sky130_fd_sc_hd__dfrtp_2
X_6296_ _6296_/A _6297_/B _6296_/C VGND VGND VPWR VPWR _6325_/B sky130_fd_sc_hd__or3_4
XFILLER_88_525 VGND VGND VPWR VPWR sky130_fd_sc_hd__fill_2
XFILLER_114_184 VGND VGND VPWR VPWR sky130_fd_sc_hd__decap_3
XFILLER_102_335 VGND VGND VPWR VPWR sky130_fd_sc_hd__decap_3
X_8035_ _7877_/X _6797_/Y _8035_/S VGND VGND VPWR VPWR _8035_/X sky130_fd_sc_hd__mux2_2
X_5247_ _5247_/A _5410_/B VGND VGND VPWR VPWR _5247_/X sky130_fd_sc_hd__and2_2
XFILLER_29_37 VGND VGND VPWR VPWR sky130_fd_sc_hd__fill_2
XFILLER_130_666 VGND VGND VPWR VPWR sky130_fd_sc_hd__decap_3
XFILLER_69_761 VGND VGND VPWR VPWR sky130_fd_sc_hd__decap_3
XFILLER_130_688 VGND VGND VPWR VPWR sky130_fd_sc_hd__decap_3
XFILLER_29_614 VGND VGND VPWR VPWR sky130_fd_sc_hd__fill_2
X_5178_ _9166_/Q _4516_/A _5175_/X _5176_/X _5177_/X VGND VGND VPWR VPWR _5429_/A
+ sky130_fd_sc_hd__a2111o_2
XFILLER_56_433 VGND VGND VPWR VPWR sky130_fd_sc_hd__decap_3
XFILLER_56_477 VGND VGND VPWR VPWR sky130_fd_sc_hd__decap_3
XFILLER_28_168 VGND VGND VPWR VPWR sky130_fd_sc_hd__decap_3
XFILLER_45_36 VGND VGND VPWR VPWR sky130_fd_sc_hd__decap_3
XFILLER_44_628 VGND VGND VPWR VPWR sky130_fd_sc_hd__decap_3
X_8937_ _8937_/A VGND VGND VPWR VPWR _9310_/D sky130_fd_sc_hd__buf_1
XFILLER_71_425 VGND VGND VPWR VPWR sky130_fd_sc_hd__decap_3
XFILLER_37_691 VGND VGND VPWR VPWR sky130_fd_sc_hd__decap_3
XFILLER_71_447 VGND VGND VPWR VPWR sky130_fd_sc_hd__fill_1
XFILLER_43_149 VGND VGND VPWR VPWR sky130_fd_sc_hd__decap_3
X_8868_ _8868_/A VGND VGND VPWR VPWR _9277_/D sky130_fd_sc_hd__buf_1
XTAP_TAPCELL_ROW_65_1153 VGND VPWR sky130_fd_sc_hd__tapvpwrvgnd_1
XTAP_TAPCELL_ROW_65_1164 VGND VPWR sky130_fd_sc_hd__tapvpwrvgnd_1
XFILLER_24_363 VGND VGND VPWR VPWR sky130_fd_sc_hd__fill_1
XFILLER_24_374 VGND VGND VPWR VPWR sky130_fd_sc_hd__decap_3
X_7819_ _7951_/B _7819_/B VGND VGND VPWR VPWR _7915_/B sky130_fd_sc_hd__or2_2
XFILLER_52_694 VGND VGND VPWR VPWR sky130_fd_sc_hd__decap_3
XFILLER_24_385 VGND VGND VPWR VPWR sky130_fd_sc_hd__decap_3
X_8799_ _9245_/Q hold765/X _8799_/S VGND VGND VPWR VPWR _8799_/X sky130_fd_sc_hd__mux2_2
XFILLER_61_24 VGND VGND VPWR VPWR sky130_fd_sc_hd__decap_3
XFILLER_12_536 VGND VGND VPWR VPWR sky130_fd_sc_hd__decap_3
XFILLER_61_57 VGND VGND VPWR VPWR sky130_fd_sc_hd__decap_3
XFILLER_12_569 VGND VGND VPWR VPWR sky130_fd_sc_hd__decap_3
XFILLER_61_68 VGND VGND VPWR VPWR sky130_fd_sc_hd__decap_3
XTAP_TAPCELL_ROW_22_575 VGND VPWR sky130_fd_sc_hd__tapvpwrvgnd_1
XFILLER_20_580 VGND VGND VPWR VPWR sky130_fd_sc_hd__decap_3
XFILLER_124_3 VGND VGND VPWR VPWR sky130_fd_sc_hd__decap_3
XPHY_EDGE_ROW_89_Left_220 VGND VGND VPWR VPWR sky130_fd_sc_hd__decap_3
XFILLER_4_713 VGND VGND VPWR VPWR sky130_fd_sc_hd__decap_3
XFILLER_4_746 VGND VGND VPWR VPWR sky130_fd_sc_hd__decap_3
XFILLER_3_223 VGND VGND VPWR VPWR sky130_fd_sc_hd__fill_1
XFILLER_4_757 VGND VGND VPWR VPWR sky130_fd_sc_hd__decap_3
XFILLER_3_234 VGND VGND VPWR VPWR sky130_fd_sc_hd__decap_3
XFILLER_10_50 VGND VGND VPWR VPWR sky130_fd_sc_hd__decap_3
XFILLER_105_140 VGND VGND VPWR VPWR sky130_fd_sc_hd__decap_3
XFILLER_79_514 VGND VGND VPWR VPWR sky130_fd_sc_hd__decap_3
XFILLER_79_525 VGND VGND VPWR VPWR sky130_fd_sc_hd__fill_1
XFILLER_121_611 VGND VGND VPWR VPWR sky130_fd_sc_hd__decap_3
XFILLER_106_696 VGND VGND VPWR VPWR sky130_fd_sc_hd__decap_3
XFILLER_126_50 VGND VGND VPWR VPWR sky130_fd_sc_hd__decap_3
XFILLER_79_547 VGND VGND VPWR VPWR sky130_fd_sc_hd__decap_3
XFILLER_86_21 VGND VGND VPWR VPWR sky130_fd_sc_hd__decap_3
XFILLER_120_121 VGND VGND VPWR VPWR sky130_fd_sc_hd__decap_3
XFILLER_126_83 VGND VGND VPWR VPWR sky130_fd_sc_hd__fill_1
XFILLER_86_43 VGND VGND VPWR VPWR sky130_fd_sc_hd__fill_1
XFILLER_126_94 VGND VGND VPWR VPWR sky130_fd_sc_hd__decap_3
XFILLER_121_666 VGND VGND VPWR VPWR sky130_fd_sc_hd__decap_3
XFILLER_120_165 VGND VGND VPWR VPWR sky130_fd_sc_hd__decap_3
XFILLER_94_539 VGND VGND VPWR VPWR sky130_fd_sc_hd__decap_3
XFILLER_75_720 VGND VGND VPWR VPWR sky130_fd_sc_hd__fill_1
XFILLER_47_411 VGND VGND VPWR VPWR sky130_fd_sc_hd__decap_3
XFILLER_87_591 VGND VGND VPWR VPWR sky130_fd_sc_hd__fill_2
XFILLER_19_113 VGND VGND VPWR VPWR sky130_fd_sc_hd__decap_3
XFILLER_101_390 VGND VGND VPWR VPWR sky130_fd_sc_hd__fill_2
XFILLER_19_70 VGND VGND VPWR VPWR sky130_fd_sc_hd__decap_3
XFILLER_90_701 VGND VGND VPWR VPWR sky130_fd_sc_hd__decap_3
XFILLER_47_477 VGND VGND VPWR VPWR sky130_fd_sc_hd__decap_3
XFILLER_35_617 VGND VGND VPWR VPWR sky130_fd_sc_hd__decap_3
XFILLER_34_105 VGND VGND VPWR VPWR sky130_fd_sc_hd__fill_2
XFILLER_34_116 VGND VGND VPWR VPWR sky130_fd_sc_hd__decap_3
XFILLER_62_436 VGND VGND VPWR VPWR sky130_fd_sc_hd__decap_3
XFILLER_62_469 VGND VGND VPWR VPWR sky130_fd_sc_hd__decap_3
XFILLER_50_609 VGND VGND VPWR VPWR sky130_fd_sc_hd__decap_3
XFILLER_43_650 VGND VGND VPWR VPWR sky130_fd_sc_hd__decap_3
XFILLER_43_694 VGND VGND VPWR VPWR sky130_fd_sc_hd__decap_3
XFILLER_15_396 VGND VGND VPWR VPWR sky130_fd_sc_hd__decap_3
XTAP_TAPCELL_ROW_41_840 VGND VPWR sky130_fd_sc_hd__tapvpwrvgnd_1
XFILLER_89_6 VGND VGND VPWR VPWR sky130_fd_sc_hd__decap_3
XFILLER_30_344 VGND VGND VPWR VPWR sky130_fd_sc_hd__decap_3
XFILLER_129_700 VGND VGND VPWR VPWR sky130_fd_sc_hd__decap_3
XFILLER_30_377 VGND VGND VPWR VPWR sky130_fd_sc_hd__decap_3
XFILLER_129_744 VGND VGND VPWR VPWR sky130_fd_sc_hd__decap_3
XFILLER_128_221 VGND VGND VPWR VPWR sky130_fd_sc_hd__decap_3
Xmax_cap204 _5220_/X VGND VGND VPWR VPWR _6077_/A sky130_fd_sc_hd__buf_2
Xmax_cap215 _5878_/B VGND VGND VPWR VPWR _5624_/B sky130_fd_sc_hd__clkbuf_2
X_6150_ _6522_/A VGND VGND VPWR VPWR _6265_/A sky130_fd_sc_hd__inv_2
X_5101_ _5530_/S _5101_/B VGND VGND VPWR VPWR _5101_/Y sky130_fd_sc_hd__nor2_2
XFILLER_124_493 VGND VGND VPWR VPWR sky130_fd_sc_hd__fill_1
X_6081_ _6083_/B _6091_/A _6079_/Y _6080_/Y _5228_/Y VGND VGND VPWR VPWR _6081_/X
+ sky130_fd_sc_hd__o32a_2
XFILLER_97_377 VGND VGND VPWR VPWR sky130_fd_sc_hd__decap_3
X_5032_ _5934_/A _6395_/A VGND VGND VPWR VPWR _5034_/A sky130_fd_sc_hd__nor2_2
XFILLER_85_528 VGND VGND VPWR VPWR sky130_fd_sc_hd__decap_3
XFILLER_57_219 VGND VGND VPWR VPWR sky130_fd_sc_hd__decap_3
Xhold1218 _8839_/X VGND VGND VPWR VPWR _8840_/A sky130_fd_sc_hd__dlygate4sd3_1
Xhold1229 _8810_/X VGND VGND VPWR VPWR _8811_/A sky130_fd_sc_hd__dlygate4sd3_1
XFILLER_66_720 VGND VGND VPWR VPWR sky130_fd_sc_hd__decap_3
XFILLER_38_411 VGND VGND VPWR VPWR sky130_fd_sc_hd__decap_3
XFILLER_66_731 VGND VGND VPWR VPWR sky130_fd_sc_hd__decap_3
XTAP_TAPCELL_ROW_49_940 VGND VPWR sky130_fd_sc_hd__tapvpwrvgnd_1
XFILLER_38_444 VGND VGND VPWR VPWR sky130_fd_sc_hd__fill_1
XFILLER_93_561 VGND VGND VPWR VPWR sky130_fd_sc_hd__decap_3
XFILLER_81_701 VGND VGND VPWR VPWR sky130_fd_sc_hd__decap_3
XFILLER_66_775 VGND VGND VPWR VPWR sky130_fd_sc_hd__fill_2
XFILLER_65_263 VGND VGND VPWR VPWR sky130_fd_sc_hd__decap_3
XFILLER_80_200 VGND VGND VPWR VPWR sky130_fd_sc_hd__decap_3
XFILLER_53_425 VGND VGND VPWR VPWR sky130_fd_sc_hd__fill_1
XFILLER_25_116 VGND VGND VPWR VPWR sky130_fd_sc_hd__decap_3
X_6983_ _6951_/X _6956_/X _6981_/X _6982_/Y VGND VGND VPWR VPWR _6985_/A sky130_fd_sc_hd__o211ai_2
XFILLER_65_296 VGND VGND VPWR VPWR sky130_fd_sc_hd__decap_3
X_8722_ _8707_/A _8721_/B _8721_/X _8718_/A VGND VGND VPWR VPWR _8722_/X sky130_fd_sc_hd__o22a_2
X_5934_ _5934_/A _5949_/B VGND VGND VPWR VPWR _5935_/A sky130_fd_sc_hd__and2_2
XFILLER_34_661 VGND VGND VPWR VPWR sky130_fd_sc_hd__fill_2
XFILLER_80_277 VGND VGND VPWR VPWR sky130_fd_sc_hd__decap_3
X_5865_ _5726_/A _5861_/Y _5864_/X _5725_/A VGND VGND VPWR VPWR _5904_/B sky130_fd_sc_hd__a211o_4
X_8653_ _8697_/C _8695_/B _8690_/A VGND VGND VPWR VPWR _8653_/X sky130_fd_sc_hd__mux2_2
XFILLER_34_694 VGND VGND VPWR VPWR sky130_fd_sc_hd__decap_3
X_4816_ _4816_/A VGND VGND VPWR VPWR _9153_/D sky130_fd_sc_hd__buf_1
X_7604_ _7604_/A VGND VGND VPWR VPWR _7946_/A sky130_fd_sc_hd__clkbuf_1
X_5796_ _5796_/A VGND VGND VPWR VPWR _5923_/S sky130_fd_sc_hd__inv_2
X_8584_ _8572_/A _8585_/A _8572_/B VGND VGND VPWR VPWR _8587_/A sky130_fd_sc_hd__o21ai_2
Xrebuffer604 _6506_/Y VGND VGND VPWR VPWR _6786_/A sky130_fd_sc_hd__buf_2
XFILLER_21_388 VGND VGND VPWR VPWR sky130_fd_sc_hd__decap_3
X_4747_ _4747_/A VGND VGND VPWR VPWR _9120_/D sky130_fd_sc_hd__buf_1
X_7535_ _7534_/A _5786_/Y _7534_/Y VGND VGND VPWR VPWR _7536_/B sky130_fd_sc_hd__o21a_2
XFILLER_31_38 VGND VGND VPWR VPWR sky130_fd_sc_hd__decap_3
XTAP_TAPCELL_ROW_60_1094 VGND VPWR sky130_fd_sc_hd__tapvpwrvgnd_1
XFILLER_107_416 VGND VGND VPWR VPWR sky130_fd_sc_hd__decap_3
X_7466_ _7488_/A _7488_/B VGND VGND VPWR VPWR _7466_/Y sky130_fd_sc_hd__nor2_2
XFILLER_119_276 VGND VGND VPWR VPWR sky130_fd_sc_hd__decap_3
X_4678_ _4678_/A VGND VGND VPWR VPWR _9087_/D sky130_fd_sc_hd__buf_1
XFILLER_110_9 VGND VGND VPWR VPWR sky130_fd_sc_hd__decap_3
X_6417_ _5950_/B _6416_/X _5317_/A VGND VGND VPWR VPWR _6418_/B sky130_fd_sc_hd__a21oi_4
X_9205_ _9209_/CLK _9205_/D fanout415/A VGND VGND VPWR VPWR _9205_/Q sky130_fd_sc_hd__dfrtp_2
XTAP_TAPCELL_ROW_116_1850 VGND VPWR sky130_fd_sc_hd__tapvpwrvgnd_1
X_7397_ _7372_/A _7355_/A _7355_/B _7372_/B VGND VGND VPWR VPWR _7397_/X sky130_fd_sc_hd__a31o_2
Xoutput27 _9181_/Q VGND VGND VPWR VPWR wire227/A sky130_fd_sc_hd__buf_1
X_6348_ _9208_/Q _6244_/C _6619_/B VGND VGND VPWR VPWR _6349_/B sky130_fd_sc_hd__a21oi_2
X_9136_ _9168_/CLK _9136_/D load_slew378/X VGND VGND VPWR VPWR _9136_/Q sky130_fd_sc_hd__dfrtp_2
XFILLER_1_727 VGND VGND VPWR VPWR sky130_fd_sc_hd__fill_1
XFILLER_0_215 VGND VGND VPWR VPWR sky130_fd_sc_hd__decap_3
XFILLER_1_738 VGND VGND VPWR VPWR sky130_fd_sc_hd__decap_3
XFILLER_0_237 VGND VGND VPWR VPWR sky130_fd_sc_hd__decap_3
XFILLER_103_655 VGND VGND VPWR VPWR sky130_fd_sc_hd__decap_3
X_9067_ _9236_/CLK _9067_/D fanout398/X VGND VGND VPWR VPWR _9067_/Q sky130_fd_sc_hd__dfrtp_2
XFILLER_102_132 VGND VGND VPWR VPWR sky130_fd_sc_hd__decap_3
X_6279_ _6279_/A _6279_/B _6279_/C _7430_/A VGND VGND VPWR VPWR _6279_/X sky130_fd_sc_hd__or4_4
XFILLER_0_259 VGND VGND VPWR VPWR sky130_fd_sc_hd__decap_3
X_8018_ _8018_/A VGND VGND VPWR VPWR _8018_/Y sky130_fd_sc_hd__inv_2
XFILLER_76_539 VGND VGND VPWR VPWR sky130_fd_sc_hd__fill_1
XFILLER_102_187 VGND VGND VPWR VPWR sky130_fd_sc_hd__fill_1
XFILLER_56_35 VGND VGND VPWR VPWR sky130_fd_sc_hd__decap_3
XFILLER_29_444 VGND VGND VPWR VPWR sky130_fd_sc_hd__decap_3
XFILLER_29_455 VGND VGND VPWR VPWR sky130_fd_sc_hd__decap_3
XFILLER_72_701 VGND VGND VPWR VPWR sky130_fd_sc_hd__fill_1
XFILLER_17_617 VGND VGND VPWR VPWR sky130_fd_sc_hd__decap_3
XFILLER_56_274 VGND VGND VPWR VPWR sky130_fd_sc_hd__fill_2
XFILLER_44_414 VGND VGND VPWR VPWR sky130_fd_sc_hd__decap_3
XFILLER_17_639 VGND VGND VPWR VPWR sky130_fd_sc_hd__decap_3
XFILLER_112_41 VGND VGND VPWR VPWR sky130_fd_sc_hd__decap_3
XTAP_TAPCELL_ROW_127_1990 VGND VPWR sky130_fd_sc_hd__tapvpwrvgnd_1
XTAP_TAPCELL_ROW_27_645 VGND VPWR sky130_fd_sc_hd__tapvpwrvgnd_1
XFILLER_72_767 VGND VGND VPWR VPWR sky130_fd_sc_hd__decap_3
XFILLER_71_244 VGND VGND VPWR VPWR sky130_fd_sc_hd__decap_3
XFILLER_32_609 VGND VGND VPWR VPWR sky130_fd_sc_hd__decap_3
XFILLER_112_85 VGND VGND VPWR VPWR sky130_fd_sc_hd__decap_3
XFILLER_72_56 VGND VGND VPWR VPWR sky130_fd_sc_hd__decap_3
XFILLER_52_480 VGND VGND VPWR VPWR sky130_fd_sc_hd__decap_3
XFILLER_72_78 VGND VGND VPWR VPWR sky130_fd_sc_hd__decap_3
XFILLER_40_631 VGND VGND VPWR VPWR sky130_fd_sc_hd__decap_3
XFILLER_8_304 VGND VGND VPWR VPWR sky130_fd_sc_hd__decap_3
XFILLER_12_377 VGND VGND VPWR VPWR sky130_fd_sc_hd__decap_3
XFILLER_8_337 VGND VGND VPWR VPWR sky130_fd_sc_hd__decap_3
XFILLER_8_359 VGND VGND VPWR VPWR sky130_fd_sc_hd__decap_3
XTAP_TAPCELL_ROW_78_1333 VGND VPWR sky130_fd_sc_hd__tapvpwrvgnd_1
XFILLER_126_725 VGND VGND VPWR VPWR sky130_fd_sc_hd__decap_3
XFILLER_125_202 VGND VGND VPWR VPWR sky130_fd_sc_hd__decap_3
XFILLER_4_510 VGND VGND VPWR VPWR sky130_fd_sc_hd__decap_3
XFILLER_126_769 VGND VGND VPWR VPWR sky130_fd_sc_hd__decap_3
XFILLER_125_246 VGND VGND VPWR VPWR sky130_fd_sc_hd__decap_3
XTAP_TAPCELL_ROW_91_1511 VGND VPWR sky130_fd_sc_hd__tapvpwrvgnd_1
XFILLER_4_565 VGND VGND VPWR VPWR sky130_fd_sc_hd__decap_3
XFILLER_113_408 VGND VGND VPWR VPWR sky130_fd_sc_hd__decap_3
XFILLER_125_279 VGND VGND VPWR VPWR sky130_fd_sc_hd__fill_1
XFILLER_106_460 VGND VGND VPWR VPWR sky130_fd_sc_hd__decap_3
XFILLER_121_430 VGND VGND VPWR VPWR sky130_fd_sc_hd__decap_3
XFILLER_97_97 VGND VGND VPWR VPWR sky130_fd_sc_hd__decap_3
XFILLER_0_760 VGND VGND VPWR VPWR sky130_fd_sc_hd__decap_3
XTAP_TAPCELL_ROW_7_370 VGND VPWR sky130_fd_sc_hd__tapvpwrvgnd_1
XFILLER_79_377 VGND VGND VPWR VPWR sky130_fd_sc_hd__decap_3
XFILLER_121_463 VGND VGND VPWR VPWR sky130_fd_sc_hd__decap_3
XTAP_TAPCELL_ROW_7_381 VGND VPWR sky130_fd_sc_hd__tapvpwrvgnd_1
XFILLER_121_496 VGND VGND VPWR VPWR sky130_fd_sc_hd__decap_3
XFILLER_75_561 VGND VGND VPWR VPWR sky130_fd_sc_hd__decap_3
XFILLER_47_252 VGND VGND VPWR VPWR sky130_fd_sc_hd__fill_1
XFILLER_63_723 VGND VGND VPWR VPWR sky130_fd_sc_hd__decap_3
XFILLER_35_414 VGND VGND VPWR VPWR sky130_fd_sc_hd__decap_3
XTAP_TAPCELL_ROW_89_1484 VGND VPWR sky130_fd_sc_hd__tapvpwrvgnd_1
XFILLER_75_594 VGND VGND VPWR VPWR sky130_fd_sc_hd__decap_3
XFILLER_35_447 VGND VGND VPWR VPWR sky130_fd_sc_hd__fill_1
XFILLER_90_553 VGND VGND VPWR VPWR sky130_fd_sc_hd__decap_3
Xmax_cap80 _7784_/B VGND VGND VPWR VPWR _8322_/A sky130_fd_sc_hd__buf_4
XFILLER_62_277 VGND VGND VPWR VPWR sky130_fd_sc_hd__fill_2
XFILLER_62_288 VGND VGND VPWR VPWR sky130_fd_sc_hd__decap_3
XFILLER_31_620 VGND VGND VPWR VPWR sky130_fd_sc_hd__fill_2
XFILLER_15_193 VGND VGND VPWR VPWR sky130_fd_sc_hd__decap_3
X_5650_ _5649_/A _5648_/B _5649_/Y _6270_/S VGND VGND VPWR VPWR _5650_/X sky130_fd_sc_hd__o211a_2
Xclkbuf_0_clk clk VGND VGND VPWR VPWR clkbuf_0_clk/X sky130_fd_sc_hd__clkbuf_16
XFILLER_31_653 VGND VGND VPWR VPWR sky130_fd_sc_hd__decap_3
XFILLER_87_3 VGND VGND VPWR VPWR sky130_fd_sc_hd__decap_3
X_4601_ _4601_/A VGND VGND VPWR VPWR _9051_/D sky130_fd_sc_hd__buf_1
X_5581_ _6206_/A _8780_/D _4916_/B _6206_/C VGND VGND VPWR VPWR _5588_/C sky130_fd_sc_hd__o211a_2
X_7320_ _7310_/X _7315_/X _7319_/X _6951_/X VGND VGND VPWR VPWR _7462_/A sky130_fd_sc_hd__a31o_4
X_4532_ hold997/X _4532_/A1 _4544_/S VGND VGND VPWR VPWR _4533_/A sky130_fd_sc_hd__mux2_2
XFILLER_7_51 VGND VGND VPWR VPWR sky130_fd_sc_hd__decap_3
XFILLER_129_585 VGND VGND VPWR VPWR sky130_fd_sc_hd__decap_3
XFILLER_116_213 VGND VGND VPWR VPWR sky130_fd_sc_hd__fill_1
XFILLER_117_747 VGND VGND VPWR VPWR sky130_fd_sc_hd__decap_3
X_7251_ _7553_/A VGND VGND VPWR VPWR _7251_/Y sky130_fd_sc_hd__inv_2
XFILLER_116_235 VGND VGND VPWR VPWR sky130_fd_sc_hd__decap_3
X_7182_ _7182_/A1 _6418_/A _7180_/X _5949_/A _7181_/Y VGND VGND VPWR VPWR _7183_/B
+ sky130_fd_sc_hd__o221a_2
XPHY_EDGE_ROW_15_Right_15 VGND VGND VPWR VPWR sky130_fd_sc_hd__decap_3
XFILLER_98_620 VGND VGND VPWR VPWR sky130_fd_sc_hd__decap_3
X_6133_ _6131_/A _6798_/S _6130_/X _6132_/X VGND VGND VPWR VPWR _6133_/X sky130_fd_sc_hd__a31o_2
Xload_slew251 fanout249/X VGND VGND VPWR VPWR _4991_/C sky130_fd_sc_hd__buf_8
X_6064_ _6064_/A1 _5902_/Y _6063_/Y _6061_/X VGND VGND VPWR VPWR _6065_/B sky130_fd_sc_hd__o211a_4
Xhold1004 _4608_/X VGND VGND VPWR VPWR _4609_/A sky130_fd_sc_hd__dlygate4sd3_1
XTAP_TAPCELL_ROW_111_1780 VGND VPWR sky130_fd_sc_hd__tapvpwrvgnd_1
XFILLER_100_636 VGND VGND VPWR VPWR sky130_fd_sc_hd__decap_3
Xhold1015 _9062_/Q VGND VGND VPWR VPWR _4658_/A1 sky130_fd_sc_hd__dlygate4sd3_1
Xload_slew284 _7893_/A VGND VGND VPWR VPWR _8011_/C sky130_fd_sc_hd__clkbuf_4
Xhold1026 _4803_/X VGND VGND VPWR VPWR _4804_/A sky130_fd_sc_hd__dlygate4sd3_1
XFILLER_100_658 VGND VGND VPWR VPWR sky130_fd_sc_hd__decap_3
X_5015_ _5016_/B _5043_/B VGND VGND VPWR VPWR _5042_/A sky130_fd_sc_hd__nor2_2
Xhold1037 _9270_/Q VGND VGND VPWR VPWR _8886_/A1 sky130_fd_sc_hd__dlygate4sd3_1
Xhold1048 _4615_/X VGND VGND VPWR VPWR _4616_/A sky130_fd_sc_hd__dlygate4sd3_1
Xhold1059 _8959_/X VGND VGND VPWR VPWR _8960_/A sky130_fd_sc_hd__dlygate4sd3_1
XFILLER_66_550 VGND VGND VPWR VPWR sky130_fd_sc_hd__fill_2
XFILLER_39_775 VGND VGND VPWR VPWR sky130_fd_sc_hd__fill_2
XFILLER_38_263 VGND VGND VPWR VPWR sky130_fd_sc_hd__fill_2
XFILLER_81_520 VGND VGND VPWR VPWR sky130_fd_sc_hd__decap_3
XFILLER_26_27 VGND VGND VPWR VPWR sky130_fd_sc_hd__fill_1
XFILLER_81_531 VGND VGND VPWR VPWR sky130_fd_sc_hd__decap_3
XFILLER_53_222 VGND VGND VPWR VPWR sky130_fd_sc_hd__fill_2
XFILLER_38_296 VGND VGND VPWR VPWR sky130_fd_sc_hd__decap_3
XFILLER_26_436 VGND VGND VPWR VPWR sky130_fd_sc_hd__fill_1
XFILLER_26_447 VGND VGND VPWR VPWR sky130_fd_sc_hd__decap_3
XFILLER_54_767 VGND VGND VPWR VPWR sky130_fd_sc_hd__decap_3
XPHY_EDGE_ROW_24_Right_24 VGND VGND VPWR VPWR sky130_fd_sc_hd__decap_3
XFILLER_81_564 VGND VGND VPWR VPWR sky130_fd_sc_hd__decap_3
X_6966_ _6965_/A _6965_/B _6718_/A VGND VGND VPWR VPWR _7058_/C sky130_fd_sc_hd__a21o_2
XTAP_TAPCELL_ROW_24_604 VGND VPWR sky130_fd_sc_hd__tapvpwrvgnd_1
X_8705_ _8706_/C _8684_/B _8706_/A VGND VGND VPWR VPWR _8705_/X sky130_fd_sc_hd__mux2_4
X_5917_ _5811_/Y _5685_/X _5813_/A VGND VGND VPWR VPWR _5967_/A sky130_fd_sc_hd__o21ai_4
XTAP_TAPCELL_ROW_62_1112 VGND VPWR sky130_fd_sc_hd__tapvpwrvgnd_1
XTAP_TAPCELL_ROW_62_1123 VGND VPWR sky130_fd_sc_hd__tapvpwrvgnd_1
XFILLER_34_480 VGND VGND VPWR VPWR sky130_fd_sc_hd__decap_3
X_6897_ _6894_/Y _6899_/B _6895_/X _6899_/A _7149_/B2 VGND VGND VPWR VPWR _6897_/X
+ sky130_fd_sc_hd__o221a_2
XFILLER_22_631 VGND VGND VPWR VPWR sky130_fd_sc_hd__decap_3
XTAP_TAPCELL_ROW_52_979 VGND VPWR sky130_fd_sc_hd__tapvpwrvgnd_1
X_8636_ _8636_/A _8636_/B VGND VGND VPWR VPWR _8636_/X sky130_fd_sc_hd__or2_2
X_5848_ _5137_/X _5138_/X _7952_/A VGND VGND VPWR VPWR _5849_/B sky130_fd_sc_hd__a21oi_2
XFILLER_22_697 VGND VGND VPWR VPWR sky130_fd_sc_hd__decap_3
X_8567_ _8562_/A _8560_/A wire71/X VGND VGND VPWR VPWR _8567_/Y sky130_fd_sc_hd__a21oi_2
X_5779_ _5780_/A _5780_/B VGND VGND VPWR VPWR _5779_/Y sky130_fd_sc_hd__nand2_2
Xrebuffer423 _6362_/A VGND VGND VPWR VPWR _6526_/B sky130_fd_sc_hd__buf_2
Xrebuffer434 _5483_/A3 VGND VGND VPWR VPWR _5689_/C sky130_fd_sc_hd__buf_2
Xrebuffer445 _6517_/X VGND VGND VPWR VPWR _6525_/B sky130_fd_sc_hd__buf_4
X_7518_ _7661_/A _7659_/B _7518_/C VGND VGND VPWR VPWR _7518_/Y sky130_fd_sc_hd__nand3_2
Xrebuffer456 _4515_/A VGND VGND VPWR VPWR _5709_/A sky130_fd_sc_hd__buf_2
X_8498_ _7799_/A _8496_/X _8497_/X VGND VGND VPWR VPWR _8515_/B sky130_fd_sc_hd__o21ba_2
Xrebuffer467 _5010_/X VGND VGND VPWR VPWR _5720_/A1 sky130_fd_sc_hd__buf_6
Xrebuffer478 rebuffer499/X VGND VGND VPWR VPWR _6211_/A sky130_fd_sc_hd__buf_6
Xrebuffer489 _7303_/B VGND VGND VPWR VPWR _7055_/A sky130_fd_sc_hd__buf_2
X_7449_ _7449_/A _7449_/B VGND VGND VPWR VPWR _7454_/A sky130_fd_sc_hd__xnor2_2
XPHY_EDGE_ROW_33_Right_33 VGND VGND VPWR VPWR sky130_fd_sc_hd__decap_3
Xhold860 _9099_/Q VGND VGND VPWR VPWR hold860/X sky130_fd_sc_hd__dlygate4sd3_1
XFILLER_89_620 VGND VGND VPWR VPWR sky130_fd_sc_hd__decap_3
XFILLER_122_227 VGND VGND VPWR VPWR sky130_fd_sc_hd__fill_2
XFILLER_107_30 VGND VGND VPWR VPWR sky130_fd_sc_hd__decap_3
Xhold871 _4638_/X VGND VGND VPWR VPWR _4639_/A sky130_fd_sc_hd__dlygate4sd3_1
XFILLER_1_524 VGND VGND VPWR VPWR sky130_fd_sc_hd__fill_1
Xhold882 _9100_/Q VGND VGND VPWR VPWR hold882/X sky130_fd_sc_hd__dlygate4sd3_1
Xhold893 _4675_/X VGND VGND VPWR VPWR _4676_/A sky130_fd_sc_hd__dlygate4sd3_1
XFILLER_89_642 VGND VGND VPWR VPWR sky130_fd_sc_hd__decap_3
XFILLER_122_249 VGND VGND VPWR VPWR sky130_fd_sc_hd__decap_3
XFILLER_103_430 VGND VGND VPWR VPWR sky130_fd_sc_hd__decap_3
X_9119_ _9135_/CLK _9119_/D load_slew384/X VGND VGND VPWR VPWR _9119_/Q sky130_fd_sc_hd__dfrtp_2
XTAP_TAPCELL_ROW_73_1263 VGND VPWR sky130_fd_sc_hd__tapvpwrvgnd_1
XFILLER_88_141 VGND VGND VPWR VPWR sky130_fd_sc_hd__fill_1
XFILLER_1_557 VGND VGND VPWR VPWR sky130_fd_sc_hd__decap_3
XFILLER_103_452 VGND VGND VPWR VPWR sky130_fd_sc_hd__decap_3
XFILLER_49_517 VGND VGND VPWR VPWR sky130_fd_sc_hd__decap_3
XFILLER_107_96 VGND VGND VPWR VPWR sky130_fd_sc_hd__decap_3
XFILLER_89_697 VGND VGND VPWR VPWR sky130_fd_sc_hd__decap_3
XFILLER_130_271 VGND VGND VPWR VPWR sky130_fd_sc_hd__decap_3
XTAP_TAPCELL_ROW_4_340 VGND VPWR sky130_fd_sc_hd__tapvpwrvgnd_1
XFILLER_123_51 VGND VGND VPWR VPWR sky130_fd_sc_hd__decap_3
XFILLER_44_200 VGND VGND VPWR VPWR sky130_fd_sc_hd__decap_3
XFILLER_17_414 VGND VGND VPWR VPWR sky130_fd_sc_hd__decap_3
XPHY_EDGE_ROW_42_Right_42 VGND VGND VPWR VPWR sky130_fd_sc_hd__decap_3
XFILLER_17_436 VGND VGND VPWR VPWR sky130_fd_sc_hd__decap_3
XFILLER_123_84 VGND VGND VPWR VPWR sky130_fd_sc_hd__decap_3
XFILLER_72_531 VGND VGND VPWR VPWR sky130_fd_sc_hd__fill_1
XFILLER_44_233 VGND VGND VPWR VPWR sky130_fd_sc_hd__decap_3
XFILLER_17_458 VGND VGND VPWR VPWR sky130_fd_sc_hd__decap_3
XFILLER_60_704 VGND VGND VPWR VPWR sky130_fd_sc_hd__decap_3
XFILLER_60_748 VGND VGND VPWR VPWR sky130_fd_sc_hd__decap_3
XFILLER_32_439 VGND VGND VPWR VPWR sky130_fd_sc_hd__decap_3
XFILLER_16_71 VGND VGND VPWR VPWR sky130_fd_sc_hd__decap_3
XPHY_EDGE_ROW_17_Left_148 VGND VGND VPWR VPWR sky130_fd_sc_hd__decap_3
XFILLER_13_664 VGND VGND VPWR VPWR sky130_fd_sc_hd__decap_3
XFILLER_8_101 VGND VGND VPWR VPWR sky130_fd_sc_hd__fill_1
XFILLER_9_646 VGND VGND VPWR VPWR sky130_fd_sc_hd__decap_3
XFILLER_13_697 VGND VGND VPWR VPWR sky130_fd_sc_hd__decap_3
XFILLER_12_185 VGND VGND VPWR VPWR sky130_fd_sc_hd__decap_3
XPHY_EDGE_ROW_51_Right_51 VGND VGND VPWR VPWR sky130_fd_sc_hd__decap_3
XFILLER_126_533 VGND VGND VPWR VPWR sky130_fd_sc_hd__decap_3
XFILLER_126_555 VGND VGND VPWR VPWR sky130_fd_sc_hd__decap_3
XPHY_EDGE_ROW_26_Left_157 VGND VGND VPWR VPWR sky130_fd_sc_hd__decap_3
XFILLER_4_395 VGND VGND VPWR VPWR sky130_fd_sc_hd__fill_2
XFILLER_122_772 VGND VGND VPWR VPWR sky130_fd_sc_hd__decap_3
XFILLER_95_623 VGND VGND VPWR VPWR sky130_fd_sc_hd__decap_3
XFILLER_121_271 VGND VGND VPWR VPWR sky130_fd_sc_hd__decap_3
XFILLER_121_293 VGND VGND VPWR VPWR sky130_fd_sc_hd__decap_3
XPHY_EDGE_ROW_60_Right_60 VGND VGND VPWR VPWR sky130_fd_sc_hd__decap_3
XFILLER_82_306 VGND VGND VPWR VPWR sky130_fd_sc_hd__fill_2
XFILLER_36_712 VGND VGND VPWR VPWR sky130_fd_sc_hd__decap_3
X_6820_ _7179_/A _7176_/A _6819_/X VGND VGND VPWR VPWR _6884_/A sky130_fd_sc_hd__o21a_2
XFILLER_35_255 VGND VGND VPWR VPWR sky130_fd_sc_hd__fill_2
XFILLER_51_726 VGND VGND VPWR VPWR sky130_fd_sc_hd__fill_2
XPHY_EDGE_ROW_35_Left_166 VGND VGND VPWR VPWR sky130_fd_sc_hd__decap_3
XFILLER_63_597 VGND VGND VPWR VPWR sky130_fd_sc_hd__decap_3
XFILLER_51_748 VGND VGND VPWR VPWR sky130_fd_sc_hd__decap_3
X_6751_ _9253_/Q _6751_/A2 _6749_/X _6750_/X VGND VGND VPWR VPWR _6929_/A sky130_fd_sc_hd__a211oi_2
XFILLER_35_299 VGND VGND VPWR VPWR sky130_fd_sc_hd__decap_3
XFILLER_16_480 VGND VGND VPWR VPWR sky130_fd_sc_hd__decap_3
X_5702_ _5603_/A _5602_/B _5701_/X VGND VGND VPWR VPWR _5703_/B sky130_fd_sc_hd__a21o_2
X_6682_ _5975_/A _6996_/A2 _6992_/A VGND VGND VPWR VPWR _6683_/B sky130_fd_sc_hd__a21oi_2
XFILLER_31_461 VGND VGND VPWR VPWR sky130_fd_sc_hd__decap_3
X_8421_ _8421_/A _8421_/B VGND VGND VPWR VPWR _8421_/X sky130_fd_sc_hd__or2_2
X_5633_ _5633_/A _5633_/B VGND VGND VPWR VPWR _5634_/B sky130_fd_sc_hd__nor2_2
XFILLER_12_18 VGND VGND VPWR VPWR sky130_fd_sc_hd__decap_3
XFILLER_12_29 VGND VGND VPWR VPWR sky130_fd_sc_hd__decap_3
X_5564_ _5450_/A _5451_/A _5563_/X VGND VGND VPWR VPWR _5768_/A sky130_fd_sc_hd__o21ai_2
X_8352_ _8399_/A _8352_/B VGND VGND VPWR VPWR _8353_/B sky130_fd_sc_hd__xor2_2
XFILLER_128_18 VGND VGND VPWR VPWR sky130_fd_sc_hd__decap_3
XFILLER_128_29 VGND VGND VPWR VPWR sky130_fd_sc_hd__decap_3
X_4515_ _4515_/A _4515_/B VGND VGND VPWR VPWR _4516_/A sky130_fd_sc_hd__and2_4
X_7303_ _7303_/A _7303_/B VGND VGND VPWR VPWR _7303_/Y sky130_fd_sc_hd__nor2_4
X_8283_ _8283_/A _8283_/B _8283_/C VGND VGND VPWR VPWR _8283_/X sky130_fd_sc_hd__and3_2
XFILLER_105_706 VGND VGND VPWR VPWR sky130_fd_sc_hd__fill_1
X_5495_ _5495_/A _5495_/B _5495_/C VGND VGND VPWR VPWR _5495_/Y sky130_fd_sc_hd__nand3_2
XPHY_EDGE_ROW_103_Right_103 VGND VGND VPWR VPWR sky130_fd_sc_hd__decap_3
XPHY_EDGE_ROW_44_Left_175 VGND VGND VPWR VPWR sky130_fd_sc_hd__decap_3
X_7234_ _7183_/A _7184_/A _7183_/B VGND VGND VPWR VPWR _7234_/X sky130_fd_sc_hd__o21ba_2
X_7165_ _6891_/A _7153_/Y _7164_/X VGND VGND VPWR VPWR _7263_/A sky130_fd_sc_hd__a21o_2
XFILLER_86_601 VGND VGND VPWR VPWR sky130_fd_sc_hd__fill_1
XTAP_TAPCELL_ROW_129_2027 VGND VPWR sky130_fd_sc_hd__tapvpwrvgnd_1
X_6116_ _6116_/A _6116_/B VGND VGND VPWR VPWR _6440_/A sky130_fd_sc_hd__xnor2_2
XFILLER_98_483 VGND VGND VPWR VPWR sky130_fd_sc_hd__fill_2
X_7096_ _7096_/A _7311_/A VGND VGND VPWR VPWR _7096_/Y sky130_fd_sc_hd__nand2_2
XFILLER_86_634 VGND VGND VPWR VPWR sky130_fd_sc_hd__decap_3
XFILLER_58_325 VGND VGND VPWR VPWR sky130_fd_sc_hd__decap_3
XFILLER_86_645 VGND VGND VPWR VPWR sky130_fd_sc_hd__decap_3
XFILLER_58_347 VGND VGND VPWR VPWR sky130_fd_sc_hd__decap_3
XFILLER_100_455 VGND VGND VPWR VPWR sky130_fd_sc_hd__decap_3
X_6047_ _6157_/B _6161_/B VGND VGND VPWR VPWR _6049_/A sky130_fd_sc_hd__nand2_2
XFILLER_86_678 VGND VGND VPWR VPWR sky130_fd_sc_hd__decap_3
XFILLER_37_26 VGND VGND VPWR VPWR sky130_fd_sc_hd__decap_3
XFILLER_73_306 VGND VGND VPWR VPWR sky130_fd_sc_hd__fill_1
XFILLER_100_477 VGND VGND VPWR VPWR sky130_fd_sc_hd__decap_3
XFILLER_27_712 VGND VGND VPWR VPWR sky130_fd_sc_hd__decap_3
XFILLER_66_380 VGND VGND VPWR VPWR sky130_fd_sc_hd__decap_3
XFILLER_54_520 VGND VGND VPWR VPWR sky130_fd_sc_hd__decap_3
XFILLER_27_734 VGND VGND VPWR VPWR sky130_fd_sc_hd__decap_3
XFILLER_27_767 VGND VGND VPWR VPWR sky130_fd_sc_hd__decap_3
XPHY_EDGE_ROW_53_Left_184 VGND VGND VPWR VPWR sky130_fd_sc_hd__decap_3
XFILLER_54_553 VGND VGND VPWR VPWR sky130_fd_sc_hd__decap_3
XFILLER_26_244 VGND VGND VPWR VPWR sky130_fd_sc_hd__decap_3
X_7998_ _7748_/S _7853_/B _7856_/A VGND VGND VPWR VPWR _7999_/B sky130_fd_sc_hd__o21ai_2
XTAP_TAPCELL_ROW_124_1960 VGND VPWR sky130_fd_sc_hd__tapvpwrvgnd_1
XTAP_TAPCELL_ROW_37_784 VGND VPWR sky130_fd_sc_hd__tapvpwrvgnd_1
XFILLER_53_36 VGND VGND VPWR VPWR sky130_fd_sc_hd__decap_3
XFILLER_41_214 VGND VGND VPWR VPWR sky130_fd_sc_hd__decap_3
XFILLER_42_748 VGND VGND VPWR VPWR sky130_fd_sc_hd__decap_3
XFILLER_41_225 VGND VGND VPWR VPWR sky130_fd_sc_hd__decap_3
XFILLER_14_439 VGND VGND VPWR VPWR sky130_fd_sc_hd__decap_3
X_6949_ _7029_/A _7029_/B VGND VGND VPWR VPWR _6950_/B sky130_fd_sc_hd__xor2_2
XFILLER_41_247 VGND VGND VPWR VPWR sky130_fd_sc_hd__decap_3
XFILLER_22_472 VGND VGND VPWR VPWR sky130_fd_sc_hd__decap_3
XFILLER_22_483 VGND VGND VPWR VPWR sky130_fd_sc_hd__decap_3
X_8619_ _9226_/Q _8697_/C VGND VGND VPWR VPWR _8619_/Y sky130_fd_sc_hd__nor2_2
XFILLER_10_645 VGND VGND VPWR VPWR sky130_fd_sc_hd__decap_3
XFILLER_127_319 VGND VGND VPWR VPWR sky130_fd_sc_hd__decap_3
XFILLER_5_104 VGND VGND VPWR VPWR sky130_fd_sc_hd__decap_3
XFILLER_10_689 VGND VGND VPWR VPWR sky130_fd_sc_hd__decap_3
XFILLER_108_522 VGND VGND VPWR VPWR sky130_fd_sc_hd__fill_1
XFILLER_108_533 VGND VGND VPWR VPWR sky130_fd_sc_hd__decap_3
XPHY_EDGE_ROW_62_Left_193 VGND VGND VPWR VPWR sky130_fd_sc_hd__decap_3
XFILLER_5_137 VGND VGND VPWR VPWR sky130_fd_sc_hd__decap_3
XFILLER_108_577 VGND VGND VPWR VPWR sky130_fd_sc_hd__fill_2
XFILLER_123_514 VGND VGND VPWR VPWR sky130_fd_sc_hd__decap_3
XFILLER_108_599 VGND VGND VPWR VPWR sky130_fd_sc_hd__decap_3
XFILLER_118_62 VGND VGND VPWR VPWR sky130_fd_sc_hd__decap_3
XFILLER_78_44 VGND VGND VPWR VPWR sky130_fd_sc_hd__decap_3
XFILLER_123_569 VGND VGND VPWR VPWR sky130_fd_sc_hd__decap_3
XFILLER_111_709 VGND VGND VPWR VPWR sky130_fd_sc_hd__decap_3
XFILLER_89_483 VGND VGND VPWR VPWR sky130_fd_sc_hd__decap_3
XFILLER_77_623 VGND VGND VPWR VPWR sky130_fd_sc_hd__decap_3
XFILLER_103_293 VGND VGND VPWR VPWR sky130_fd_sc_hd__fill_1
XFILLER_77_667 VGND VGND VPWR VPWR sky130_fd_sc_hd__decap_3
XFILLER_76_144 VGND VGND VPWR VPWR sky130_fd_sc_hd__decap_3
XFILLER_18_701 VGND VGND VPWR VPWR sky130_fd_sc_hd__decap_3
XFILLER_64_317 VGND VGND VPWR VPWR sky130_fd_sc_hd__decap_3
XFILLER_92_648 VGND VGND VPWR VPWR sky130_fd_sc_hd__decap_3
XFILLER_18_734 VGND VGND VPWR VPWR sky130_fd_sc_hd__decap_3
XFILLER_45_531 VGND VGND VPWR VPWR sky130_fd_sc_hd__decap_3
XFILLER_17_222 VGND VGND VPWR VPWR sky130_fd_sc_hd__fill_2
XTAP_TAPCELL_ROW_86_1443 VGND VPWR sky130_fd_sc_hd__tapvpwrvgnd_1
XFILLER_45_553 VGND VGND VPWR VPWR sky130_fd_sc_hd__decap_3
XFILLER_27_70 VGND VGND VPWR VPWR sky130_fd_sc_hd__decap_3
XFILLER_33_704 VGND VGND VPWR VPWR sky130_fd_sc_hd__decap_3
XFILLER_17_255 VGND VGND VPWR VPWR sky130_fd_sc_hd__decap_3
XFILLER_72_361 VGND VGND VPWR VPWR sky130_fd_sc_hd__decap_3
XFILLER_33_726 VGND VGND VPWR VPWR sky130_fd_sc_hd__fill_2
XFILLER_32_214 VGND VGND VPWR VPWR sky130_fd_sc_hd__decap_3
XFILLER_32_247 VGND VGND VPWR VPWR sky130_fd_sc_hd__decap_3
XFILLER_60_589 VGND VGND VPWR VPWR sky130_fd_sc_hd__fill_2
XTAP_TAPCELL_ROW_15_478 VGND VPWR sky130_fd_sc_hd__tapvpwrvgnd_1
XTAP_TAPCELL_ROW_15_489 VGND VPWR sky130_fd_sc_hd__tapvpwrvgnd_1
XFILLER_13_483 VGND VGND VPWR VPWR sky130_fd_sc_hd__fill_1
XFILLER_40_280 VGND VGND VPWR VPWR sky130_fd_sc_hd__fill_1
XFILLER_71_6 VGND VGND VPWR VPWR sky130_fd_sc_hd__fill_2
XFILLER_118_319 VGND VGND VPWR VPWR sky130_fd_sc_hd__fill_1
XFILLER_126_341 VGND VGND VPWR VPWR sky130_fd_sc_hd__decap_3
XTAP_TAPCELL_ROW_97_1594 VGND VPWR sky130_fd_sc_hd__tapvpwrvgnd_1
XFILLER_114_514 VGND VGND VPWR VPWR sky130_fd_sc_hd__decap_3
XFILLER_5_671 VGND VGND VPWR VPWR sky130_fd_sc_hd__fill_1
XFILLER_126_374 VGND VGND VPWR VPWR sky130_fd_sc_hd__decap_3
X_5280_ _5280_/A _5280_/B VGND VGND VPWR VPWR _5281_/B sky130_fd_sc_hd__nor2_2
XFILLER_99_225 VGND VGND VPWR VPWR sky130_fd_sc_hd__decap_3
XFILLER_5_682 VGND VGND VPWR VPWR sky130_fd_sc_hd__decap_3
XFILLER_126_385 VGND VGND VPWR VPWR sky130_fd_sc_hd__decap_3
XFILLER_114_547 VGND VGND VPWR VPWR sky130_fd_sc_hd__decap_3
XFILLER_99_247 VGND VGND VPWR VPWR sky130_fd_sc_hd__decap_3
XFILLER_99_258 VGND VGND VPWR VPWR sky130_fd_sc_hd__decap_3
XFILLER_4_41 VGND VGND VPWR VPWR sky130_fd_sc_hd__decap_3
XFILLER_4_63 VGND VGND VPWR VPWR sky130_fd_sc_hd__decap_3
XFILLER_4_85 VGND VGND VPWR VPWR sky130_fd_sc_hd__decap_3
XFILLER_68_645 VGND VGND VPWR VPWR sky130_fd_sc_hd__decap_3
XFILLER_110_731 VGND VGND VPWR VPWR sky130_fd_sc_hd__fill_2
XFILLER_67_122 VGND VGND VPWR VPWR sky130_fd_sc_hd__fill_1
XFILLER_67_155 VGND VGND VPWR VPWR sky130_fd_sc_hd__decap_3
X_8970_ _9326_/Q _8970_/A1 _8988_/S VGND VGND VPWR VPWR _8970_/X sky130_fd_sc_hd__mux2_2
XFILLER_55_306 VGND VGND VPWR VPWR sky130_fd_sc_hd__decap_3
XFILLER_95_475 VGND VGND VPWR VPWR sky130_fd_sc_hd__decap_3
XFILLER_67_177 VGND VGND VPWR VPWR sky130_fd_sc_hd__decap_3
XFILLER_95_497 VGND VGND VPWR VPWR sky130_fd_sc_hd__fill_1
XFILLER_83_637 VGND VGND VPWR VPWR sky130_fd_sc_hd__fill_1
X_7921_ _7826_/A _7825_/B _7920_/X VGND VGND VPWR VPWR _8111_/B sky130_fd_sc_hd__o21ai_2
XFILLER_82_125 VGND VGND VPWR VPWR sky130_fd_sc_hd__decap_3
XFILLER_36_520 VGND VGND VPWR VPWR sky130_fd_sc_hd__decap_3
XFILLER_70_309 VGND VGND VPWR VPWR sky130_fd_sc_hd__decap_3
X_7852_ _7852_/A VGND VGND VPWR VPWR _9217_/D sky130_fd_sc_hd__buf_1
XFILLER_63_361 VGND VGND VPWR VPWR sky130_fd_sc_hd__decap_3
XFILLER_24_726 VGND VGND VPWR VPWR sky130_fd_sc_hd__decap_3
X_6803_ _6492_/A _6492_/B _6802_/X VGND VGND VPWR VPWR _6834_/A sky130_fd_sc_hd__o21ai_2
XFILLER_63_383 VGND VGND VPWR VPWR sky130_fd_sc_hd__decap_3
XFILLER_23_225 VGND VGND VPWR VPWR sky130_fd_sc_hd__decap_3
X_7783_ _8170_/A _7784_/B _7784_/C VGND VGND VPWR VPWR _7783_/X sky130_fd_sc_hd__a21o_2
X_4995_ _8175_/A _6206_/C _5059_/S _7794_/A VGND VGND VPWR VPWR _4995_/X sky130_fd_sc_hd__and4bb_2
XTAP_TAPCELL_ROW_34_743 VGND VPWR sky130_fd_sc_hd__tapvpwrvgnd_1
XFILLER_51_556 VGND VGND VPWR VPWR sky130_fd_sc_hd__decap_3
XFILLER_23_258 VGND VGND VPWR VPWR sky130_fd_sc_hd__fill_2
XFILLER_51_578 VGND VGND VPWR VPWR sky130_fd_sc_hd__decap_3
X_6734_ _6736_/C _7090_/A _6733_/X VGND VGND VPWR VPWR _6924_/B sky130_fd_sc_hd__a21o_4
X_6665_ _6665_/A _6665_/B VGND VGND VPWR VPWR _6670_/A sky130_fd_sc_hd__xnor2_2
X_8404_ _8335_/A _8334_/B _8403_/X VGND VGND VPWR VPWR _8435_/A sky130_fd_sc_hd__a21oi_2
X_5616_ _6342_/A _5614_/X _5615_/X VGND VGND VPWR VPWR _5616_/X sky130_fd_sc_hd__a21bo_2
X_6596_ _6676_/B _6676_/A VGND VGND VPWR VPWR _6665_/B sky130_fd_sc_hd__xnor2_4
XFILLER_129_190 VGND VGND VPWR VPWR sky130_fd_sc_hd__decap_3
X_8335_ _8335_/A _8335_/B VGND VGND VPWR VPWR _8397_/B sky130_fd_sc_hd__xnor2_2
X_5547_ _5957_/A _5664_/B VGND VGND VPWR VPWR _5548_/B sky130_fd_sc_hd__xnor2_2
XFILLER_2_118 VGND VGND VPWR VPWR sky130_fd_sc_hd__decap_3
XFILLER_117_385 VGND VGND VPWR VPWR sky130_fd_sc_hd__decap_3
X_5478_ _9202_/Q _7413_/A VGND VGND VPWR VPWR _5479_/B sky130_fd_sc_hd__nand2_2
X_8266_ _9219_/Q _9220_/Q VGND VGND VPWR VPWR _8266_/Y sky130_fd_sc_hd__nor2_2
XTAP_TAPCELL_ROW_57_1055 VGND VPWR sky130_fd_sc_hd__tapvpwrvgnd_1
XFILLER_3_9 VGND VGND VPWR VPWR sky130_fd_sc_hd__decap_3
X_7217_ _7268_/S _7217_/B VGND VGND VPWR VPWR _7217_/Y sky130_fd_sc_hd__xnor2_2
Xfanout400 fanout402/X VGND VGND VPWR VPWR fanout400/X sky130_fd_sc_hd__clkdlybuf4s25_1
X_8197_ _9218_/Q _8195_/X _8196_/X VGND VGND VPWR VPWR _8197_/X sky130_fd_sc_hd__o21a_2
XTAP_TAPCELL_ROW_70_1222 VGND VPWR sky130_fd_sc_hd__tapvpwrvgnd_1
XFILLER_59_623 VGND VGND VPWR VPWR sky130_fd_sc_hd__decap_3
XTAP_TAPCELL_ROW_70_1233 VGND VPWR sky130_fd_sc_hd__tapvpwrvgnd_1
XFILLER_120_539 VGND VGND VPWR VPWR sky130_fd_sc_hd__decap_3
X_7148_ _7148_/A _7148_/B VGND VGND VPWR VPWR _7148_/X sky130_fd_sc_hd__and2_2
XFILLER_113_580 VGND VGND VPWR VPWR sky130_fd_sc_hd__decap_3
XFILLER_86_442 VGND VGND VPWR VPWR sky130_fd_sc_hd__decap_3
XFILLER_101_753 VGND VGND VPWR VPWR sky130_fd_sc_hd__decap_3
X_7079_ _7099_/B _7311_/A VGND VGND VPWR VPWR _7094_/B sky130_fd_sc_hd__nand2_2
XFILLER_74_604 VGND VGND VPWR VPWR sky130_fd_sc_hd__decap_3
XFILLER_86_475 VGND VGND VPWR VPWR sky130_fd_sc_hd__fill_1
XFILLER_86_486 VGND VGND VPWR VPWR sky130_fd_sc_hd__decap_3
XFILLER_100_285 VGND VGND VPWR VPWR sky130_fd_sc_hd__decap_3
XFILLER_104_53 VGND VGND VPWR VPWR sky130_fd_sc_hd__fill_1
XFILLER_27_520 VGND VGND VPWR VPWR sky130_fd_sc_hd__decap_3
XFILLER_27_553 VGND VGND VPWR VPWR sky130_fd_sc_hd__decap_3
XFILLER_27_564 VGND VGND VPWR VPWR sky130_fd_sc_hd__decap_3
XFILLER_15_715 VGND VGND VPWR VPWR sky130_fd_sc_hd__decap_3
XFILLER_54_361 VGND VGND VPWR VPWR sky130_fd_sc_hd__decap_3
XFILLER_82_692 VGND VGND VPWR VPWR sky130_fd_sc_hd__fill_1
XFILLER_54_383 VGND VGND VPWR VPWR sky130_fd_sc_hd__fill_2
XFILLER_27_597 VGND VGND VPWR VPWR sky130_fd_sc_hd__decap_3
XTAP_TAPCELL_ROW_68_1195 VGND VPWR sky130_fd_sc_hd__tapvpwrvgnd_1
XFILLER_15_759 VGND VGND VPWR VPWR sky130_fd_sc_hd__decap_3
XFILLER_14_236 VGND VGND VPWR VPWR sky130_fd_sc_hd__decap_3
XFILLER_42_556 VGND VGND VPWR VPWR sky130_fd_sc_hd__decap_3
XFILLER_120_41 VGND VGND VPWR VPWR sky130_fd_sc_hd__decap_3
XFILLER_42_578 VGND VGND VPWR VPWR sky130_fd_sc_hd__decap_3
XFILLER_14_269 VGND VGND VPWR VPWR sky130_fd_sc_hd__decap_3
XFILLER_42_589 VGND VGND VPWR VPWR sky130_fd_sc_hd__decap_3
XFILLER_120_74 VGND VGND VPWR VPWR sky130_fd_sc_hd__decap_3
XFILLER_120_85 VGND VGND VPWR VPWR sky130_fd_sc_hd__decap_3
XTAP_TAPCELL_ROW_81_1373 VGND VPWR sky130_fd_sc_hd__tapvpwrvgnd_1
XTAP_TAPCELL_ROW_12_437 VGND VPWR sky130_fd_sc_hd__tapvpwrvgnd_1
XFILLER_80_67 VGND VGND VPWR VPWR sky130_fd_sc_hd__decap_3
XTAP_TAPCELL_ROW_12_448 VGND VPWR sky130_fd_sc_hd__tapvpwrvgnd_1
XFILLER_128_628 VGND VGND VPWR VPWR sky130_fd_sc_hd__decap_3
XPHY_EDGE_ROW_70_Left_201 VGND VGND VPWR VPWR sky130_fd_sc_hd__decap_3
XFILLER_127_105 VGND VGND VPWR VPWR sky130_fd_sc_hd__decap_3
XFILLER_127_116 VGND VGND VPWR VPWR sky130_fd_sc_hd__decap_3
XFILLER_6_424 VGND VGND VPWR VPWR sky130_fd_sc_hd__fill_1
XFILLER_10_475 VGND VGND VPWR VPWR sky130_fd_sc_hd__fill_1
XFILLER_10_486 VGND VGND VPWR VPWR sky130_fd_sc_hd__decap_3
XFILLER_108_330 VGND VGND VPWR VPWR sky130_fd_sc_hd__decap_3
XFILLER_13_94 VGND VGND VPWR VPWR sky130_fd_sc_hd__decap_3
XFILLER_127_149 VGND VGND VPWR VPWR sky130_fd_sc_hd__decap_3
XFILLER_89_21 VGND VGND VPWR VPWR sky130_fd_sc_hd__fill_1
XFILLER_129_72 VGND VGND VPWR VPWR sky130_fd_sc_hd__decap_3
XFILLER_108_385 VGND VGND VPWR VPWR sky130_fd_sc_hd__decap_3
XFILLER_97_707 VGND VGND VPWR VPWR sky130_fd_sc_hd__decap_3
XFILLER_123_355 VGND VGND VPWR VPWR sky130_fd_sc_hd__decap_3
XFILLER_97_729 VGND VGND VPWR VPWR sky130_fd_sc_hd__decap_3
XFILLER_96_206 VGND VGND VPWR VPWR sky130_fd_sc_hd__decap_3
XFILLER_2_663 VGND VGND VPWR VPWR sky130_fd_sc_hd__decap_3
XFILLER_111_517 VGND VGND VPWR VPWR sky130_fd_sc_hd__decap_3
XFILLER_123_388 VGND VGND VPWR VPWR sky130_fd_sc_hd__decap_3
XFILLER_104_580 VGND VGND VPWR VPWR sky130_fd_sc_hd__decap_3
XFILLER_49_111 VGND VGND VPWR VPWR sky130_fd_sc_hd__fill_1
XFILLER_2_696 VGND VGND VPWR VPWR sky130_fd_sc_hd__decap_3
XFILLER_49_122 VGND VGND VPWR VPWR sky130_fd_sc_hd__decap_3
XFILLER_77_464 VGND VGND VPWR VPWR sky130_fd_sc_hd__decap_3
XFILLER_65_626 VGND VGND VPWR VPWR sky130_fd_sc_hd__decap_3
XFILLER_49_177 VGND VGND VPWR VPWR sky130_fd_sc_hd__decap_3
XFILLER_64_114 VGND VGND VPWR VPWR sky130_fd_sc_hd__decap_3
XFILLER_37_328 VGND VGND VPWR VPWR sky130_fd_sc_hd__decap_3
XFILLER_49_199 VGND VGND VPWR VPWR sky130_fd_sc_hd__fill_1
XFILLER_18_520 VGND VGND VPWR VPWR sky130_fd_sc_hd__decap_3
XFILLER_65_659 VGND VGND VPWR VPWR sky130_fd_sc_hd__decap_3
XFILLER_80_618 VGND VGND VPWR VPWR sky130_fd_sc_hd__decap_3
XFILLER_52_309 VGND VGND VPWR VPWR sky130_fd_sc_hd__fill_1
XFILLER_33_523 VGND VGND VPWR VPWR sky130_fd_sc_hd__decap_3
XFILLER_33_567 VGND VGND VPWR VPWR sky130_fd_sc_hd__decap_3
X_4780_ _9136_/Q _4780_/A1 _4798_/S VGND VGND VPWR VPWR _4780_/X sky130_fd_sc_hd__mux2_2
XTAP_TAPCELL_ROW_31_702 VGND VPWR sky130_fd_sc_hd__tapvpwrvgnd_1
XFILLER_21_729 VGND VGND VPWR VPWR sky130_fd_sc_hd__decap_3
XPHY_EDGE_ROW_109_Left_240 VGND VGND VPWR VPWR sky130_fd_sc_hd__decap_3
XFILLER_20_228 VGND VGND VPWR VPWR sky130_fd_sc_hd__decap_3
XTAP_TAPCELL_ROW_99_1612 VGND VPWR sky130_fd_sc_hd__tapvpwrvgnd_1
XTAP_TAPCELL_ROW_99_1623 VGND VPWR sky130_fd_sc_hd__tapvpwrvgnd_1
XFILLER_119_617 VGND VGND VPWR VPWR sky130_fd_sc_hd__decap_3
XFILLER_9_251 VGND VGND VPWR VPWR sky130_fd_sc_hd__fill_2
XFILLER_119_628 VGND VGND VPWR VPWR sky130_fd_sc_hd__decap_3
X_6450_ _6470_/A _6450_/B VGND VGND VPWR VPWR _6450_/Y sky130_fd_sc_hd__nor2_2
XFILLER_9_273 VGND VGND VPWR VPWR sky130_fd_sc_hd__fill_1
XFILLER_118_127 VGND VGND VPWR VPWR sky130_fd_sc_hd__decap_3
Xclkload10 _9135_/CLK VGND VGND VPWR VPWR clkload10/X sky130_fd_sc_hd__clkbuf_4
Xclkload21 _9133_/CLK VGND VGND VPWR VPWR clkload21/X sky130_fd_sc_hd__clkbuf_4
X_5401_ _5048_/B _5400_/X _5280_/A _5281_/A VGND VGND VPWR VPWR _5495_/C sky130_fd_sc_hd__a2bb2o_2
X_6381_ _6261_/A _6220_/X _6261_/B _6380_/X _6263_/A VGND VGND VPWR VPWR _6382_/B
+ sky130_fd_sc_hd__a32o_2
XFILLER_127_650 VGND VGND VPWR VPWR sky130_fd_sc_hd__decap_3
X_5332_ _6441_/A1 _5320_/Y _5331_/X VGND VGND VPWR VPWR _5334_/A sky130_fd_sc_hd__a21o_2
X_8120_ _7902_/X _7989_/Y _8114_/B _7990_/A VGND VGND VPWR VPWR _8120_/X sky130_fd_sc_hd__a211o_2
XFILLER_127_694 VGND VGND VPWR VPWR sky130_fd_sc_hd__decap_3
XFILLER_126_171 VGND VGND VPWR VPWR sky130_fd_sc_hd__decap_3
XFILLER_114_333 VGND VGND VPWR VPWR sky130_fd_sc_hd__decap_3
X_5263_ _9275_/Q _6336_/B _5442_/B VGND VGND VPWR VPWR _5263_/X sky130_fd_sc_hd__and3_2
X_8051_ _8050_/B _8049_/Y _8050_/Y _8047_/S VGND VGND VPWR VPWR _8051_/X sky130_fd_sc_hd__o22a_2
XFILLER_88_729 VGND VGND VPWR VPWR sky130_fd_sc_hd__decap_3
XFILLER_114_377 VGND VGND VPWR VPWR sky130_fd_sc_hd__decap_3
X_7002_ _5276_/A _7071_/D _6710_/X _7002_/B1 VGND VGND VPWR VPWR _7002_/Y sky130_fd_sc_hd__a31oi_2
XFILLER_87_228 VGND VGND VPWR VPWR sky130_fd_sc_hd__decap_3
XFILLER_87_239 VGND VGND VPWR VPWR sky130_fd_sc_hd__fill_2
X_5194_ _5194_/A _5410_/A VGND VGND VPWR VPWR _5195_/B sky130_fd_sc_hd__xnor2_2
XFILLER_68_464 VGND VGND VPWR VPWR sky130_fd_sc_hd__decap_3
XTAP_TAPCELL_ROW_39_802 VGND VPWR sky130_fd_sc_hd__tapvpwrvgnd_1
XTAP_TAPCELL_ROW_39_813 VGND VPWR sky130_fd_sc_hd__tapvpwrvgnd_1
XFILLER_83_401 VGND VGND VPWR VPWR sky130_fd_sc_hd__decap_3
XFILLER_18_39 VGND VGND VPWR VPWR sky130_fd_sc_hd__decap_3
X_8953_ _9318_/Q _8953_/A1 _8967_/S VGND VGND VPWR VPWR _8953_/X sky130_fd_sc_hd__mux2_2
XTAP_TAPCELL_ROW_108_1741 VGND VPWR sky130_fd_sc_hd__tapvpwrvgnd_1
XFILLER_83_467 VGND VGND VPWR VPWR sky130_fd_sc_hd__decap_3
XFILLER_71_607 VGND VGND VPWR VPWR sky130_fd_sc_hd__decap_3
X_7904_ wire67/A VGND VGND VPWR VPWR wire61/A sky130_fd_sc_hd__clkbuf_1
XFILLER_55_169 VGND VGND VPWR VPWR sky130_fd_sc_hd__fill_1
X_8884_ _8884_/A VGND VGND VPWR VPWR _9285_/D sky130_fd_sc_hd__buf_1
XFILLER_70_106 VGND VGND VPWR VPWR sky130_fd_sc_hd__decap_3
XFILLER_64_670 VGND VGND VPWR VPWR sky130_fd_sc_hd__decap_3
X_7835_ _7840_/B _7908_/A _7831_/X VGND VGND VPWR VPWR _7835_/X sky130_fd_sc_hd__o21a_2
XFILLER_51_320 VGND VGND VPWR VPWR sky130_fd_sc_hd__decap_3
XFILLER_34_27 VGND VGND VPWR VPWR sky130_fd_sc_hd__fill_1
XFILLER_12_707 VGND VGND VPWR VPWR sky130_fd_sc_hd__decap_3
XFILLER_51_364 VGND VGND VPWR VPWR sky130_fd_sc_hd__fill_1
X_7766_ wire84/X _7759_/X _7761_/X _7765_/X VGND VGND VPWR VPWR _7766_/X sky130_fd_sc_hd__o31a_2
XFILLER_24_589 VGND VGND VPWR VPWR sky130_fd_sc_hd__decap_3
X_4978_ _5739_/S _8780_/D VGND VGND VPWR VPWR _4978_/Y sky130_fd_sc_hd__nor2_2
XFILLER_51_386 VGND VGND VPWR VPWR sky130_fd_sc_hd__decap_3
X_6717_ _6717_/A _6717_/B VGND VGND VPWR VPWR _6965_/B sky130_fd_sc_hd__nand2_4
XFILLER_20_740 VGND VGND VPWR VPWR sky130_fd_sc_hd__decap_3
X_7697_ _7697_/A _7697_/B VGND VGND VPWR VPWR wire41/A sky130_fd_sc_hd__xnor2_2
Xwire119 _6250_/B VGND VGND VPWR VPWR _5999_/B sky130_fd_sc_hd__buf_2
Xclkload4 clkload4/A VGND VGND VPWR VPWR clkload4/X sky130_fd_sc_hd__clkbuf_4
XFILLER_109_116 VGND VGND VPWR VPWR sky130_fd_sc_hd__decap_3
X_6648_ _6382_/A _6383_/B _6647_/X VGND VGND VPWR VPWR _6650_/A sky130_fd_sc_hd__o21ai_2
XFILLER_109_149 VGND VGND VPWR VPWR sky130_fd_sc_hd__decap_3
XFILLER_50_59 VGND VGND VPWR VPWR sky130_fd_sc_hd__decap_3
XFILLER_119_6 VGND VGND VPWR VPWR sky130_fd_sc_hd__decap_3
X_6579_ _6579_/A _6579_/B VGND VGND VPWR VPWR _6579_/Y sky130_fd_sc_hd__nand2_2
XTAP_TAPCELL_ROW_119_1892 VGND VPWR sky130_fd_sc_hd__tapvpwrvgnd_1
XFILLER_118_672 VGND VGND VPWR VPWR sky130_fd_sc_hd__decap_3
X_8318_ wire88/X _8408_/A _8408_/B VGND VGND VPWR VPWR _8319_/C sky130_fd_sc_hd__or3_2
XFILLER_118_694 VGND VGND VPWR VPWR sky130_fd_sc_hd__decap_3
X_9298_ _9346_/CLK _9298_/D fanout403/X VGND VGND VPWR VPWR _9298_/Q sky130_fd_sc_hd__dfrtp_2
XFILLER_3_449 VGND VGND VPWR VPWR sky130_fd_sc_hd__decap_3
XFILLER_105_333 VGND VGND VPWR VPWR sky130_fd_sc_hd__decap_3
XFILLER_1_6 VGND VGND VPWR VPWR sky130_fd_sc_hd__decap_3
X_8249_ _8427_/B _8249_/B VGND VGND VPWR VPWR _8251_/A sky130_fd_sc_hd__xor2_2
XFILLER_59_57 VGND VGND VPWR VPWR sky130_fd_sc_hd__fill_2
XFILLER_78_228 VGND VGND VPWR VPWR sky130_fd_sc_hd__fill_1
XFILLER_59_420 VGND VGND VPWR VPWR sky130_fd_sc_hd__fill_1
XFILLER_120_347 VGND VGND VPWR VPWR sky130_fd_sc_hd__fill_1
XFILLER_115_30 VGND VGND VPWR VPWR sky130_fd_sc_hd__decap_3
XFILLER_59_442 VGND VGND VPWR VPWR sky130_fd_sc_hd__decap_3
Xfanout252 _5361_/A1 VGND VGND VPWR VPWR _5143_/B sky130_fd_sc_hd__clkbuf_2
Xfanout274 hold753/X VGND VGND VPWR VPWR _5949_/B sky130_fd_sc_hd__buf_6
XFILLER_115_63 VGND VGND VPWR VPWR sky130_fd_sc_hd__decap_3
XFILLER_101_561 VGND VGND VPWR VPWR sky130_fd_sc_hd__fill_2
Xfanout285 input7/X VGND VGND VPWR VPWR _6859_/A sky130_fd_sc_hd__clkdlybuf4s25_1
XFILLER_59_475 VGND VGND VPWR VPWR sky130_fd_sc_hd__decap_3
XFILLER_19_317 VGND VGND VPWR VPWR sky130_fd_sc_hd__decap_3
XFILLER_47_637 VGND VGND VPWR VPWR sky130_fd_sc_hd__decap_3
XFILLER_101_594 VGND VGND VPWR VPWR sky130_fd_sc_hd__decap_3
XFILLER_47_659 VGND VGND VPWR VPWR sky130_fd_sc_hd__decap_3
XFILLER_74_467 VGND VGND VPWR VPWR sky130_fd_sc_hd__decap_3
XFILLER_62_618 VGND VGND VPWR VPWR sky130_fd_sc_hd__fill_1
XTAP_TAPCELL_ROW_17_507 VGND VPWR sky130_fd_sc_hd__tapvpwrvgnd_1
XTAP_TAPCELL_ROW_83_1402 VGND VPWR sky130_fd_sc_hd__tapvpwrvgnd_1
XFILLER_74_489 VGND VGND VPWR VPWR sky130_fd_sc_hd__decap_3
XFILLER_62_629 VGND VGND VPWR VPWR sky130_fd_sc_hd__fill_1
XFILLER_61_106 VGND VGND VPWR VPWR sky130_fd_sc_hd__decap_3
XFILLER_27_361 VGND VGND VPWR VPWR sky130_fd_sc_hd__decap_3
XFILLER_15_501 VGND VGND VPWR VPWR sky130_fd_sc_hd__decap_3
XFILLER_27_383 VGND VGND VPWR VPWR sky130_fd_sc_hd__decap_3
XFILLER_91_55 VGND VGND VPWR VPWR sky130_fd_sc_hd__fill_1
XFILLER_15_578 VGND VGND VPWR VPWR sky130_fd_sc_hd__decap_3
XFILLER_91_77 VGND VGND VPWR VPWR sky130_fd_sc_hd__fill_2
XFILLER_91_99 VGND VGND VPWR VPWR sky130_fd_sc_hd__decap_3
XFILLER_24_82 VGND VGND VPWR VPWR sky130_fd_sc_hd__fill_2
XFILLER_11_762 VGND VGND VPWR VPWR sky130_fd_sc_hd__decap_3
XFILLER_7_722 VGND VGND VPWR VPWR sky130_fd_sc_hd__decap_3
XFILLER_7_744 VGND VGND VPWR VPWR sky130_fd_sc_hd__decap_3
XFILLER_6_221 VGND VGND VPWR VPWR sky130_fd_sc_hd__decap_3
XFILLER_115_119 VGND VGND VPWR VPWR sky130_fd_sc_hd__decap_3
XFILLER_109_694 VGND VGND VPWR VPWR sky130_fd_sc_hd__decap_3
XTAP_TAPCELL_ROW_94_1553 VGND VPWR sky130_fd_sc_hd__tapvpwrvgnd_1
XFILLER_123_152 VGND VGND VPWR VPWR sky130_fd_sc_hd__decap_3
XFILLER_69_228 VGND VGND VPWR VPWR sky130_fd_sc_hd__fill_2
XFILLER_2_471 VGND VGND VPWR VPWR sky130_fd_sc_hd__decap_3
XFILLER_69_239 VGND VGND VPWR VPWR sky130_fd_sc_hd__decap_3
XFILLER_123_196 VGND VGND VPWR VPWR sky130_fd_sc_hd__decap_3
XFILLER_111_358 VGND VGND VPWR VPWR sky130_fd_sc_hd__fill_1
XFILLER_78_773 VGND VGND VPWR VPWR sky130_fd_sc_hd__decap_3
XFILLER_49_90 VGND VGND VPWR VPWR sky130_fd_sc_hd__decap_3
XFILLER_93_721 VGND VGND VPWR VPWR sky130_fd_sc_hd__decap_3
XFILLER_38_637 VGND VGND VPWR VPWR sky130_fd_sc_hd__decap_3
XFILLER_93_732 VGND VGND VPWR VPWR sky130_fd_sc_hd__decap_3
XFILLER_77_294 VGND VGND VPWR VPWR sky130_fd_sc_hd__decap_3
XFILLER_65_434 VGND VGND VPWR VPWR sky130_fd_sc_hd__fill_1
XFILLER_38_648 VGND VGND VPWR VPWR sky130_fd_sc_hd__decap_3
XFILLER_37_125 VGND VGND VPWR VPWR sky130_fd_sc_hd__decap_3
XFILLER_1_42 VGND VGND VPWR VPWR sky130_fd_sc_hd__decap_3
XFILLER_92_231 VGND VGND VPWR VPWR sky130_fd_sc_hd__fill_2
XFILLER_37_147 VGND VGND VPWR VPWR sky130_fd_sc_hd__decap_3
XFILLER_37_169 VGND VGND VPWR VPWR sky130_fd_sc_hd__decap_3
X_5950_ _5950_/A _5950_/B VGND VGND VPWR VPWR _5950_/X sky130_fd_sc_hd__or2_2
XFILLER_65_489 VGND VGND VPWR VPWR sky130_fd_sc_hd__decap_3
XFILLER_1_97 VGND VGND VPWR VPWR sky130_fd_sc_hd__decap_3
XFILLER_46_670 VGND VGND VPWR VPWR sky130_fd_sc_hd__decap_3
XFILLER_18_383 VGND VGND VPWR VPWR sky130_fd_sc_hd__decap_3
X_4901_ _8446_/A _4907_/B VGND VGND VPWR VPWR _4901_/Y sky130_fd_sc_hd__nor2_2
XFILLER_80_448 VGND VGND VPWR VPWR sky130_fd_sc_hd__fill_2
XFILLER_33_320 VGND VGND VPWR VPWR sky130_fd_sc_hd__fill_1
X_5881_ _9328_/Q _4992_/X _5878_/X _5879_/X _5880_/X VGND VGND VPWR VPWR _5890_/B
+ sky130_fd_sc_hd__a2111o_2
XFILLER_45_191 VGND VGND VPWR VPWR sky130_fd_sc_hd__decap_3
XFILLER_33_331 VGND VGND VPWR VPWR sky130_fd_sc_hd__decap_3
XFILLER_61_651 VGND VGND VPWR VPWR sky130_fd_sc_hd__decap_3
X_7620_ _7620_/A _7754_/A VGND VGND VPWR VPWR _7621_/B sky130_fd_sc_hd__xor2_2
XFILLER_33_364 VGND VGND VPWR VPWR sky130_fd_sc_hd__decap_3
X_4832_ _4832_/A0 _9145_/Q _4840_/S VGND VGND VPWR VPWR _4832_/X sky130_fd_sc_hd__mux2_2
XTAP_TAPCELL_ROW_44_871 VGND VPWR sky130_fd_sc_hd__tapvpwrvgnd_1
XFILLER_60_150 VGND VGND VPWR VPWR sky130_fd_sc_hd__decap_3
XTAP_TAPCELL_ROW_44_882 VGND VPWR sky130_fd_sc_hd__tapvpwrvgnd_1
XFILLER_33_386 VGND VGND VPWR VPWR sky130_fd_sc_hd__decap_3
XTAP_TAPCELL_ROW_103_1671 VGND VPWR sky130_fd_sc_hd__tapvpwrvgnd_1
XFILLER_60_183 VGND VGND VPWR VPWR sky130_fd_sc_hd__fill_1
X_7551_ _7253_/A _7253_/B _7254_/A VGND VGND VPWR VPWR _7551_/X sky130_fd_sc_hd__o21ba_2
X_4763_ hold918/X _4763_/A1 _4777_/S VGND VGND VPWR VPWR _4764_/A sky130_fd_sc_hd__mux2_2
XFILLER_119_414 VGND VGND VPWR VPWR sky130_fd_sc_hd__decap_3
X_6502_ _6504_/A2 _6501_/Y _6430_/B VGND VGND VPWR VPWR _6502_/X sky130_fd_sc_hd__o21ba_2
X_4694_ _4694_/A VGND VGND VPWR VPWR _9095_/D sky130_fd_sc_hd__buf_1
X_7482_ _8248_/B _7482_/B VGND VGND VPWR VPWR _7483_/B sky130_fd_sc_hd__nor2_2
XFILLER_119_458 VGND VGND VPWR VPWR sky130_fd_sc_hd__decap_3
X_9221_ _9223_/CLK _9221_/D input1/X VGND VGND VPWR VPWR _9221_/Q sky130_fd_sc_hd__dfrtp_2
X_6433_ _6500_/A _6433_/B VGND VGND VPWR VPWR _6497_/B sky130_fd_sc_hd__xnor2_2
XFILLER_20_18 VGND VGND VPWR VPWR sky130_fd_sc_hd__decap_3
X_9152_ _9168_/CLK _9152_/D fanout377/X VGND VGND VPWR VPWR _9152_/Q sky130_fd_sc_hd__dfrtp_2
X_6364_ _6364_/A1 _6363_/B _6363_/A VGND VGND VPWR VPWR _6374_/B sky130_fd_sc_hd__a21oi_2
XFILLER_115_631 VGND VGND VPWR VPWR sky130_fd_sc_hd__decap_3
XFILLER_115_653 VGND VGND VPWR VPWR sky130_fd_sc_hd__decap_3
X_8103_ _6749_/X _8104_/C _8271_/A VGND VGND VPWR VPWR _8103_/X sky130_fd_sc_hd__mux2_2
X_5315_ _5228_/Y _5230_/Y _5507_/A VGND VGND VPWR VPWR _5315_/X sky130_fd_sc_hd__mux2_2
XTAP_TAPCELL_ROW_54_1014 VGND VPWR sky130_fd_sc_hd__tapvpwrvgnd_1
XFILLER_0_408 VGND VGND VPWR VPWR sky130_fd_sc_hd__decap_3
X_6295_ _6297_/C _6297_/D VGND VGND VPWR VPWR _6296_/C sky130_fd_sc_hd__nand2_2
X_9083_ _9236_/CLK _9083_/D fanout398/X VGND VGND VPWR VPWR _9083_/Q sky130_fd_sc_hd__dfrtp_2
XFILLER_130_601 VGND VGND VPWR VPWR sky130_fd_sc_hd__decap_3
XFILLER_130_623 VGND VGND VPWR VPWR sky130_fd_sc_hd__decap_3
XFILLER_115_697 VGND VGND VPWR VPWR sky130_fd_sc_hd__decap_3
X_8034_ _8034_/A _8034_/B VGND VGND VPWR VPWR _8034_/Y sky130_fd_sc_hd__nand2_2
X_5246_ _5210_/B _5241_/Y _5245_/X VGND VGND VPWR VPWR _5310_/A sky130_fd_sc_hd__a21o_2
XFILLER_130_645 VGND VGND VPWR VPWR sky130_fd_sc_hd__decap_3
XFILLER_102_347 VGND VGND VPWR VPWR sky130_fd_sc_hd__fill_1
XFILLER_69_740 VGND VGND VPWR VPWR sky130_fd_sc_hd__decap_3
XPHY_EDGE_ROW_89_Right_89 VGND VGND VPWR VPWR sky130_fd_sc_hd__decap_3
XFILLER_29_49 VGND VGND VPWR VPWR sky130_fd_sc_hd__decap_3
X_5177_ _9118_/Q _5875_/B _5879_/C VGND VGND VPWR VPWR _5177_/X sky130_fd_sc_hd__and3_2
XFILLER_68_250 VGND VGND VPWR VPWR sky130_fd_sc_hd__fill_2
XFILLER_29_626 VGND VGND VPWR VPWR sky130_fd_sc_hd__decap_3
XFILLER_28_103 VGND VGND VPWR VPWR sky130_fd_sc_hd__fill_2
XFILLER_84_743 VGND VGND VPWR VPWR sky130_fd_sc_hd__fill_1
XFILLER_29_659 VGND VGND VPWR VPWR sky130_fd_sc_hd__decap_3
XFILLER_56_445 VGND VGND VPWR VPWR sky130_fd_sc_hd__fill_2
XFILLER_28_147 VGND VGND VPWR VPWR sky130_fd_sc_hd__decap_3
XFILLER_45_15 VGND VGND VPWR VPWR sky130_fd_sc_hd__decap_3
XFILLER_16_309 VGND VGND VPWR VPWR sky130_fd_sc_hd__decap_3
X_8936_ _9310_/Q hold886/X _8946_/S VGND VGND VPWR VPWR _8936_/X sky130_fd_sc_hd__mux2_2
X_8867_ hold848/X hold867/X _8883_/S VGND VGND VPWR VPWR _8868_/A sky130_fd_sc_hd__mux2_2
XFILLER_36_191 VGND VGND VPWR VPWR sky130_fd_sc_hd__decap_3
XTAP_TAPCELL_ROW_65_1154 VGND VPWR sky130_fd_sc_hd__tapvpwrvgnd_1
XFILLER_101_43 VGND VGND VPWR VPWR sky130_fd_sc_hd__decap_3
XTAP_TAPCELL_ROW_65_1165 VGND VPWR sky130_fd_sc_hd__tapvpwrvgnd_1
X_7818_ _9217_/Q VGND VGND VPWR VPWR _7916_/B sky130_fd_sc_hd__inv_2
XFILLER_52_673 VGND VGND VPWR VPWR sky130_fd_sc_hd__decap_3
X_8798_ _8798_/A VGND VGND VPWR VPWR _9244_/D sky130_fd_sc_hd__buf_1
XPHY_EDGE_ROW_98_Right_98 VGND VGND VPWR VPWR sky130_fd_sc_hd__decap_3
XFILLER_51_172 VGND VGND VPWR VPWR sky130_fd_sc_hd__decap_3
XFILLER_61_36 VGND VGND VPWR VPWR sky130_fd_sc_hd__decap_3
X_7749_ _7742_/Y _7853_/B _7748_/X VGND VGND VPWR VPWR _7750_/B sky130_fd_sc_hd__a21oi_2
XFILLER_8_508 VGND VGND VPWR VPWR sky130_fd_sc_hd__decap_3
XTAP_TAPCELL_ROW_22_576 VGND VPWR sky130_fd_sc_hd__tapvpwrvgnd_1
XFILLER_20_592 VGND VGND VPWR VPWR sky130_fd_sc_hd__fill_2
XFILLER_117_3 VGND VGND VPWR VPWR sky130_fd_sc_hd__decap_3
XFILLER_4_725 VGND VGND VPWR VPWR sky130_fd_sc_hd__decap_3
XFILLER_118_480 VGND VGND VPWR VPWR sky130_fd_sc_hd__decap_3
XFILLER_106_631 VGND VGND VPWR VPWR sky130_fd_sc_hd__decap_3
XFILLER_3_246 VGND VGND VPWR VPWR sky130_fd_sc_hd__fill_2
XFILLER_105_152 VGND VGND VPWR VPWR sky130_fd_sc_hd__decap_3
XFILLER_3_279 VGND VGND VPWR VPWR sky130_fd_sc_hd__fill_1
XFILLER_121_623 VGND VGND VPWR VPWR sky130_fd_sc_hd__decap_3
XFILLER_120_100 VGND VGND VPWR VPWR sky130_fd_sc_hd__decap_3
XFILLER_126_62 VGND VGND VPWR VPWR sky130_fd_sc_hd__decap_3
XFILLER_79_559 VGND VGND VPWR VPWR sky130_fd_sc_hd__fill_1
XFILLER_120_133 VGND VGND VPWR VPWR sky130_fd_sc_hd__decap_3
XFILLER_120_144 VGND VGND VPWR VPWR sky130_fd_sc_hd__decap_3
XFILLER_94_518 VGND VGND VPWR VPWR sky130_fd_sc_hd__decap_3
XFILLER_121_689 VGND VGND VPWR VPWR sky130_fd_sc_hd__decap_3
XFILLER_87_570 VGND VGND VPWR VPWR sky130_fd_sc_hd__decap_3
XFILLER_120_177 VGND VGND VPWR VPWR sky130_fd_sc_hd__decap_3
XFILLER_47_423 VGND VGND VPWR VPWR sky130_fd_sc_hd__fill_2
XFILLER_47_456 VGND VGND VPWR VPWR sky130_fd_sc_hd__decap_3
XFILLER_75_776 VGND VGND VPWR VPWR sky130_fd_sc_hd__fill_1
XFILLER_74_253 VGND VGND VPWR VPWR sky130_fd_sc_hd__decap_3
XFILLER_90_724 VGND VGND VPWR VPWR sky130_fd_sc_hd__decap_3
XFILLER_62_415 VGND VGND VPWR VPWR sky130_fd_sc_hd__decap_3
XFILLER_90_746 VGND VGND VPWR VPWR sky130_fd_sc_hd__decap_3
XFILLER_90_757 VGND VGND VPWR VPWR sky130_fd_sc_hd__fill_2
XFILLER_62_448 VGND VGND VPWR VPWR sky130_fd_sc_hd__decap_3
XFILLER_27_191 VGND VGND VPWR VPWR sky130_fd_sc_hd__decap_3
XFILLER_43_662 VGND VGND VPWR VPWR sky130_fd_sc_hd__decap_3
XFILLER_43_673 VGND VGND VPWR VPWR sky130_fd_sc_hd__decap_3
XFILLER_30_301 VGND VGND VPWR VPWR sky130_fd_sc_hd__fill_2
XFILLER_30_312 VGND VGND VPWR VPWR sky130_fd_sc_hd__fill_2
XTAP_TAPCELL_ROW_41_830 VGND VPWR sky130_fd_sc_hd__tapvpwrvgnd_1
XTAP_TAPCELL_ROW_41_841 VGND VPWR sky130_fd_sc_hd__tapvpwrvgnd_1
XFILLER_129_712 VGND VGND VPWR VPWR sky130_fd_sc_hd__decap_3
XFILLER_128_200 VGND VGND VPWR VPWR sky130_fd_sc_hd__decap_3
XFILLER_30_389 VGND VGND VPWR VPWR sky130_fd_sc_hd__decap_3
XFILLER_129_756 VGND VGND VPWR VPWR sky130_fd_sc_hd__decap_3
XFILLER_11_570 VGND VGND VPWR VPWR sky130_fd_sc_hd__decap_3
XFILLER_128_233 VGND VGND VPWR VPWR sky130_fd_sc_hd__decap_3
XFILLER_128_266 VGND VGND VPWR VPWR sky130_fd_sc_hd__decap_3
Xmax_cap205 _5117_/Y VGND VGND VPWR VPWR _5991_/B1 sky130_fd_sc_hd__clkbuf_2
XFILLER_7_574 VGND VGND VPWR VPWR sky130_fd_sc_hd__decap_3
Xmax_cap216 _6603_/B VGND VGND VPWR VPWR _5880_/B sky130_fd_sc_hd__buf_4
XFILLER_128_288 VGND VGND VPWR VPWR sky130_fd_sc_hd__decap_3
XFILLER_116_428 VGND VGND VPWR VPWR sky130_fd_sc_hd__decap_3
XFILLER_7_596 VGND VGND VPWR VPWR sky130_fd_sc_hd__decap_3
XFILLER_124_461 VGND VGND VPWR VPWR sky130_fd_sc_hd__fill_2
XFILLER_112_601 VGND VGND VPWR VPWR sky130_fd_sc_hd__decap_3
XFILLER_112_623 VGND VGND VPWR VPWR sky130_fd_sc_hd__decap_3
X_5100_ _5934_/A _6434_/B _5100_/C VGND VGND VPWR VPWR _5100_/X sky130_fd_sc_hd__or3_2
Xload_slew411 fanout407/A VGND VGND VPWR VPWR fanout391/A sky130_fd_sc_hd__buf_4
X_6080_ _6083_/B _6091_/A _6076_/A VGND VGND VPWR VPWR _6080_/Y sky130_fd_sc_hd__a21oi_2
XFILLER_97_334 VGND VGND VPWR VPWR sky130_fd_sc_hd__fill_2
XFILLER_112_645 VGND VGND VPWR VPWR sky130_fd_sc_hd__decap_3
XFILLER_111_122 VGND VGND VPWR VPWR sky130_fd_sc_hd__fill_2
X_5031_ _6096_/A VGND VGND VPWR VPWR _6808_/S sky130_fd_sc_hd__clkbuf_1
Xhold1208 _5527_/Y VGND VGND VPWR VPWR _5529_/A sky130_fd_sc_hd__dlygate4sd3_1
Xhold1219 _9246_/Q VGND VGND VPWR VPWR _8835_/A1 sky130_fd_sc_hd__dlygate4sd3_1
XFILLER_66_743 VGND VGND VPWR VPWR sky130_fd_sc_hd__decap_3
XTAP_TAPCELL_ROW_49_941 VGND VPWR sky130_fd_sc_hd__tapvpwrvgnd_1
XFILLER_93_540 VGND VGND VPWR VPWR sky130_fd_sc_hd__decap_3
XFILLER_38_456 VGND VGND VPWR VPWR sky130_fd_sc_hd__decap_3
XFILLER_93_573 VGND VGND VPWR VPWR sky130_fd_sc_hd__decap_3
XFILLER_81_713 VGND VGND VPWR VPWR sky130_fd_sc_hd__decap_3
XFILLER_65_275 VGND VGND VPWR VPWR sky130_fd_sc_hd__decap_3
X_6982_ _7036_/A _7036_/B _6982_/C VGND VGND VPWR VPWR _6982_/Y sky130_fd_sc_hd__nand3_2
XTAP_TAPCELL_ROW_105_1700 VGND VPWR sky130_fd_sc_hd__tapvpwrvgnd_1
XFILLER_81_735 VGND VGND VPWR VPWR sky130_fd_sc_hd__decap_3
XFILLER_65_286 VGND VGND VPWR VPWR sky130_fd_sc_hd__fill_1
XFILLER_25_128 VGND VGND VPWR VPWR sky130_fd_sc_hd__decap_3
X_8721_ _8672_/B _8721_/B VGND VGND VPWR VPWR _8721_/X sky130_fd_sc_hd__and2b_2
X_5933_ _5791_/B _5791_/A _5932_/X _5950_/A VGND VGND VPWR VPWR _5962_/A sky130_fd_sc_hd__a22o_2
XFILLER_81_768 VGND VGND VPWR VPWR sky130_fd_sc_hd__fill_1
XFILLER_34_651 VGND VGND VPWR VPWR sky130_fd_sc_hd__decap_3
XFILLER_15_18 VGND VGND VPWR VPWR sky130_fd_sc_hd__decap_3
XFILLER_34_673 VGND VGND VPWR VPWR sky130_fd_sc_hd__decap_3
X_8652_ _8638_/Y _8639_/A _8651_/X VGND VGND VPWR VPWR _8706_/A sky130_fd_sc_hd__a21oi_4
XFILLER_80_289 VGND VGND VPWR VPWR sky130_fd_sc_hd__decap_3
X_5864_ _5862_/X _5863_/Y _5864_/S VGND VGND VPWR VPWR _5864_/X sky130_fd_sc_hd__mux2_4
XFILLER_61_470 VGND VGND VPWR VPWR sky130_fd_sc_hd__decap_3
XFILLER_21_301 VGND VGND VPWR VPWR sky130_fd_sc_hd__fill_2
XFILLER_33_172 VGND VGND VPWR VPWR sky130_fd_sc_hd__decap_3
XFILLER_61_492 VGND VGND VPWR VPWR sky130_fd_sc_hd__fill_1
X_7603_ _8309_/A _7784_/B _7601_/Y _7602_/Y VGND VGND VPWR VPWR _7608_/A sky130_fd_sc_hd__a31o_2
X_4815_ hold910/X _4815_/A1 _4819_/S VGND VGND VPWR VPWR _4816_/A sky130_fd_sc_hd__mux2_2
XFILLER_33_194 VGND VGND VPWR VPWR sky130_fd_sc_hd__decap_3
X_8583_ wire110/X _8580_/Y _8582_/X VGND VGND VPWR VPWR _9226_/D sky130_fd_sc_hd__a21oi_2
X_5795_ _5950_/B _5795_/B VGND VGND VPWR VPWR _5796_/A sky130_fd_sc_hd__xnor2_2
XFILLER_21_367 VGND VGND VPWR VPWR sky130_fd_sc_hd__decap_3
X_7534_ _7534_/A _7534_/B VGND VGND VPWR VPWR _7534_/Y sky130_fd_sc_hd__nand2_2
Xrebuffer605 _6783_/A2 VGND VGND VPWR VPWR _6512_/A sky130_fd_sc_hd__buf_2
XFILLER_31_17 VGND VGND VPWR VPWR sky130_fd_sc_hd__decap_3
X_4746_ _9120_/Q hold872/X _4756_/S VGND VGND VPWR VPWR _4746_/X sky130_fd_sc_hd__mux2_2
XFILLER_119_222 VGND VGND VPWR VPWR sky130_fd_sc_hd__fill_2
XTAP_TAPCELL_ROW_60_1095 VGND VPWR sky130_fd_sc_hd__tapvpwrvgnd_1
X_7465_ _7465_/A _7636_/B _7636_/C VGND VGND VPWR VPWR _7488_/B sky130_fd_sc_hd__and3_4
X_4677_ _4710_/A1 _4677_/A1 _4693_/S VGND VGND VPWR VPWR _4678_/A sky130_fd_sc_hd__mux2_2
X_9204_ _9204_/CLK _9204_/D fanout415/A VGND VGND VPWR VPWR _9204_/Q sky130_fd_sc_hd__dfrtp_2
X_6416_ _6416_/A _6416_/B VGND VGND VPWR VPWR _6416_/X sky130_fd_sc_hd__or2_2
XTAP_TAPCELL_ROW_116_1851 VGND VPWR sky130_fd_sc_hd__tapvpwrvgnd_1
XFILLER_103_9 VGND VGND VPWR VPWR sky130_fd_sc_hd__decap_3
X_7396_ _7396_/A VGND VGND VPWR VPWR _9214_/D sky130_fd_sc_hd__buf_1
Xoutput28 _9182_/Q VGND VGND VPWR VPWR wire226/A sky130_fd_sc_hd__buf_1
XFILLER_122_409 VGND VGND VPWR VPWR sky130_fd_sc_hd__decap_3
X_9135_ _9135_/CLK _9135_/D load_slew396/X VGND VGND VPWR VPWR _9135_/Q sky130_fd_sc_hd__dfrtp_2
XFILLER_1_706 VGND VGND VPWR VPWR sky130_fd_sc_hd__decap_3
X_6347_ _9208_/Q _7043_/B _7571_/A VGND VGND VPWR VPWR _6349_/C sky130_fd_sc_hd__and3_4
XFILLER_115_461 VGND VGND VPWR VPWR sky130_fd_sc_hd__fill_1
XFILLER_103_623 VGND VGND VPWR VPWR sky130_fd_sc_hd__decap_3
XFILLER_115_494 VGND VGND VPWR VPWR sky130_fd_sc_hd__decap_3
X_9066_ _9335_/CLK _9066_/D fanout400/X VGND VGND VPWR VPWR _9066_/Q sky130_fd_sc_hd__dfrtp_2
X_6278_ _6560_/B _6560_/C VGND VGND VPWR VPWR _6288_/B sky130_fd_sc_hd__nand2_2
X_8017_ _8017_/A _8025_/S VGND VGND VPWR VPWR _8017_/X sky130_fd_sc_hd__xor2_2
XFILLER_102_166 VGND VGND VPWR VPWR sky130_fd_sc_hd__decap_3
XFILLER_103_689 VGND VGND VPWR VPWR sky130_fd_sc_hd__decap_3
X_5229_ _6415_/A _7181_/A VGND VGND VPWR VPWR _5229_/X sky130_fd_sc_hd__and2b_2
XFILLER_130_486 VGND VGND VPWR VPWR sky130_fd_sc_hd__decap_3
XFILLER_69_581 VGND VGND VPWR VPWR sky130_fd_sc_hd__fill_1
XFILLER_56_14 VGND VGND VPWR VPWR sky130_fd_sc_hd__decap_3
XFILLER_69_592 VGND VGND VPWR VPWR sky130_fd_sc_hd__decap_3
XFILLER_57_732 VGND VGND VPWR VPWR sky130_fd_sc_hd__decap_3
XFILLER_56_47 VGND VGND VPWR VPWR sky130_fd_sc_hd__decap_3
XFILLER_56_231 VGND VGND VPWR VPWR sky130_fd_sc_hd__decap_3
XFILLER_57_776 VGND VGND VPWR VPWR sky130_fd_sc_hd__fill_1
XFILLER_56_69 VGND VGND VPWR VPWR sky130_fd_sc_hd__decap_3
XFILLER_56_253 VGND VGND VPWR VPWR sky130_fd_sc_hd__decap_3
XFILLER_84_573 VGND VGND VPWR VPWR sky130_fd_sc_hd__decap_3
XFILLER_84_595 VGND VGND VPWR VPWR sky130_fd_sc_hd__fill_2
XFILLER_71_212 VGND VGND VPWR VPWR sky130_fd_sc_hd__decap_3
X_8919_ _9302_/Q hold922/X _8925_/S VGND VGND VPWR VPWR _8919_/X sky130_fd_sc_hd__mux2_2
XTAP_TAPCELL_ROW_27_646 VGND VPWR sky130_fd_sc_hd__tapvpwrvgnd_1
XTAP_TAPCELL_ROW_127_1991 VGND VPWR sky130_fd_sc_hd__tapvpwrvgnd_1
XFILLER_44_459 VGND VGND VPWR VPWR sky130_fd_sc_hd__decap_3
XFILLER_112_53 VGND VGND VPWR VPWR sky130_fd_sc_hd__decap_3
XFILLER_72_24 VGND VGND VPWR VPWR sky130_fd_sc_hd__decap_3
XFILLER_25_673 VGND VGND VPWR VPWR sky130_fd_sc_hd__decap_3
XFILLER_24_150 VGND VGND VPWR VPWR sky130_fd_sc_hd__decap_3
XFILLER_52_470 VGND VGND VPWR VPWR sky130_fd_sc_hd__decap_3
XFILLER_25_695 VGND VGND VPWR VPWR sky130_fd_sc_hd__decap_3
XFILLER_12_312 VGND VGND VPWR VPWR sky130_fd_sc_hd__decap_3
XFILLER_24_183 VGND VGND VPWR VPWR sky130_fd_sc_hd__decap_3
XFILLER_40_654 VGND VGND VPWR VPWR sky130_fd_sc_hd__decap_3
XPHY_EDGE_ROW_117_Right_117 VGND VGND VPWR VPWR sky130_fd_sc_hd__decap_3
XFILLER_40_698 VGND VGND VPWR VPWR sky130_fd_sc_hd__fill_2
XFILLER_12_389 VGND VGND VPWR VPWR sky130_fd_sc_hd__decap_3
XFILLER_126_704 VGND VGND VPWR VPWR sky130_fd_sc_hd__decap_3
XTAP_TAPCELL_ROW_78_1334 VGND VPWR sky130_fd_sc_hd__tapvpwrvgnd_1
XFILLER_126_737 VGND VGND VPWR VPWR sky130_fd_sc_hd__decap_3
XFILLER_125_214 VGND VGND VPWR VPWR sky130_fd_sc_hd__decap_3
XFILLER_4_522 VGND VGND VPWR VPWR sky130_fd_sc_hd__decap_3
XFILLER_125_225 VGND VGND VPWR VPWR sky130_fd_sc_hd__decap_3
XFILLER_4_533 VGND VGND VPWR VPWR sky130_fd_sc_hd__decap_3
XFILLER_125_258 VGND VGND VPWR VPWR sky130_fd_sc_hd__decap_3
XFILLER_21_94 VGND VGND VPWR VPWR sky130_fd_sc_hd__decap_3
XTAP_TAPCELL_ROW_91_1512 VGND VPWR sky130_fd_sc_hd__tapvpwrvgnd_1
XFILLER_98_109 VGND VGND VPWR VPWR sky130_fd_sc_hd__decap_3
XFILLER_79_301 VGND VGND VPWR VPWR sky130_fd_sc_hd__decap_3
XFILLER_106_483 VGND VGND VPWR VPWR sky130_fd_sc_hd__decap_3
XFILLER_97_54 VGND VGND VPWR VPWR sky130_fd_sc_hd__fill_2
XFILLER_79_334 VGND VGND VPWR VPWR sky130_fd_sc_hd__fill_2
XFILLER_97_87 VGND VGND VPWR VPWR sky130_fd_sc_hd__fill_1
XFILLER_0_750 VGND VGND VPWR VPWR sky130_fd_sc_hd__decap_3
XFILLER_39_209 VGND VGND VPWR VPWR sky130_fd_sc_hd__fill_2
XTAP_TAPCELL_ROW_7_371 VGND VPWR sky130_fd_sc_hd__tapvpwrvgnd_1
XFILLER_94_304 VGND VGND VPWR VPWR sky130_fd_sc_hd__decap_3
XFILLER_121_475 VGND VGND VPWR VPWR sky130_fd_sc_hd__decap_3
XFILLER_0_772 VGND VGND VPWR VPWR sky130_fd_sc_hd__decap_3
XTAP_TAPCELL_ROW_7_382 VGND VPWR sky130_fd_sc_hd__tapvpwrvgnd_1
XFILLER_75_540 VGND VGND VPWR VPWR sky130_fd_sc_hd__decap_3
XFILLER_47_231 VGND VGND VPWR VPWR sky130_fd_sc_hd__decap_3
XFILLER_48_776 VGND VGND VPWR VPWR sky130_fd_sc_hd__fill_1
XTAP_TAPCELL_ROW_46_900 VGND VPWR sky130_fd_sc_hd__tapvpwrvgnd_1
XTAP_TAPCELL_ROW_89_1485 VGND VPWR sky130_fd_sc_hd__tapvpwrvgnd_1
XFILLER_90_510 VGND VGND VPWR VPWR sky130_fd_sc_hd__decap_3
XFILLER_75_584 VGND VGND VPWR VPWR sky130_fd_sc_hd__decap_3
XFILLER_63_735 VGND VGND VPWR VPWR sky130_fd_sc_hd__fill_1
XFILLER_35_426 VGND VGND VPWR VPWR sky130_fd_sc_hd__decap_3
XFILLER_35_459 VGND VGND VPWR VPWR sky130_fd_sc_hd__decap_3
Xmax_cap70 _8249_/B VGND VGND VPWR VPWR _8486_/A sky130_fd_sc_hd__clkbuf_2
XFILLER_90_565 VGND VGND VPWR VPWR sky130_fd_sc_hd__decap_3
Xmax_cap81 _7593_/X VGND VGND VPWR VPWR _8222_/A sky130_fd_sc_hd__buf_2
XFILLER_16_651 VGND VGND VPWR VPWR sky130_fd_sc_hd__fill_2
Xmax_cap92 _6443_/Y VGND VGND VPWR VPWR _6509_/A sky130_fd_sc_hd__buf_2
XFILLER_22_109 VGND VGND VPWR VPWR sky130_fd_sc_hd__decap_3
XFILLER_31_610 VGND VGND VPWR VPWR sky130_fd_sc_hd__decap_3
XFILLER_43_470 VGND VGND VPWR VPWR sky130_fd_sc_hd__decap_3
XFILLER_15_172 VGND VGND VPWR VPWR sky130_fd_sc_hd__decap_3
XTAP_TAPCELL_ROW_100_1630 VGND VPWR sky130_fd_sc_hd__tapvpwrvgnd_1
XFILLER_30_131 VGND VGND VPWR VPWR sky130_fd_sc_hd__decap_3
XFILLER_31_676 VGND VGND VPWR VPWR sky130_fd_sc_hd__decap_3
X_4600_ _9051_/Q hold964/X _4608_/S VGND VGND VPWR VPWR _4600_/X sky130_fd_sc_hd__mux2_2
X_5580_ _5443_/A _5875_/B _5579_/Y _5739_/S VGND VGND VPWR VPWR _5588_/B sky130_fd_sc_hd__a211oi_2
XFILLER_7_30 VGND VGND VPWR VPWR sky130_fd_sc_hd__decap_3
XFILLER_129_553 VGND VGND VPWR VPWR sky130_fd_sc_hd__decap_3
XFILLER_129_564 VGND VGND VPWR VPWR sky130_fd_sc_hd__decap_3
X_4531_ _4531_/A VGND VGND VPWR VPWR _9018_/D sky130_fd_sc_hd__buf_1
XFILLER_117_715 VGND VGND VPWR VPWR sky130_fd_sc_hd__decap_3
XFILLER_7_74 VGND VGND VPWR VPWR sky130_fd_sc_hd__fill_2
XFILLER_129_597 VGND VGND VPWR VPWR sky130_fd_sc_hd__decap_3
XFILLER_7_371 VGND VGND VPWR VPWR sky130_fd_sc_hd__decap_3
X_7250_ _7243_/X _7249_/X _6797_/B _6857_/B VGND VGND VPWR VPWR _7553_/A sky130_fd_sc_hd__o211a_2
XFILLER_7_382 VGND VGND VPWR VPWR sky130_fd_sc_hd__fill_1
XFILLER_117_759 VGND VGND VPWR VPWR sky130_fd_sc_hd__decap_3
XFILLER_7_393 VGND VGND VPWR VPWR sky130_fd_sc_hd__decap_3
XFILLER_116_247 VGND VGND VPWR VPWR sky130_fd_sc_hd__decap_3
XFILLER_104_409 VGND VGND VPWR VPWR sky130_fd_sc_hd__fill_2
X_6201_ _5105_/Y _8405_/A _8313_/A VGND VGND VPWR VPWR _6203_/A sky130_fd_sc_hd__and3b_2
X_7181_ _7181_/A _7181_/B VGND VGND VPWR VPWR _7181_/Y sky130_fd_sc_hd__nand2_2
X_6132_ _6134_/B _6131_/Y _5942_/B VGND VGND VPWR VPWR _6132_/X sky130_fd_sc_hd__o21ba_2
XFILLER_98_654 VGND VGND VPWR VPWR sky130_fd_sc_hd__decap_3
XFILLER_98_676 VGND VGND VPWR VPWR sky130_fd_sc_hd__decap_3
XFILLER_58_507 VGND VGND VPWR VPWR sky130_fd_sc_hd__decap_3
Xload_slew241 _5384_/A VGND VGND VPWR VPWR _5611_/S sky130_fd_sc_hd__buf_6
X_6063_ _6143_/A _6063_/B VGND VGND VPWR VPWR _6063_/Y sky130_fd_sc_hd__nand2_2
Xload_slew263 _6206_/B VGND VGND VPWR VPWR _5737_/B sky130_fd_sc_hd__buf_6
XTAP_TAPCELL_ROW_111_1781 VGND VPWR sky130_fd_sc_hd__tapvpwrvgnd_1
XFILLER_98_698 VGND VGND VPWR VPWR sky130_fd_sc_hd__fill_2
XFILLER_100_626 VGND VGND VPWR VPWR sky130_fd_sc_hd__fill_2
Xhold1005 _9088_/Q VGND VGND VPWR VPWR _4712_/A1 sky130_fd_sc_hd__dlygate4sd3_1
Xhold1016 _9161_/Q VGND VGND VPWR VPWR _4832_/A0 sky130_fd_sc_hd__dlygate4sd3_1
Xhold1027 _9106_/Q VGND VGND VPWR VPWR _4750_/A1 sky130_fd_sc_hd__dlygate4sd3_1
X_5014_ _5014_/A VGND VGND VPWR VPWR _5014_/X sky130_fd_sc_hd__clkbuf_1
Xload_slew296 _7729_/C1 VGND VGND VPWR VPWR _7243_/A sky130_fd_sc_hd__buf_4
Xhold1038 _9302_/Q VGND VGND VPWR VPWR _8953_/A1 sky130_fd_sc_hd__dlygate4sd3_1
XFILLER_85_348 VGND VGND VPWR VPWR sky130_fd_sc_hd__fill_1
Xhold1049 _9324_/Q VGND VGND VPWR VPWR _8999_/A1 sky130_fd_sc_hd__dlygate4sd3_1
XFILLER_39_754 VGND VGND VPWR VPWR sky130_fd_sc_hd__fill_1
XFILLER_38_231 VGND VGND VPWR VPWR sky130_fd_sc_hd__decap_3
XFILLER_38_253 VGND VGND VPWR VPWR sky130_fd_sc_hd__decap_3
XFILLER_26_404 VGND VGND VPWR VPWR sky130_fd_sc_hd__decap_3
XFILLER_81_510 VGND VGND VPWR VPWR sky130_fd_sc_hd__decap_3
XFILLER_26_459 VGND VGND VPWR VPWR sky130_fd_sc_hd__decap_3
X_6965_ _6965_/A _6965_/B VGND VGND VPWR VPWR _7058_/B sky130_fd_sc_hd__or2_2
X_8704_ _8737_/B _8704_/B VGND VGND VPWR VPWR _8721_/B sky130_fd_sc_hd__xor2_2
XTAP_TAPCELL_ROW_24_605 VGND VPWR sky130_fd_sc_hd__tapvpwrvgnd_1
XFILLER_13_109 VGND VGND VPWR VPWR sky130_fd_sc_hd__decap_3
X_5916_ _5916_/A VGND VGND VPWR VPWR _9206_/D sky130_fd_sc_hd__buf_1
XFILLER_41_429 VGND VGND VPWR VPWR sky130_fd_sc_hd__decap_3
XTAP_TAPCELL_ROW_62_1113 VGND VPWR sky130_fd_sc_hd__tapvpwrvgnd_1
X_6896_ _6840_/B _6899_/B _6895_/X _6899_/A _7149_/B2 VGND VGND VPWR VPWR _6896_/Y
+ sky130_fd_sc_hd__a221oi_2
XTAP_TAPCELL_ROW_62_1124 VGND VPWR sky130_fd_sc_hd__tapvpwrvgnd_1
XFILLER_22_643 VGND VGND VPWR VPWR sky130_fd_sc_hd__fill_1
X_8635_ _8636_/A _8636_/B _8575_/B VGND VGND VPWR VPWR _8635_/X sky130_fd_sc_hd__a21o_2
X_5847_ _7313_/A _7313_/B _7065_/A VGND VGND VPWR VPWR _5849_/A sky130_fd_sc_hd__a21oi_2
XFILLER_21_131 VGND VGND VPWR VPWR sky130_fd_sc_hd__decap_3
X_8566_ _8566_/A wire66/X VGND VGND VPWR VPWR _8566_/Y sky130_fd_sc_hd__nand2_2
XFILLER_21_175 VGND VGND VPWR VPWR sky130_fd_sc_hd__decap_3
X_5778_ _5778_/A VGND VGND VPWR VPWR _9205_/D sky130_fd_sc_hd__buf_1
XFILLER_21_186 VGND VGND VPWR VPWR sky130_fd_sc_hd__decap_3
Xrebuffer424 rebuffer447/X VGND VGND VPWR VPWR _7651_/A sky130_fd_sc_hd__buf_2
X_7517_ _7659_/B _7518_/C _7515_/X VGND VGND VPWR VPWR _7517_/X sky130_fd_sc_hd__o21a_2
Xrebuffer435 _4998_/A VGND VGND VPWR VPWR _4952_/A sky130_fd_sc_hd__buf_6
X_4729_ _9112_/Q _4729_/A1 _4735_/S VGND VGND VPWR VPWR _4729_/X sky130_fd_sc_hd__mux2_2
Xrebuffer446 _6167_/A2 VGND VGND VPWR VPWR _6972_/A sky130_fd_sc_hd__buf_6
XFILLER_5_308 VGND VGND VPWR VPWR sky130_fd_sc_hd__decap_3
XFILLER_107_203 VGND VGND VPWR VPWR sky130_fd_sc_hd__fill_2
X_8497_ _7799_/A _8177_/B _8496_/S _8350_/B VGND VGND VPWR VPWR _8497_/X sky130_fd_sc_hd__a31o_2
Xrebuffer457 _4515_/A VGND VGND VPWR VPWR _5062_/A sky130_fd_sc_hd__buf_2
XFILLER_107_214 VGND VGND VPWR VPWR sky130_fd_sc_hd__decap_3
Xrebuffer468 _6953_/B VGND VGND VPWR VPWR _5077_/B sky130_fd_sc_hd__buf_2
Xrebuffer479 _6256_/B1 VGND VGND VPWR VPWR _6005_/A sky130_fd_sc_hd__buf_2
X_7448_ _7448_/A _7448_/B VGND VGND VPWR VPWR _7449_/B sky130_fd_sc_hd__xnor2_2
XFILLER_101_6 VGND VGND VPWR VPWR sky130_fd_sc_hd__decap_3
XFILLER_123_718 VGND VGND VPWR VPWR sky130_fd_sc_hd__decap_3
XFILLER_123_729 VGND VGND VPWR VPWR sky130_fd_sc_hd__decap_3
Xhold850 _9158_/Q VGND VGND VPWR VPWR hold850/X sky130_fd_sc_hd__dlygate4sd3_1
XFILLER_1_503 VGND VGND VPWR VPWR sky130_fd_sc_hd__fill_1
XFILLER_122_206 VGND VGND VPWR VPWR sky130_fd_sc_hd__decap_3
X_7379_ _7379_/A VGND VGND VPWR VPWR _7379_/Y sky130_fd_sc_hd__inv_2
Xhold861 _4735_/X VGND VGND VPWR VPWR _4736_/A sky130_fd_sc_hd__dlygate4sd3_1
Xhold872 _9104_/Q VGND VGND VPWR VPWR hold872/X sky130_fd_sc_hd__dlygate4sd3_1
XFILLER_107_42 VGND VGND VPWR VPWR sky130_fd_sc_hd__decap_3
Xhold883 _4738_/X VGND VGND VPWR VPWR _4739_/A sky130_fd_sc_hd__dlygate4sd3_1
X_9118_ _9293_/CLK _9118_/D fanout383/X VGND VGND VPWR VPWR _9118_/Q sky130_fd_sc_hd__dfrtp_2
Xhold894 _9170_/Q VGND VGND VPWR VPWR hold894/X sky130_fd_sc_hd__dlygate4sd3_1
XFILLER_89_654 VGND VGND VPWR VPWR sky130_fd_sc_hd__decap_3
XFILLER_115_291 VGND VGND VPWR VPWR sky130_fd_sc_hd__decap_3
XFILLER_103_442 VGND VGND VPWR VPWR sky130_fd_sc_hd__decap_3
XTAP_TAPCELL_ROW_73_1264 VGND VPWR sky130_fd_sc_hd__tapvpwrvgnd_1
XFILLER_89_676 VGND VGND VPWR VPWR sky130_fd_sc_hd__decap_3
XFILLER_103_464 VGND VGND VPWR VPWR sky130_fd_sc_hd__decap_3
X_9049_ _9228_/CLK _9049_/D wire406/A VGND VGND VPWR VPWR _9049_/Q sky130_fd_sc_hd__dfrtp_2
XFILLER_49_529 VGND VGND VPWR VPWR sky130_fd_sc_hd__decap_3
XFILLER_67_57 VGND VGND VPWR VPWR sky130_fd_sc_hd__decap_3
XTAP_TAPCELL_ROW_4_330 VGND VPWR sky130_fd_sc_hd__tapvpwrvgnd_1
XTAP_TAPCELL_ROW_4_341 VGND VPWR sky130_fd_sc_hd__tapvpwrvgnd_1
XFILLER_130_294 VGND VGND VPWR VPWR sky130_fd_sc_hd__decap_3
XFILLER_76_359 VGND VGND VPWR VPWR sky130_fd_sc_hd__fill_2
XFILLER_29_220 VGND VGND VPWR VPWR sky130_fd_sc_hd__decap_3
XFILLER_123_30 VGND VGND VPWR VPWR sky130_fd_sc_hd__decap_3
XFILLER_29_242 VGND VGND VPWR VPWR sky130_fd_sc_hd__decap_3
XFILLER_123_63 VGND VGND VPWR VPWR sky130_fd_sc_hd__decap_3
XFILLER_84_381 VGND VGND VPWR VPWR sky130_fd_sc_hd__decap_3
XFILLER_44_212 VGND VGND VPWR VPWR sky130_fd_sc_hd__decap_3
XFILLER_123_96 VGND VGND VPWR VPWR sky130_fd_sc_hd__decap_3
XFILLER_44_256 VGND VGND VPWR VPWR sky130_fd_sc_hd__decap_3
XFILLER_16_50 VGND VGND VPWR VPWR sky130_fd_sc_hd__decap_3
XFILLER_25_481 VGND VGND VPWR VPWR sky130_fd_sc_hd__decap_3
XFILLER_16_83 VGND VGND VPWR VPWR sky130_fd_sc_hd__fill_1
XFILLER_13_643 VGND VGND VPWR VPWR sky130_fd_sc_hd__fill_1
XFILLER_12_153 VGND VGND VPWR VPWR sky130_fd_sc_hd__decap_3
XFILLER_40_473 VGND VGND VPWR VPWR sky130_fd_sc_hd__decap_3
XFILLER_40_484 VGND VGND VPWR VPWR sky130_fd_sc_hd__decap_3
XFILLER_9_669 VGND VGND VPWR VPWR sky130_fd_sc_hd__decap_3
XFILLER_12_197 VGND VGND VPWR VPWR sky130_fd_sc_hd__decap_3
XFILLER_32_71 VGND VGND VPWR VPWR sky130_fd_sc_hd__decap_3
XFILLER_8_168 VGND VGND VPWR VPWR sky130_fd_sc_hd__decap_3
XFILLER_126_501 VGND VGND VPWR VPWR sky130_fd_sc_hd__decap_3
XFILLER_126_545 VGND VGND VPWR VPWR sky130_fd_sc_hd__decap_3
XFILLER_126_567 VGND VGND VPWR VPWR sky130_fd_sc_hd__decap_3
XFILLER_114_707 VGND VGND VPWR VPWR sky130_fd_sc_hd__decap_3
XFILLER_99_418 VGND VGND VPWR VPWR sky130_fd_sc_hd__decap_3
XFILLER_126_589 VGND VGND VPWR VPWR sky130_fd_sc_hd__decap_3
XFILLER_4_374 VGND VGND VPWR VPWR sky130_fd_sc_hd__decap_3
XFILLER_106_280 VGND VGND VPWR VPWR sky130_fd_sc_hd__decap_3
XFILLER_79_142 VGND VGND VPWR VPWR sky130_fd_sc_hd__decap_3
XFILLER_122_751 VGND VGND VPWR VPWR sky130_fd_sc_hd__decap_3
XFILLER_95_602 VGND VGND VPWR VPWR sky130_fd_sc_hd__decap_3
XFILLER_121_250 VGND VGND VPWR VPWR sky130_fd_sc_hd__decap_3
XFILLER_95_635 VGND VGND VPWR VPWR sky130_fd_sc_hd__decap_3
XFILLER_95_679 VGND VGND VPWR VPWR sky130_fd_sc_hd__decap_3
XFILLER_48_551 VGND VGND VPWR VPWR sky130_fd_sc_hd__decap_3
XFILLER_82_318 VGND VGND VPWR VPWR sky130_fd_sc_hd__decap_3
XFILLER_48_584 VGND VGND VPWR VPWR sky130_fd_sc_hd__decap_3
XFILLER_36_724 VGND VGND VPWR VPWR sky130_fd_sc_hd__decap_3
XFILLER_48_595 VGND VGND VPWR VPWR sky130_fd_sc_hd__decap_3
XFILLER_36_757 VGND VGND VPWR VPWR sky130_fd_sc_hd__decap_3
XFILLER_35_234 VGND VGND VPWR VPWR sky130_fd_sc_hd__decap_3
XFILLER_90_351 VGND VGND VPWR VPWR sky130_fd_sc_hd__fill_1
X_6750_ _9177_/Q _9179_/D _5456_/B _9081_/Q VGND VGND VPWR VPWR _6750_/X sky130_fd_sc_hd__a22o_2
X_5701_ _7311_/A _5707_/B _5602_/B _5602_/A VGND VGND VPWR VPWR _5701_/X sky130_fd_sc_hd__o31a_2
XFILLER_50_248 VGND VGND VPWR VPWR sky130_fd_sc_hd__decap_3
XFILLER_50_259 VGND VGND VPWR VPWR sky130_fd_sc_hd__decap_3
X_6681_ wire122/X _6681_/A2 _5743_/Y _6279_/C VGND VGND VPWR VPWR _6992_/C sky130_fd_sc_hd__a211o_2
X_8420_ _8514_/A _8420_/B VGND VGND VPWR VPWR _8469_/A sky130_fd_sc_hd__xnor2_2
XFILLER_31_473 VGND VGND VPWR VPWR sky130_fd_sc_hd__decap_3
X_5632_ _8050_/B _5632_/B VGND VGND VPWR VPWR _5633_/B sky130_fd_sc_hd__xnor2_2
X_8351_ wire61/X _8402_/A _8566_/A VGND VGND VPWR VPWR _8352_/B sky130_fd_sc_hd__a21oi_2
X_5563_ _5450_/A _5451_/A _5450_/B VGND VGND VPWR VPWR _5563_/X sky130_fd_sc_hd__a21o_2
X_7302_ _7301_/A _7301_/B _7069_/Y VGND VGND VPWR VPWR _7302_/X sky130_fd_sc_hd__a21o_2
XFILLER_117_534 VGND VGND VPWR VPWR sky130_fd_sc_hd__decap_3
X_4514_ _7794_/A _8175_/A VGND VGND VPWR VPWR _4515_/B sky130_fd_sc_hd__and2b_2
XFILLER_8_691 VGND VGND VPWR VPWR sky130_fd_sc_hd__decap_3
X_8282_ _8286_/S _8297_/A _8281_/Y VGND VGND VPWR VPWR _8282_/X sky130_fd_sc_hd__a21o_2
X_5494_ _5492_/X _5495_/B _5495_/C _5495_/A VGND VGND VPWR VPWR _5494_/X sky130_fd_sc_hd__a211o_2
XFILLER_117_567 VGND VGND VPWR VPWR sky130_fd_sc_hd__fill_2
X_7233_ _7233_/A _7233_/B VGND VGND VPWR VPWR _7661_/B sky130_fd_sc_hd__xnor2_2
XTAP_TAPCELL_ROW_113_1810 VGND VPWR sky130_fd_sc_hd__tapvpwrvgnd_1
XFILLER_104_239 VGND VGND VPWR VPWR sky130_fd_sc_hd__decap_3
X_7164_ _7156_/X _7163_/Y _7212_/B VGND VGND VPWR VPWR _7164_/X sky130_fd_sc_hd__mux2_2
XTAP_TAPCELL_ROW_129_2017 VGND VPWR sky130_fd_sc_hd__tapvpwrvgnd_1
XFILLER_98_462 VGND VGND VPWR VPWR sky130_fd_sc_hd__decap_3
X_6115_ _5084_/B _6110_/X _6114_/X VGND VGND VPWR VPWR _6116_/A sky130_fd_sc_hd__a21oi_2
XTAP_TAPCELL_ROW_129_2028 VGND VPWR sky130_fd_sc_hd__tapvpwrvgnd_1
XFILLER_112_261 VGND VGND VPWR VPWR sky130_fd_sc_hd__decap_3
X_7095_ _7095_/A _7099_/C VGND VGND VPWR VPWR _7095_/Y sky130_fd_sc_hd__nand2_2
XFILLER_86_657 VGND VGND VPWR VPWR sky130_fd_sc_hd__decap_3
X_6046_ _6368_/A _6215_/B VGND VGND VPWR VPWR _6050_/A sky130_fd_sc_hd__xor2_2
XFILLER_58_359 VGND VGND VPWR VPWR sky130_fd_sc_hd__decap_3
XTAP_TAPCELL_ROW_1_300 VGND VPWR sky130_fd_sc_hd__tapvpwrvgnd_1
XFILLER_100_489 VGND VGND VPWR VPWR sky130_fd_sc_hd__decap_3
XFILLER_27_724 VGND VGND VPWR VPWR sky130_fd_sc_hd__decap_3
XFILLER_94_690 VGND VGND VPWR VPWR sky130_fd_sc_hd__decap_3
XFILLER_66_392 VGND VGND VPWR VPWR sky130_fd_sc_hd__fill_2
XFILLER_81_340 VGND VGND VPWR VPWR sky130_fd_sc_hd__decap_3
X_7997_ _7997_/A _7997_/B VGND VGND VPWR VPWR _7999_/A sky130_fd_sc_hd__nand2_2
XFILLER_54_565 VGND VGND VPWR VPWR sky130_fd_sc_hd__fill_1
XFILLER_26_256 VGND VGND VPWR VPWR sky130_fd_sc_hd__decap_3
XTAP_TAPCELL_ROW_124_1950 VGND VPWR sky130_fd_sc_hd__tapvpwrvgnd_1
XFILLER_81_362 VGND VGND VPWR VPWR sky130_fd_sc_hd__decap_3
XFILLER_54_576 VGND VGND VPWR VPWR sky130_fd_sc_hd__decap_3
XFILLER_53_15 VGND VGND VPWR VPWR sky130_fd_sc_hd__decap_3
XTAP_TAPCELL_ROW_124_1961 VGND VPWR sky130_fd_sc_hd__tapvpwrvgnd_1
XFILLER_14_418 VGND VGND VPWR VPWR sky130_fd_sc_hd__fill_2
XTAP_TAPCELL_ROW_37_785 VGND VPWR sky130_fd_sc_hd__tapvpwrvgnd_1
X_6948_ _7112_/A _6948_/B VGND VGND VPWR VPWR _7029_/B sky130_fd_sc_hd__xnor2_2
XFILLER_53_48 VGND VGND VPWR VPWR sky130_fd_sc_hd__decap_3
XFILLER_22_440 VGND VGND VPWR VPWR sky130_fd_sc_hd__decap_3
X_6879_ _7196_/B _6879_/B VGND VGND VPWR VPWR _7203_/B sky130_fd_sc_hd__xnor2_2
XFILLER_50_760 VGND VGND VPWR VPWR sky130_fd_sc_hd__decap_3
X_8618_ _9226_/Q _8695_/B _8655_/B VGND VGND VPWR VPWR _8618_/X sky130_fd_sc_hd__o21a_2
X_8549_ _8549_/A VGND VGND VPWR VPWR _8549_/Y sky130_fd_sc_hd__inv_2
XFILLER_5_116 VGND VGND VPWR VPWR sky130_fd_sc_hd__fill_1
XFILLER_108_556 VGND VGND VPWR VPWR sky130_fd_sc_hd__decap_3
XFILLER_5_149 VGND VGND VPWR VPWR sky130_fd_sc_hd__decap_3
XTAP_TAPCELL_ROW_9_400 VGND VPWR sky130_fd_sc_hd__tapvpwrvgnd_1
XFILLER_118_41 VGND VGND VPWR VPWR sky130_fd_sc_hd__decap_3
XFILLER_78_12 VGND VGND VPWR VPWR sky130_fd_sc_hd__decap_3
XFILLER_123_526 VGND VGND VPWR VPWR sky130_fd_sc_hd__decap_3
XFILLER_118_74 VGND VGND VPWR VPWR sky130_fd_sc_hd__decap_3
XFILLER_118_85 VGND VGND VPWR VPWR sky130_fd_sc_hd__decap_3
XFILLER_123_559 VGND VGND VPWR VPWR sky130_fd_sc_hd__fill_1
XFILLER_104_751 VGND VGND VPWR VPWR sky130_fd_sc_hd__fill_2
XFILLER_89_462 VGND VGND VPWR VPWR sky130_fd_sc_hd__decap_3
XFILLER_77_613 VGND VGND VPWR VPWR sky130_fd_sc_hd__decap_3
XFILLER_89_495 VGND VGND VPWR VPWR sky130_fd_sc_hd__decap_3
XFILLER_49_337 VGND VGND VPWR VPWR sky130_fd_sc_hd__fill_1
XFILLER_1_399 VGND VGND VPWR VPWR sky130_fd_sc_hd__decap_3
XFILLER_94_44 VGND VGND VPWR VPWR sky130_fd_sc_hd__fill_1
XFILLER_92_616 VGND VGND VPWR VPWR sky130_fd_sc_hd__decap_3
XFILLER_92_627 VGND VGND VPWR VPWR sky130_fd_sc_hd__fill_1
XFILLER_18_713 VGND VGND VPWR VPWR sky130_fd_sc_hd__decap_3
XFILLER_94_77 VGND VGND VPWR VPWR sky130_fd_sc_hd__decap_3
XFILLER_94_88 VGND VGND VPWR VPWR sky130_fd_sc_hd__fill_2
XFILLER_91_137 VGND VGND VPWR VPWR sky130_fd_sc_hd__decap_3
XFILLER_18_746 VGND VGND VPWR VPWR sky130_fd_sc_hd__decap_3
XFILLER_45_543 VGND VGND VPWR VPWR sky130_fd_sc_hd__decap_3
XFILLER_18_757 VGND VGND VPWR VPWR sky130_fd_sc_hd__decap_3
XFILLER_17_234 VGND VGND VPWR VPWR sky130_fd_sc_hd__decap_3
XTAP_TAPCELL_ROW_86_1444 VGND VPWR sky130_fd_sc_hd__tapvpwrvgnd_1
XFILLER_27_82 VGND VGND VPWR VPWR sky130_fd_sc_hd__decap_3
XFILLER_60_502 VGND VGND VPWR VPWR sky130_fd_sc_hd__decap_3
XFILLER_45_576 VGND VGND VPWR VPWR sky130_fd_sc_hd__decap_3
XFILLER_17_267 VGND VGND VPWR VPWR sky130_fd_sc_hd__decap_3
Xclkbuf_2_0__f_clk clkbuf_0_clk/X VGND VGND VPWR VPWR clkload0/A sky130_fd_sc_hd__clkbuf_16
XFILLER_32_226 VGND VGND VPWR VPWR sky130_fd_sc_hd__decap_3
XFILLER_60_568 VGND VGND VPWR VPWR sky130_fd_sc_hd__decap_3
XTAP_TAPCELL_ROW_15_479 VGND VPWR sky130_fd_sc_hd__tapvpwrvgnd_1
XFILLER_9_411 VGND VGND VPWR VPWR sky130_fd_sc_hd__decap_3
XFILLER_13_462 VGND VGND VPWR VPWR sky130_fd_sc_hd__decap_3
XFILLER_43_81 VGND VGND VPWR VPWR sky130_fd_sc_hd__decap_3
XFILLER_9_455 VGND VGND VPWR VPWR sky130_fd_sc_hd__decap_3
XFILLER_40_292 VGND VGND VPWR VPWR sky130_fd_sc_hd__fill_1
XFILLER_118_309 VGND VGND VPWR VPWR sky130_fd_sc_hd__fill_1
XFILLER_9_466 VGND VGND VPWR VPWR sky130_fd_sc_hd__decap_3
XFILLER_9_488 VGND VGND VPWR VPWR sky130_fd_sc_hd__decap_3
XFILLER_9_499 VGND VGND VPWR VPWR sky130_fd_sc_hd__decap_3
XFILLER_64_6 VGND VGND VPWR VPWR sky130_fd_sc_hd__decap_3
XTAP_TAPCELL_ROW_97_1595 VGND VPWR sky130_fd_sc_hd__tapvpwrvgnd_1
XFILLER_99_237 VGND VGND VPWR VPWR sky130_fd_sc_hd__decap_3
XFILLER_5_694 VGND VGND VPWR VPWR sky130_fd_sc_hd__decap_3
XFILLER_126_397 VGND VGND VPWR VPWR sky130_fd_sc_hd__fill_1
XFILLER_114_559 VGND VGND VPWR VPWR sky130_fd_sc_hd__decap_3
XFILLER_4_53 VGND VGND VPWR VPWR sky130_fd_sc_hd__decap_3
XFILLER_68_602 VGND VGND VPWR VPWR sky130_fd_sc_hd__decap_3
XFILLER_4_97 VGND VGND VPWR VPWR sky130_fd_sc_hd__decap_3
XFILLER_122_570 VGND VGND VPWR VPWR sky130_fd_sc_hd__decap_3
XFILLER_110_721 VGND VGND VPWR VPWR sky130_fd_sc_hd__fill_1
XFILLER_122_592 VGND VGND VPWR VPWR sky130_fd_sc_hd__decap_3
XFILLER_67_145 VGND VGND VPWR VPWR sky130_fd_sc_hd__fill_1
XFILLER_83_605 VGND VGND VPWR VPWR sky130_fd_sc_hd__decap_3
X_7920_ _7826_/A _7825_/B _7825_/A VGND VGND VPWR VPWR _7920_/X sky130_fd_sc_hd__a21o_2
XFILLER_82_137 VGND VGND VPWR VPWR sky130_fd_sc_hd__decap_3
X_7851_ _7751_/X _7850_/Y _8117_/S VGND VGND VPWR VPWR _7852_/A sky130_fd_sc_hd__mux2_2
XFILLER_63_340 VGND VGND VPWR VPWR sky130_fd_sc_hd__decap_3
XFILLER_91_671 VGND VGND VPWR VPWR sky130_fd_sc_hd__fill_1
XFILLER_51_502 VGND VGND VPWR VPWR sky130_fd_sc_hd__fill_2
X_6802_ _6492_/A _6492_/B _6493_/B VGND VGND VPWR VPWR _6802_/X sky130_fd_sc_hd__a21bo_2
XFILLER_36_587 VGND VGND VPWR VPWR sky130_fd_sc_hd__fill_1
XFILLER_24_738 VGND VGND VPWR VPWR sky130_fd_sc_hd__decap_3
X_7782_ _7782_/A _7782_/B VGND VGND VPWR VPWR _7790_/A sky130_fd_sc_hd__xnor2_2
X_4994_ _9035_/Q _6757_/B _5442_/A VGND VGND VPWR VPWR _4994_/X sky130_fd_sc_hd__and3_2
XFILLER_51_546 VGND VGND VPWR VPWR sky130_fd_sc_hd__fill_1
XFILLER_23_237 VGND VGND VPWR VPWR sky130_fd_sc_hd__fill_2
XTAP_TAPCELL_ROW_34_744 VGND VPWR sky130_fd_sc_hd__tapvpwrvgnd_1
X_6733_ _6733_/A _6733_/B _6733_/C _6733_/D VGND VGND VPWR VPWR _6733_/X sky130_fd_sc_hd__and4_4
XFILLER_23_18 VGND VGND VPWR VPWR sky130_fd_sc_hd__decap_3
XFILLER_32_771 VGND VGND VPWR VPWR sky130_fd_sc_hd__decap_3
X_6664_ _6662_/X _6664_/B _6664_/C VGND VGND VPWR VPWR _6777_/C sky130_fd_sc_hd__nand3b_2
XFILLER_31_281 VGND VGND VPWR VPWR sky130_fd_sc_hd__decap_3
X_8403_ _8337_/Y _8402_/Y _8334_/B _8335_/A VGND VGND VPWR VPWR _8403_/X sky130_fd_sc_hd__o2bb2a_2
X_5615_ _6342_/A _6342_/B _9310_/Q VGND VGND VPWR VPWR _5615_/X sky130_fd_sc_hd__or3b_2
X_6595_ _7010_/B _6595_/B VGND VGND VPWR VPWR _6676_/B sky130_fd_sc_hd__xnor2_4
X_8334_ _8402_/B _8334_/B VGND VGND VPWR VPWR _8335_/B sky130_fd_sc_hd__xnor2_2
X_5546_ _5667_/S _5546_/B VGND VGND VPWR VPWR _5664_/B sky130_fd_sc_hd__xnor2_2
XFILLER_117_331 VGND VGND VPWR VPWR sky130_fd_sc_hd__decap_3
XFILLER_117_364 VGND VGND VPWR VPWR sky130_fd_sc_hd__fill_2
XFILLER_105_526 VGND VGND VPWR VPWR sky130_fd_sc_hd__decap_3
X_8265_ _8265_/A wire45/X VGND VGND VPWR VPWR _8275_/B sky130_fd_sc_hd__xnor2_2
X_5477_ _7430_/A VGND VGND VPWR VPWR _7945_/A sky130_fd_sc_hd__buf_4
XTAP_TAPCELL_ROW_57_1045 VGND VPWR sky130_fd_sc_hd__tapvpwrvgnd_1
XTAP_TAPCELL_ROW_57_1056 VGND VPWR sky130_fd_sc_hd__tapvpwrvgnd_1
X_7216_ _7263_/A _7216_/B VGND VGND VPWR VPWR _7217_/B sky130_fd_sc_hd__xnor2_2
X_8196_ _8271_/A wire71/A _8196_/C VGND VGND VPWR VPWR _8196_/X sky130_fd_sc_hd__or3_2
XFILLER_59_602 VGND VGND VPWR VPWR sky130_fd_sc_hd__decap_3
XTAP_TAPCELL_ROW_70_1223 VGND VPWR sky130_fd_sc_hd__tapvpwrvgnd_1
XFILLER_120_529 VGND VGND VPWR VPWR sky130_fd_sc_hd__decap_3
X_7147_ _7147_/A _7147_/B VGND VGND VPWR VPWR _7147_/Y sky130_fd_sc_hd__xnor2_2
XFILLER_59_635 VGND VGND VPWR VPWR sky130_fd_sc_hd__fill_2
XFILLER_101_732 VGND VGND VPWR VPWR sky130_fd_sc_hd__decap_3
XFILLER_86_421 VGND VGND VPWR VPWR sky130_fd_sc_hd__decap_3
XFILLER_48_59 VGND VGND VPWR VPWR sky130_fd_sc_hd__decap_3
XFILLER_100_231 VGND VGND VPWR VPWR sky130_fd_sc_hd__decap_3
X_7078_ _7077_/B _7077_/C _7069_/Y VGND VGND VPWR VPWR _7078_/Y sky130_fd_sc_hd__a21boi_2
XFILLER_58_156 VGND VGND VPWR VPWR sky130_fd_sc_hd__fill_1
XFILLER_74_616 VGND VGND VPWR VPWR sky130_fd_sc_hd__decap_3
XFILLER_58_178 VGND VGND VPWR VPWR sky130_fd_sc_hd__fill_2
X_6029_ _6302_/A _6035_/B VGND VGND VPWR VPWR _6030_/A sky130_fd_sc_hd__or2_2
XFILLER_39_381 VGND VGND VPWR VPWR sky130_fd_sc_hd__decap_3
XFILLER_27_532 VGND VGND VPWR VPWR sky130_fd_sc_hd__decap_3
XFILLER_54_340 VGND VGND VPWR VPWR sky130_fd_sc_hd__decap_3
XFILLER_82_660 VGND VGND VPWR VPWR sky130_fd_sc_hd__decap_3
XFILLER_42_513 VGND VGND VPWR VPWR sky130_fd_sc_hd__decap_3
XFILLER_15_727 VGND VGND VPWR VPWR sky130_fd_sc_hd__fill_1
XFILLER_15_738 VGND VGND VPWR VPWR sky130_fd_sc_hd__decap_3
XTAP_TAPCELL_ROW_68_1196 VGND VPWR sky130_fd_sc_hd__tapvpwrvgnd_1
XFILLER_120_53 VGND VGND VPWR VPWR sky130_fd_sc_hd__decap_3
XFILLER_80_24 VGND VGND VPWR VPWR sky130_fd_sc_hd__decap_3
XFILLER_23_771 VGND VGND VPWR VPWR sky130_fd_sc_hd__decap_3
XTAP_TAPCELL_ROW_81_1374 VGND VPWR sky130_fd_sc_hd__tapvpwrvgnd_1
XFILLER_120_97 VGND VGND VPWR VPWR sky130_fd_sc_hd__decap_3
XFILLER_10_410 VGND VGND VPWR VPWR sky130_fd_sc_hd__decap_3
XTAP_TAPCELL_ROW_12_438 VGND VPWR sky130_fd_sc_hd__tapvpwrvgnd_1
XFILLER_10_421 VGND VGND VPWR VPWR sky130_fd_sc_hd__decap_3
XFILLER_128_607 VGND VGND VPWR VPWR sky130_fd_sc_hd__decap_3
XTAP_TAPCELL_ROW_12_449 VGND VPWR sky130_fd_sc_hd__tapvpwrvgnd_1
XFILLER_80_79 VGND VGND VPWR VPWR sky130_fd_sc_hd__decap_3
XFILLER_6_414 VGND VGND VPWR VPWR sky130_fd_sc_hd__decap_3
XFILLER_127_128 VGND VGND VPWR VPWR sky130_fd_sc_hd__decap_3
XFILLER_129_51 VGND VGND VPWR VPWR sky130_fd_sc_hd__decap_3
XFILLER_10_498 VGND VGND VPWR VPWR sky130_fd_sc_hd__decap_3
XFILLER_129_84 VGND VGND VPWR VPWR sky130_fd_sc_hd__decap_3
XFILLER_89_55 VGND VGND VPWR VPWR sky130_fd_sc_hd__fill_1
XFILLER_123_301 VGND VGND VPWR VPWR sky130_fd_sc_hd__decap_3
XFILLER_108_397 VGND VGND VPWR VPWR sky130_fd_sc_hd__fill_1
XFILLER_89_88 VGND VGND VPWR VPWR sky130_fd_sc_hd__decap_3
XFILLER_2_631 VGND VGND VPWR VPWR sky130_fd_sc_hd__decap_3
XFILLER_123_367 VGND VGND VPWR VPWR sky130_fd_sc_hd__decap_3
XFILLER_2_675 VGND VGND VPWR VPWR sky130_fd_sc_hd__decap_3
XFILLER_89_281 VGND VGND VPWR VPWR sky130_fd_sc_hd__decap_3
XFILLER_77_421 VGND VGND VPWR VPWR sky130_fd_sc_hd__fill_1
XFILLER_65_605 VGND VGND VPWR VPWR sky130_fd_sc_hd__fill_1
XFILLER_92_402 VGND VGND VPWR VPWR sky130_fd_sc_hd__decap_3
XFILLER_49_167 VGND VGND VPWR VPWR sky130_fd_sc_hd__fill_1
XFILLER_65_638 VGND VGND VPWR VPWR sky130_fd_sc_hd__decap_3
XFILLER_92_424 VGND VGND VPWR VPWR sky130_fd_sc_hd__decap_3
XFILLER_73_660 VGND VGND VPWR VPWR sky130_fd_sc_hd__decap_3
XFILLER_18_598 VGND VGND VPWR VPWR sky130_fd_sc_hd__decap_3
XFILLER_73_693 VGND VGND VPWR VPWR sky130_fd_sc_hd__decap_3
XFILLER_72_170 VGND VGND VPWR VPWR sky130_fd_sc_hd__decap_3
XFILLER_45_384 VGND VGND VPWR VPWR sky130_fd_sc_hd__decap_3
XFILLER_21_708 VGND VGND VPWR VPWR sky130_fd_sc_hd__decap_3
XFILLER_60_365 VGND VGND VPWR VPWR sky130_fd_sc_hd__decap_3
XFILLER_33_579 VGND VGND VPWR VPWR sky130_fd_sc_hd__decap_3
XFILLER_14_760 VGND VGND VPWR VPWR sky130_fd_sc_hd__decap_3
XTAP_TAPCELL_ROW_31_703 VGND VPWR sky130_fd_sc_hd__tapvpwrvgnd_1
XFILLER_60_387 VGND VGND VPWR VPWR sky130_fd_sc_hd__decap_3
XTAP_TAPCELL_ROW_99_1613 VGND VPWR sky130_fd_sc_hd__tapvpwrvgnd_1
XTAP_TAPCELL_ROW_99_1624 VGND VPWR sky130_fd_sc_hd__tapvpwrvgnd_1
XFILLER_13_281 VGND VGND VPWR VPWR sky130_fd_sc_hd__decap_3
XFILLER_118_106 VGND VGND VPWR VPWR sky130_fd_sc_hd__decap_3
XFILLER_118_139 VGND VGND VPWR VPWR sky130_fd_sc_hd__fill_1
X_5400_ _9201_/Q wire84/A _5398_/Y _5399_/Y _5251_/B VGND VGND VPWR VPWR _5400_/X
+ sky130_fd_sc_hd__o32a_2
Xclkload11 _9339_/CLK VGND VGND VPWR VPWR clkload11/X sky130_fd_sc_hd__clkbuf_8
Xclkload22 _9335_/CLK VGND VGND VPWR VPWR clkload22/X sky130_fd_sc_hd__clkbuf_4
X_6380_ _6261_/A _6261_/B _6220_/B _6220_/A VGND VGND VPWR VPWR _6380_/X sky130_fd_sc_hd__a211o_2
XFILLER_127_662 VGND VGND VPWR VPWR sky130_fd_sc_hd__decap_3
XFILLER_127_673 VGND VGND VPWR VPWR sky130_fd_sc_hd__decap_3
XFILLER_126_150 VGND VGND VPWR VPWR sky130_fd_sc_hd__decap_3
X_5331_ _5667_/S _6436_/B _5507_/A _5326_/X VGND VGND VPWR VPWR _5331_/X sky130_fd_sc_hd__o211a_2
XFILLER_114_312 VGND VGND VPWR VPWR sky130_fd_sc_hd__decap_3
XFILLER_126_183 VGND VGND VPWR VPWR sky130_fd_sc_hd__decap_3
X_8050_ _8050_/A _8050_/B VGND VGND VPWR VPWR _8050_/Y sky130_fd_sc_hd__nand2_2
XFILLER_5_491 VGND VGND VPWR VPWR sky130_fd_sc_hd__decap_3
XFILLER_114_345 VGND VGND VPWR VPWR sky130_fd_sc_hd__decap_3
X_5262_ _9135_/Q _5262_/B _6607_/C VGND VGND VPWR VPWR _5262_/X sky130_fd_sc_hd__and3_2
X_7001_ _6690_/A _6690_/B _6691_/A VGND VGND VPWR VPWR _7110_/A sky130_fd_sc_hd__o21bai_2
XFILLER_114_389 VGND VGND VPWR VPWR sky130_fd_sc_hd__decap_3
X_5193_ _7480_/C _5193_/B VGND VGND VPWR VPWR _5410_/A sky130_fd_sc_hd__nor2_2
XFILLER_68_421 VGND VGND VPWR VPWR sky130_fd_sc_hd__decap_3
XFILLER_96_752 VGND VGND VPWR VPWR sky130_fd_sc_hd__decap_3
XFILLER_96_763 VGND VGND VPWR VPWR sky130_fd_sc_hd__decap_3
XFILLER_110_540 VGND VGND VPWR VPWR sky130_fd_sc_hd__decap_3
XTAP_TAPCELL_ROW_39_803 VGND VPWR sky130_fd_sc_hd__tapvpwrvgnd_1
XFILLER_18_18 VGND VGND VPWR VPWR sky130_fd_sc_hd__decap_3
XTAP_TAPCELL_ROW_39_814 VGND VPWR sky130_fd_sc_hd__tapvpwrvgnd_1
XFILLER_56_627 VGND VGND VPWR VPWR sky130_fd_sc_hd__decap_3
XFILLER_18_29 VGND VGND VPWR VPWR sky130_fd_sc_hd__decap_3
XFILLER_83_413 VGND VGND VPWR VPWR sky130_fd_sc_hd__decap_3
XFILLER_95_284 VGND VGND VPWR VPWR sky130_fd_sc_hd__decap_3
XFILLER_68_498 VGND VGND VPWR VPWR sky130_fd_sc_hd__decap_3
X_8952_ _8952_/A VGND VGND VPWR VPWR _9317_/D sky130_fd_sc_hd__buf_1
XFILLER_110_595 VGND VGND VPWR VPWR sky130_fd_sc_hd__decap_3
XFILLER_83_446 VGND VGND VPWR VPWR sky130_fd_sc_hd__fill_2
XTAP_TAPCELL_ROW_108_1742 VGND VPWR sky130_fd_sc_hd__tapvpwrvgnd_1
X_7903_ _7651_/A _7899_/Y _7902_/X VGND VGND VPWR VPWR _7991_/A sky130_fd_sc_hd__a21o_2
X_8883_ _9285_/Q hold852/X _8883_/S VGND VGND VPWR VPWR _8883_/X sky130_fd_sc_hd__mux2_2
XFILLER_83_479 VGND VGND VPWR VPWR sky130_fd_sc_hd__decap_3
X_7834_ _9129_/Q wire172/X _5457_/X _9301_/Q VGND VGND VPWR VPWR _7908_/A sky130_fd_sc_hd__a22oi_2
XTAP_TAPCELL_ROW_121_1920 VGND VPWR sky130_fd_sc_hd__tapvpwrvgnd_1
XFILLER_24_546 VGND VGND VPWR VPWR sky130_fd_sc_hd__decap_3
XFILLER_51_332 VGND VGND VPWR VPWR sky130_fd_sc_hd__decap_3
XFILLER_51_343 VGND VGND VPWR VPWR sky130_fd_sc_hd__decap_3
X_7765_ _7619_/A _7762_/Y _7764_/Y _7590_/A VGND VGND VPWR VPWR _7765_/X sky130_fd_sc_hd__a211o_2
XFILLER_12_719 VGND VGND VPWR VPWR sky130_fd_sc_hd__decap_3
X_4977_ _8777_/B _6239_/A VGND VGND VPWR VPWR _8780_/D sky130_fd_sc_hd__nand2_2
X_6716_ wire160/X _5165_/B _6305_/B VGND VGND VPWR VPWR _6718_/A sky130_fd_sc_hd__a21o_2
X_7696_ _7857_/A _7696_/B VGND VGND VPWR VPWR _7697_/B sky130_fd_sc_hd__xnor2_2
Xclkload5 clkload5/A VGND VGND VPWR VPWR clkload5/X sky130_fd_sc_hd__clkbuf_4
XFILLER_20_752 VGND VGND VPWR VPWR sky130_fd_sc_hd__decap_3
XFILLER_20_763 VGND VGND VPWR VPWR sky130_fd_sc_hd__decap_3
X_6647_ _6382_/A _6376_/A _6376_/B _6382_/B VGND VGND VPWR VPWR _6647_/X sky130_fd_sc_hd__a31o_2
XFILLER_50_27 VGND VGND VPWR VPWR sky130_fd_sc_hd__fill_1
XFILLER_50_38 VGND VGND VPWR VPWR sky130_fd_sc_hd__decap_3
X_6578_ _6579_/A _6578_/B VGND VGND VPWR VPWR _6578_/Y sky130_fd_sc_hd__nor2_2
XFILLER_118_651 VGND VGND VPWR VPWR sky130_fd_sc_hd__decap_3
XTAP_TAPCELL_ROW_119_1882 VGND VPWR sky130_fd_sc_hd__tapvpwrvgnd_1
XFILLER_124_109 VGND VGND VPWR VPWR sky130_fd_sc_hd__decap_3
X_8317_ _8408_/A _8408_/B wire88/X VGND VGND VPWR VPWR _8319_/B sky130_fd_sc_hd__o21ai_2
XTAP_TAPCELL_ROW_119_1893 VGND VPWR sky130_fd_sc_hd__tapvpwrvgnd_1
X_5529_ _5529_/A _5529_/B VGND VGND VPWR VPWR _5529_/X sky130_fd_sc_hd__and2_2
XFILLER_105_312 VGND VGND VPWR VPWR sky130_fd_sc_hd__decap_3
X_9297_ _9313_/CLK _9297_/D fanout391/X VGND VGND VPWR VPWR _9297_/Q sky130_fd_sc_hd__dfrtp_2
XFILLER_117_172 VGND VGND VPWR VPWR sky130_fd_sc_hd__decap_3
XFILLER_59_14 VGND VGND VPWR VPWR sky130_fd_sc_hd__fill_1
XFILLER_105_345 VGND VGND VPWR VPWR sky130_fd_sc_hd__decap_3
XFILLER_59_25 VGND VGND VPWR VPWR sky130_fd_sc_hd__decap_3
X_8248_ _8421_/A _8248_/B VGND VGND VPWR VPWR _8249_/B sky130_fd_sc_hd__nor2_1
XFILLER_59_47 VGND VGND VPWR VPWR sky130_fd_sc_hd__fill_2
XFILLER_105_378 VGND VGND VPWR VPWR sky130_fd_sc_hd__decap_3
XFILLER_120_315 VGND VGND VPWR VPWR sky130_fd_sc_hd__decap_3
X_8179_ _8179_/A _8179_/B VGND VGND VPWR VPWR _8180_/B sky130_fd_sc_hd__xnor2_2
XFILLER_120_326 VGND VGND VPWR VPWR sky130_fd_sc_hd__decap_3
Xfanout242 _9236_/Q VGND VGND VPWR VPWR wire243/A sky130_fd_sc_hd__buf_6
XFILLER_59_432 VGND VGND VPWR VPWR sky130_fd_sc_hd__decap_3
XFILLER_115_42 VGND VGND VPWR VPWR sky130_fd_sc_hd__decap_3
XFILLER_75_13 VGND VGND VPWR VPWR sky130_fd_sc_hd__decap_3
Xfanout286 input6/X VGND VGND VPWR VPWR _7877_/A sky130_fd_sc_hd__clkdlybuf4s25_1
XFILLER_115_75 VGND VGND VPWR VPWR sky130_fd_sc_hd__decap_3
XFILLER_46_104 VGND VGND VPWR VPWR sky130_fd_sc_hd__decap_3
XFILLER_74_424 VGND VGND VPWR VPWR sky130_fd_sc_hd__fill_1
XFILLER_75_57 VGND VGND VPWR VPWR sky130_fd_sc_hd__fill_1
XFILLER_74_446 VGND VGND VPWR VPWR sky130_fd_sc_hd__decap_3
XFILLER_27_340 VGND VGND VPWR VPWR sky130_fd_sc_hd__decap_3
XTAP_TAPCELL_ROW_17_508 VGND VPWR sky130_fd_sc_hd__tapvpwrvgnd_1
XTAP_TAPCELL_ROW_83_1403 VGND VPWR sky130_fd_sc_hd__tapvpwrvgnd_1
XFILLER_55_671 VGND VGND VPWR VPWR sky130_fd_sc_hd__fill_1
XFILLER_27_373 VGND VGND VPWR VPWR sky130_fd_sc_hd__fill_2
XFILLER_55_693 VGND VGND VPWR VPWR sky130_fd_sc_hd__decap_3
XFILLER_82_490 VGND VGND VPWR VPWR sky130_fd_sc_hd__decap_3
XFILLER_42_321 VGND VGND VPWR VPWR sky130_fd_sc_hd__decap_3
XFILLER_15_546 VGND VGND VPWR VPWR sky130_fd_sc_hd__decap_3
XFILLER_70_663 VGND VGND VPWR VPWR sky130_fd_sc_hd__fill_1
XFILLER_42_365 VGND VGND VPWR VPWR sky130_fd_sc_hd__decap_3
XFILLER_30_527 VGND VGND VPWR VPWR sky130_fd_sc_hd__decap_3
XFILLER_24_50 VGND VGND VPWR VPWR sky130_fd_sc_hd__decap_3
XFILLER_42_398 VGND VGND VPWR VPWR sky130_fd_sc_hd__decap_3
XFILLER_11_741 VGND VGND VPWR VPWR sky130_fd_sc_hd__decap_3
XFILLER_7_701 VGND VGND VPWR VPWR sky130_fd_sc_hd__decap_3
XFILLER_10_240 VGND VGND VPWR VPWR sky130_fd_sc_hd__decap_3
XFILLER_6_200 VGND VGND VPWR VPWR sky130_fd_sc_hd__decap_3
XFILLER_11_774 VGND VGND VPWR VPWR sky130_fd_sc_hd__decap_3
XFILLER_109_640 VGND VGND VPWR VPWR sky130_fd_sc_hd__decap_3
XFILLER_7_756 VGND VGND VPWR VPWR sky130_fd_sc_hd__decap_3
XFILLER_6_244 VGND VGND VPWR VPWR sky130_fd_sc_hd__decap_3
XFILLER_109_673 VGND VGND VPWR VPWR sky130_fd_sc_hd__decap_3
XFILLER_6_288 VGND VGND VPWR VPWR sky130_fd_sc_hd__decap_3
XFILLER_40_82 VGND VGND VPWR VPWR sky130_fd_sc_hd__fill_2
XTAP_TAPCELL_ROW_94_1554 VGND VPWR sky130_fd_sc_hd__tapvpwrvgnd_1
XFILLER_124_643 VGND VGND VPWR VPWR sky130_fd_sc_hd__fill_1
XFILLER_123_131 VGND VGND VPWR VPWR sky130_fd_sc_hd__decap_3
XFILLER_97_505 VGND VGND VPWR VPWR sky130_fd_sc_hd__decap_3
XFILLER_69_207 VGND VGND VPWR VPWR sky130_fd_sc_hd__decap_3
XFILLER_123_164 VGND VGND VPWR VPWR sky130_fd_sc_hd__decap_3
XFILLER_123_175 VGND VGND VPWR VPWR sky130_fd_sc_hd__decap_3
XFILLER_111_326 VGND VGND VPWR VPWR sky130_fd_sc_hd__decap_3
XFILLER_78_730 VGND VGND VPWR VPWR sky130_fd_sc_hd__decap_3
XFILLER_2_483 VGND VGND VPWR VPWR sky130_fd_sc_hd__fill_2
XFILLER_2_494 VGND VGND VPWR VPWR sky130_fd_sc_hd__decap_3
XFILLER_78_752 VGND VGND VPWR VPWR sky130_fd_sc_hd__decap_3
XFILLER_27_6 VGND VGND VPWR VPWR sky130_fd_sc_hd__decap_3
XFILLER_38_605 VGND VGND VPWR VPWR sky130_fd_sc_hd__decap_3
XFILLER_93_700 VGND VGND VPWR VPWR sky130_fd_sc_hd__fill_2
XFILLER_1_21 VGND VGND VPWR VPWR sky130_fd_sc_hd__decap_3
XFILLER_77_284 VGND VGND VPWR VPWR sky130_fd_sc_hd__fill_1
XFILLER_93_744 VGND VGND VPWR VPWR sky130_fd_sc_hd__decap_3
XFILLER_92_221 VGND VGND VPWR VPWR sky130_fd_sc_hd__decap_3
XFILLER_1_54 VGND VGND VPWR VPWR sky130_fd_sc_hd__fill_2
XFILLER_37_159 VGND VGND VPWR VPWR sky130_fd_sc_hd__decap_3
XFILLER_80_405 VGND VGND VPWR VPWR sky130_fd_sc_hd__decap_3
XFILLER_52_107 VGND VGND VPWR VPWR sky130_fd_sc_hd__decap_3
X_4900_ _4876_/A _4899_/Y _4878_/A hold810/X VGND VGND VPWR VPWR _4900_/X sky130_fd_sc_hd__a2bb2o_2
X_5880_ _9312_/Q _5880_/B _6607_/C VGND VGND VPWR VPWR _5880_/X sky130_fd_sc_hd__and3_2
X_4831_ _4831_/A VGND VGND VPWR VPWR _9160_/D sky130_fd_sc_hd__buf_1
XFILLER_21_505 VGND VGND VPWR VPWR sky130_fd_sc_hd__fill_2
XTAP_TAPCELL_ROW_44_872 VGND VPWR sky130_fd_sc_hd__tapvpwrvgnd_1
XFILLER_60_162 VGND VGND VPWR VPWR sky130_fd_sc_hd__decap_3
XFILLER_21_527 VGND VGND VPWR VPWR sky130_fd_sc_hd__decap_3
XTAP_TAPCELL_ROW_103_1672 VGND VPWR sky130_fd_sc_hd__tapvpwrvgnd_1
X_7550_ _7550_/A _7550_/B VGND VGND VPWR VPWR _7554_/A sky130_fd_sc_hd__xnor2_2
X_4762_ _4762_/A VGND VGND VPWR VPWR _9127_/D sky130_fd_sc_hd__buf_1
X_6501_ _6501_/A _6885_/B VGND VGND VPWR VPWR _6501_/Y sky130_fd_sc_hd__nor2_2
X_7481_ _7479_/Y _7480_/X _7481_/S VGND VGND VPWR VPWR _7482_/B sky130_fd_sc_hd__mux2_2
XFILLER_119_426 VGND VGND VPWR VPWR sky130_fd_sc_hd__decap_3
X_4693_ _4727_/A1 _4693_/A1 _4693_/S VGND VGND VPWR VPWR _4694_/A sky130_fd_sc_hd__mux2_2
X_9220_ _9223_/CLK _9220_/D load_slew420/X VGND VGND VPWR VPWR _9220_/Q sky130_fd_sc_hd__dfrtp_2
X_6432_ _7877_/A _6432_/B VGND VGND VPWR VPWR _6433_/B sky130_fd_sc_hd__xnor2_2
X_9151_ _9171_/CLK _9151_/D load_slew393/X VGND VGND VPWR VPWR _9151_/Q sky130_fd_sc_hd__dfrtp_2
XFILLER_127_470 VGND VGND VPWR VPWR sky130_fd_sc_hd__decap_3
XFILLER_115_610 VGND VGND VPWR VPWR sky130_fd_sc_hd__decap_3
X_6363_ _6363_/A _6363_/B _6363_/C VGND VGND VPWR VPWR _6374_/A sky130_fd_sc_hd__and3_4
X_8102_ _8271_/A _8104_/C _8083_/Y _9217_/Q VGND VGND VPWR VPWR _8102_/X sky130_fd_sc_hd__o211a_2
XFILLER_115_643 VGND VGND VPWR VPWR sky130_fd_sc_hd__decap_3
X_5314_ _5314_/A VGND VGND VPWR VPWR _9201_/D sky130_fd_sc_hd__buf_1
XTAP_TAPCELL_ROW_54_1004 VGND VPWR sky130_fd_sc_hd__tapvpwrvgnd_1
X_9082_ _9343_/CLK _9082_/D load_slew401/X VGND VGND VPWR VPWR _9082_/Q sky130_fd_sc_hd__dfrtp_2
X_6294_ _6293_/A _6293_/B _6169_/Y _6170_/X VGND VGND VPWR VPWR _6294_/X sky130_fd_sc_hd__a2bb2o_4
XTAP_TAPCELL_ROW_54_1015 VGND VPWR sky130_fd_sc_hd__tapvpwrvgnd_1
XFILLER_115_676 VGND VGND VPWR VPWR sky130_fd_sc_hd__decap_3
XFILLER_88_516 VGND VGND VPWR VPWR sky130_fd_sc_hd__decap_3
XFILLER_114_153 VGND VGND VPWR VPWR sky130_fd_sc_hd__decap_3
XFILLER_130_613 VGND VGND VPWR VPWR sky130_fd_sc_hd__decap_3
X_8033_ _8011_/A _8035_/S _7877_/X _7885_/Y VGND VGND VPWR VPWR _8034_/B sky130_fd_sc_hd__a31o_2
X_5245_ _5210_/B _5241_/Y _5243_/X _5244_/Y VGND VGND VPWR VPWR _5245_/X sky130_fd_sc_hd__o211a_2
XFILLER_88_549 VGND VGND VPWR VPWR sky130_fd_sc_hd__decap_3
XFILLER_130_635 VGND VGND VPWR VPWR sky130_fd_sc_hd__decap_3
XFILLER_29_28 VGND VGND VPWR VPWR sky130_fd_sc_hd__decap_3
XFILLER_130_657 VGND VGND VPWR VPWR sky130_fd_sc_hd__decap_3
XFILLER_69_752 VGND VGND VPWR VPWR sky130_fd_sc_hd__decap_3
XFILLER_130_679 VGND VGND VPWR VPWR sky130_fd_sc_hd__decap_3
X_5176_ _9134_/Q _5879_/B _5875_/C VGND VGND VPWR VPWR _5176_/X sky130_fd_sc_hd__and3_2
XFILLER_56_424 VGND VGND VPWR VPWR sky130_fd_sc_hd__decap_3
XFILLER_56_468 VGND VGND VPWR VPWR sky130_fd_sc_hd__decap_3
XFILLER_28_159 VGND VGND VPWR VPWR sky130_fd_sc_hd__decap_3
X_8935_ _8935_/A VGND VGND VPWR VPWR _9309_/D sky130_fd_sc_hd__buf_1
XFILLER_45_27 VGND VGND VPWR VPWR sky130_fd_sc_hd__decap_3
XFILLER_83_276 VGND VGND VPWR VPWR sky130_fd_sc_hd__decap_3
XFILLER_45_49 VGND VGND VPWR VPWR sky130_fd_sc_hd__decap_3
XFILLER_37_682 VGND VGND VPWR VPWR sky130_fd_sc_hd__decap_3
X_8866_ _8866_/A VGND VGND VPWR VPWR _9276_/D sky130_fd_sc_hd__buf_1
XFILLER_52_630 VGND VGND VPWR VPWR sky130_fd_sc_hd__fill_1
XFILLER_24_321 VGND VGND VPWR VPWR sky130_fd_sc_hd__decap_3
XTAP_TAPCELL_ROW_65_1155 VGND VPWR sky130_fd_sc_hd__tapvpwrvgnd_1
X_7817_ _7582_/A _7815_/Y _7816_/Y VGND VGND VPWR VPWR _7824_/A sky130_fd_sc_hd__a21o_2
XFILLER_24_365 VGND VGND VPWR VPWR sky130_fd_sc_hd__decap_3
X_8797_ _9244_/Q hold759/X _8799_/S VGND VGND VPWR VPWR _8797_/X sky130_fd_sc_hd__mux2_2
XFILLER_51_151 VGND VGND VPWR VPWR sky130_fd_sc_hd__decap_3
XFILLER_12_516 VGND VGND VPWR VPWR sky130_fd_sc_hd__decap_3
XFILLER_52_685 VGND VGND VPWR VPWR sky130_fd_sc_hd__decap_3
XFILLER_101_66 VGND VGND VPWR VPWR sky130_fd_sc_hd__decap_3
XFILLER_61_15 VGND VGND VPWR VPWR sky130_fd_sc_hd__decap_3
XFILLER_12_527 VGND VGND VPWR VPWR sky130_fd_sc_hd__decap_3
XFILLER_51_184 VGND VGND VPWR VPWR sky130_fd_sc_hd__fill_1
X_7748_ _7746_/Y _7747_/X _7748_/S VGND VGND VPWR VPWR _7748_/X sky130_fd_sc_hd__mux2_2
X_7679_ _7871_/A _7679_/B VGND VGND VPWR VPWR _7683_/A sky130_fd_sc_hd__xnor2_2
XTAP_TAPCELL_ROW_22_577 VGND VPWR sky130_fd_sc_hd__tapvpwrvgnd_1
XFILLER_20_560 VGND VGND VPWR VPWR sky130_fd_sc_hd__fill_1
XFILLER_4_704 VGND VGND VPWR VPWR sky130_fd_sc_hd__decap_3
XPHY_EDGE_ROW_128_Left_259 VGND VGND VPWR VPWR sky130_fd_sc_hd__decap_3
XFILLER_106_610 VGND VGND VPWR VPWR sky130_fd_sc_hd__fill_2
XFILLER_3_203 VGND VGND VPWR VPWR sky130_fd_sc_hd__decap_3
XFILLER_4_737 VGND VGND VPWR VPWR sky130_fd_sc_hd__decap_3
XFILLER_3_214 VGND VGND VPWR VPWR sky130_fd_sc_hd__decap_3
XFILLER_3_225 VGND VGND VPWR VPWR sky130_fd_sc_hd__decap_3
XFILLER_118_492 VGND VGND VPWR VPWR sky130_fd_sc_hd__decap_3
XFILLER_106_643 VGND VGND VPWR VPWR sky130_fd_sc_hd__fill_1
XFILLER_10_41 VGND VGND VPWR VPWR sky130_fd_sc_hd__decap_3
XFILLER_106_665 VGND VGND VPWR VPWR sky130_fd_sc_hd__fill_2
XFILLER_79_505 VGND VGND VPWR VPWR sky130_fd_sc_hd__decap_3
XFILLER_105_164 VGND VGND VPWR VPWR sky130_fd_sc_hd__decap_3
XFILLER_106_687 VGND VGND VPWR VPWR sky130_fd_sc_hd__decap_3
XFILLER_126_41 VGND VGND VPWR VPWR sky130_fd_sc_hd__decap_3
XFILLER_10_74 VGND VGND VPWR VPWR sky130_fd_sc_hd__decap_3
XFILLER_105_175 VGND VGND VPWR VPWR sky130_fd_sc_hd__fill_1
XFILLER_79_538 VGND VGND VPWR VPWR sky130_fd_sc_hd__decap_3
XFILLER_10_96 VGND VGND VPWR VPWR sky130_fd_sc_hd__decap_3
XFILLER_86_12 VGND VGND VPWR VPWR sky130_fd_sc_hd__decap_3
XFILLER_121_635 VGND VGND VPWR VPWR sky130_fd_sc_hd__decap_3
XFILLER_120_112 VGND VGND VPWR VPWR sky130_fd_sc_hd__decap_3
XFILLER_126_74 VGND VGND VPWR VPWR sky130_fd_sc_hd__decap_3
XFILLER_126_85 VGND VGND VPWR VPWR sky130_fd_sc_hd__decap_3
XFILLER_121_679 VGND VGND VPWR VPWR sky130_fd_sc_hd__fill_2
XFILLER_120_156 VGND VGND VPWR VPWR sky130_fd_sc_hd__decap_3
XFILLER_47_402 VGND VGND VPWR VPWR sky130_fd_sc_hd__decap_3
XFILLER_87_582 VGND VGND VPWR VPWR sky130_fd_sc_hd__decap_3
XFILLER_19_104 VGND VGND VPWR VPWR sky130_fd_sc_hd__fill_1
XFILLER_120_189 VGND VGND VPWR VPWR sky130_fd_sc_hd__decap_3
XFILLER_59_284 VGND VGND VPWR VPWR sky130_fd_sc_hd__decap_3
XFILLER_19_50 VGND VGND VPWR VPWR sky130_fd_sc_hd__decap_3
XFILLER_19_83 VGND VGND VPWR VPWR sky130_fd_sc_hd__decap_3
XFILLER_47_468 VGND VGND VPWR VPWR sky130_fd_sc_hd__decap_3
XFILLER_35_608 VGND VGND VPWR VPWR sky130_fd_sc_hd__decap_3
XFILLER_19_159 VGND VGND VPWR VPWR sky130_fd_sc_hd__decap_3
XFILLER_28_671 VGND VGND VPWR VPWR sky130_fd_sc_hd__fill_2
XFILLER_90_736 VGND VGND VPWR VPWR sky130_fd_sc_hd__fill_1
XFILLER_62_427 VGND VGND VPWR VPWR sky130_fd_sc_hd__decap_3
XFILLER_34_129 VGND VGND VPWR VPWR sky130_fd_sc_hd__fill_2
XFILLER_15_343 VGND VGND VPWR VPWR sky130_fd_sc_hd__decap_3
XFILLER_35_60 VGND VGND VPWR VPWR sky130_fd_sc_hd__fill_1
XFILLER_70_460 VGND VGND VPWR VPWR sky130_fd_sc_hd__decap_3
XFILLER_43_685 VGND VGND VPWR VPWR sky130_fd_sc_hd__decap_3
XFILLER_42_162 VGND VGND VPWR VPWR sky130_fd_sc_hd__decap_3
XFILLER_15_387 VGND VGND VPWR VPWR sky130_fd_sc_hd__decap_3
XTAP_TAPCELL_ROW_41_831 VGND VPWR sky130_fd_sc_hd__tapvpwrvgnd_1
XFILLER_30_335 VGND VGND VPWR VPWR sky130_fd_sc_hd__decap_3
XFILLER_30_368 VGND VGND VPWR VPWR sky130_fd_sc_hd__decap_3
XFILLER_129_724 VGND VGND VPWR VPWR sky130_fd_sc_hd__decap_3
XFILLER_129_735 VGND VGND VPWR VPWR sky130_fd_sc_hd__decap_3
XFILLER_128_212 VGND VGND VPWR VPWR sky130_fd_sc_hd__decap_3
XFILLER_129_768 VGND VGND VPWR VPWR sky130_fd_sc_hd__decap_3
XFILLER_51_81 VGND VGND VPWR VPWR sky130_fd_sc_hd__decap_3
XFILLER_7_553 VGND VGND VPWR VPWR sky130_fd_sc_hd__decap_3
XFILLER_128_256 VGND VGND VPWR VPWR sky130_fd_sc_hd__fill_1
XFILLER_116_407 VGND VGND VPWR VPWR sky130_fd_sc_hd__decap_3
Xmax_cap206 _5110_/Y VGND VGND VPWR VPWR _5259_/B1 sky130_fd_sc_hd__buf_1
Xmax_cap217 _4513_/Y VGND VGND VPWR VPWR _4515_/A sky130_fd_sc_hd__buf_6
XFILLER_109_470 VGND VGND VPWR VPWR sky130_fd_sc_hd__decap_3
XFILLER_7_586 VGND VGND VPWR VPWR sky130_fd_sc_hd__decap_3
XFILLER_97_302 VGND VGND VPWR VPWR sky130_fd_sc_hd__decap_3
Xload_slew401 fanout400/X VGND VGND VPWR VPWR load_slew401/X sky130_fd_sc_hd__buf_2
Xload_slew412 fanout410/X VGND VGND VPWR VPWR fanout407/A sky130_fd_sc_hd__clkbuf_4
X_5030_ _7181_/A VGND VGND VPWR VPWR _6096_/A sky130_fd_sc_hd__inv_2
XFILLER_85_508 VGND VGND VPWR VPWR sky130_fd_sc_hd__decap_3
XFILLER_25_3 VGND VGND VPWR VPWR sky130_fd_sc_hd__decap_3
XFILLER_112_679 VGND VGND VPWR VPWR sky130_fd_sc_hd__fill_1
Xhold1209 _5529_/X VGND VGND VPWR VPWR _5530_/A1 sky130_fd_sc_hd__dlygate4sd3_1
XFILLER_38_402 VGND VGND VPWR VPWR sky130_fd_sc_hd__fill_1
XFILLER_38_424 VGND VGND VPWR VPWR sky130_fd_sc_hd__decap_3
XFILLER_111_189 VGND VGND VPWR VPWR sky130_fd_sc_hd__decap_3
XFILLER_38_435 VGND VGND VPWR VPWR sky130_fd_sc_hd__decap_3
XTAP_TAPCELL_ROW_49_942 VGND VPWR sky130_fd_sc_hd__tapvpwrvgnd_1
XFILLER_66_755 VGND VGND VPWR VPWR sky130_fd_sc_hd__fill_1
XFILLER_66_766 VGND VGND VPWR VPWR sky130_fd_sc_hd__decap_3
XFILLER_38_468 VGND VGND VPWR VPWR sky130_fd_sc_hd__decap_3
X_6981_ _7036_/A _7036_/B _6982_/C VGND VGND VPWR VPWR _6981_/X sky130_fd_sc_hd__a21o_2
XFILLER_19_660 VGND VGND VPWR VPWR sky130_fd_sc_hd__fill_1
XFILLER_81_725 VGND VGND VPWR VPWR sky130_fd_sc_hd__decap_3
XFILLER_53_416 VGND VGND VPWR VPWR sky130_fd_sc_hd__decap_3
XFILLER_25_107 VGND VGND VPWR VPWR sky130_fd_sc_hd__decap_3
XFILLER_19_671 VGND VGND VPWR VPWR sky130_fd_sc_hd__fill_1
XTAP_TAPCELL_ROW_105_1701 VGND VPWR sky130_fd_sc_hd__tapvpwrvgnd_1
XFILLER_93_596 VGND VGND VPWR VPWR sky130_fd_sc_hd__fill_2
X_5932_ _5927_/X _5929_/Y _5931_/X _6084_/A VGND VGND VPWR VPWR _5932_/X sky130_fd_sc_hd__a22o_2
X_8720_ _8707_/A _8718_/A _8672_/B VGND VGND VPWR VPWR _8720_/X sky130_fd_sc_hd__o21ba_2
XFILLER_53_449 VGND VGND VPWR VPWR sky130_fd_sc_hd__decap_3
XFILLER_34_630 VGND VGND VPWR VPWR sky130_fd_sc_hd__decap_3
XFILLER_18_181 VGND VGND VPWR VPWR sky130_fd_sc_hd__decap_3
XFILLER_80_246 VGND VGND VPWR VPWR sky130_fd_sc_hd__fill_2
X_8651_ _8642_/Y _8648_/X _8650_/X _8516_/Y VGND VGND VPWR VPWR _8651_/X sky130_fd_sc_hd__a22o_2
XFILLER_33_140 VGND VGND VPWR VPWR sky130_fd_sc_hd__decap_3
X_5863_ _5863_/A _5863_/B VGND VGND VPWR VPWR _5863_/Y sky130_fd_sc_hd__nor2_2
XFILLER_34_685 VGND VGND VPWR VPWR sky130_fd_sc_hd__decap_3
XFILLER_33_162 VGND VGND VPWR VPWR sky130_fd_sc_hd__decap_3
X_7602_ _7602_/A _7602_/B VGND VGND VPWR VPWR _7602_/Y sky130_fd_sc_hd__nor2_2
XFILLER_61_482 VGND VGND VPWR VPWR sky130_fd_sc_hd__decap_3
XFILLER_21_313 VGND VGND VPWR VPWR sky130_fd_sc_hd__decap_3
X_4814_ _4814_/A VGND VGND VPWR VPWR _9152_/D sky130_fd_sc_hd__buf_1
X_8582_ wire313/X _8581_/Y _7561_/A _8774_/C1 VGND VGND VPWR VPWR _8582_/X sky130_fd_sc_hd__o211a_2
XFILLER_21_335 VGND VGND VPWR VPWR sky130_fd_sc_hd__fill_1
X_5794_ _5939_/S _5794_/B VGND VGND VPWR VPWR _5794_/Y sky130_fd_sc_hd__xnor2_4
X_7533_ _7533_/A _7533_/B VGND VGND VPWR VPWR _8035_/S sky130_fd_sc_hd__nand2_2
X_4745_ _4745_/A VGND VGND VPWR VPWR _9119_/D sky130_fd_sc_hd__buf_1
Xrebuffer606 _8512_/X VGND VGND VPWR VPWR _8543_/A sky130_fd_sc_hd__buf_2
XFILLER_21_379 VGND VGND VPWR VPWR sky130_fd_sc_hd__decap_3
XFILLER_31_29 VGND VGND VPWR VPWR sky130_fd_sc_hd__decap_3
XTAP_TAPCELL_ROW_60_1085 VGND VPWR sky130_fd_sc_hd__tapvpwrvgnd_1
X_7464_ _7636_/B _7636_/C _7465_/A VGND VGND VPWR VPWR _7488_/A sky130_fd_sc_hd__a21oi_2
XTAP_TAPCELL_ROW_60_1096 VGND VPWR sky130_fd_sc_hd__tapvpwrvgnd_1
XFILLER_107_407 VGND VGND VPWR VPWR sky130_fd_sc_hd__decap_3
X_4676_ _4676_/A VGND VGND VPWR VPWR _9086_/D sky130_fd_sc_hd__buf_1
X_6415_ _6415_/A _7170_/S VGND VGND VPWR VPWR _6418_/A sky130_fd_sc_hd__xnor2_4
X_9203_ _9204_/CLK _9203_/D fanout415/A VGND VGND VPWR VPWR _9203_/Q sky130_fd_sc_hd__dfrtp_2
X_7395_ _7271_/X _7394_/Y _8117_/S VGND VGND VPWR VPWR _7396_/A sky130_fd_sc_hd__mux2_2
XTAP_TAPCELL_ROW_116_1841 VGND VPWR sky130_fd_sc_hd__tapvpwrvgnd_1
XTAP_TAPCELL_ROW_116_1852 VGND VPWR sky130_fd_sc_hd__tapvpwrvgnd_1
X_9134_ _9293_/CLK _9134_/D fanout383/X VGND VGND VPWR VPWR _9134_/Q sky130_fd_sc_hd__dfrtp_2
X_6346_ _6346_/A _6346_/B VGND VGND VPWR VPWR _7571_/A sky130_fd_sc_hd__nand2_8
Xoutput29 _9183_/Q VGND VGND VPWR VPWR wire225/A sky130_fd_sc_hd__buf_1
XFILLER_1_718 VGND VGND VPWR VPWR sky130_fd_sc_hd__decap_3
XFILLER_103_602 VGND VGND VPWR VPWR sky130_fd_sc_hd__decap_3
XFILLER_0_206 VGND VGND VPWR VPWR sky130_fd_sc_hd__fill_2
XFILLER_1_729 VGND VGND VPWR VPWR sky130_fd_sc_hd__decap_3
X_9065_ _9228_/CLK _9065_/D wire406/A VGND VGND VPWR VPWR _9065_/Q sky130_fd_sc_hd__dfrtp_2
XFILLER_103_646 VGND VGND VPWR VPWR sky130_fd_sc_hd__decap_3
X_6277_ _6274_/X _6275_/X _7445_/A _7955_/A VGND VGND VPWR VPWR _6560_/C sky130_fd_sc_hd__o211ai_2
XFILLER_130_421 VGND VGND VPWR VPWR sky130_fd_sc_hd__fill_1
X_8016_ _8015_/A _8015_/Y _8017_/A VGND VGND VPWR VPWR _8016_/X sky130_fd_sc_hd__mux2_2
XFILLER_76_508 VGND VGND VPWR VPWR sky130_fd_sc_hd__decap_3
X_5228_ _6395_/A _5538_/A VGND VGND VPWR VPWR _5228_/Y sky130_fd_sc_hd__nand2_2
XFILLER_57_711 VGND VGND VPWR VPWR sky130_fd_sc_hd__decap_3
XFILLER_102_178 VGND VGND VPWR VPWR sky130_fd_sc_hd__decap_3
XFILLER_29_413 VGND VGND VPWR VPWR sky130_fd_sc_hd__fill_1
XFILLER_130_498 VGND VGND VPWR VPWR sky130_fd_sc_hd__decap_3
XFILLER_56_26 VGND VGND VPWR VPWR sky130_fd_sc_hd__fill_2
X_5159_ _5160_/A _5160_/B VGND VGND VPWR VPWR _5159_/X sky130_fd_sc_hd__and2_2
XFILLER_84_530 VGND VGND VPWR VPWR sky130_fd_sc_hd__fill_2
XFILLER_57_755 VGND VGND VPWR VPWR sky130_fd_sc_hd__decap_3
XFILLER_29_479 VGND VGND VPWR VPWR sky130_fd_sc_hd__decap_3
XFILLER_84_585 VGND VGND VPWR VPWR sky130_fd_sc_hd__decap_3
XFILLER_16_107 VGND VGND VPWR VPWR sky130_fd_sc_hd__decap_3
XFILLER_112_21 VGND VGND VPWR VPWR sky130_fd_sc_hd__decap_3
XFILLER_112_32 VGND VGND VPWR VPWR sky130_fd_sc_hd__decap_3
XFILLER_72_747 VGND VGND VPWR VPWR sky130_fd_sc_hd__fill_2
XFILLER_44_438 VGND VGND VPWR VPWR sky130_fd_sc_hd__fill_2
X_8918_ _8918_/A VGND VGND VPWR VPWR _9301_/D sky130_fd_sc_hd__buf_1
XTAP_TAPCELL_ROW_127_1992 VGND VPWR sky130_fd_sc_hd__tapvpwrvgnd_1
Xclkbuf_leaf_36_clk clkload1/A VGND VGND VPWR VPWR _9204_/CLK sky130_fd_sc_hd__clkbuf_8
XTAP_TAPCELL_ROW_27_647 VGND VPWR sky130_fd_sc_hd__tapvpwrvgnd_1
XFILLER_112_65 VGND VGND VPWR VPWR sky130_fd_sc_hd__fill_2
X_8849_ _8849_/A VGND VGND VPWR VPWR _9268_/D sky130_fd_sc_hd__buf_1
XFILLER_52_493 VGND VGND VPWR VPWR sky130_fd_sc_hd__decap_3
XFILLER_12_335 VGND VGND VPWR VPWR sky130_fd_sc_hd__fill_1
XFILLER_24_195 VGND VGND VPWR VPWR sky130_fd_sc_hd__fill_1
XFILLER_12_357 VGND VGND VPWR VPWR sky130_fd_sc_hd__decap_3
XFILLER_20_390 VGND VGND VPWR VPWR sky130_fd_sc_hd__fill_1
XFILLER_126_716 VGND VGND VPWR VPWR sky130_fd_sc_hd__decap_3
XTAP_TAPCELL_ROW_78_1335 VGND VPWR sky130_fd_sc_hd__tapvpwrvgnd_1
XFILLER_126_749 VGND VGND VPWR VPWR sky130_fd_sc_hd__decap_3
XFILLER_125_237 VGND VGND VPWR VPWR sky130_fd_sc_hd__decap_3
XFILLER_4_545 VGND VGND VPWR VPWR sky130_fd_sc_hd__fill_1
XFILLER_106_451 VGND VGND VPWR VPWR sky130_fd_sc_hd__decap_3
XTAP_TAPCELL_ROW_91_1513 VGND VPWR sky130_fd_sc_hd__tapvpwrvgnd_1
XFILLER_106_473 VGND VGND VPWR VPWR sky130_fd_sc_hd__decap_3
XFILLER_4_589 VGND VGND VPWR VPWR sky130_fd_sc_hd__fill_1
XFILLER_121_410 VGND VGND VPWR VPWR sky130_fd_sc_hd__decap_3
XFILLER_106_495 VGND VGND VPWR VPWR sky130_fd_sc_hd__decap_3
XTAP_TAPCELL_ROW_7_372 VGND VPWR sky130_fd_sc_hd__tapvpwrvgnd_1
XFILLER_67_519 VGND VGND VPWR VPWR sky130_fd_sc_hd__decap_3
XFILLER_121_487 VGND VGND VPWR VPWR sky130_fd_sc_hd__decap_3
XFILLER_102_690 VGND VGND VPWR VPWR sky130_fd_sc_hd__decap_3
XFILLER_47_221 VGND VGND VPWR VPWR sky130_fd_sc_hd__decap_3
XFILLER_11_9 VGND VGND VPWR VPWR sky130_fd_sc_hd__decap_3
XFILLER_75_552 VGND VGND VPWR VPWR sky130_fd_sc_hd__decap_3
XTAP_TAPCELL_ROW_46_901 VGND VPWR sky130_fd_sc_hd__tapvpwrvgnd_1
XFILLER_63_714 VGND VGND VPWR VPWR sky130_fd_sc_hd__decap_3
XFILLER_35_405 VGND VGND VPWR VPWR sky130_fd_sc_hd__decap_3
XTAP_TAPCELL_ROW_89_1486 VGND VPWR sky130_fd_sc_hd__tapvpwrvgnd_1
XFILLER_47_276 VGND VGND VPWR VPWR sky130_fd_sc_hd__decap_3
XFILLER_90_522 VGND VGND VPWR VPWR sky130_fd_sc_hd__decap_3
XFILLER_35_438 VGND VGND VPWR VPWR sky130_fd_sc_hd__decap_3
Xmax_cap60 _8560_/B VGND VGND VPWR VPWR _8655_/B sky130_fd_sc_hd__buf_2
Xclkbuf_leaf_27_clk clkload2/A VGND VGND VPWR VPWR _9334_/CLK sky130_fd_sc_hd__clkbuf_8
XFILLER_90_544 VGND VGND VPWR VPWR sky130_fd_sc_hd__decap_3
XFILLER_16_641 VGND VGND VPWR VPWR sky130_fd_sc_hd__decap_3
Xmax_cap82 _7159_/A VGND VGND VPWR VPWR _6891_/A sky130_fd_sc_hd__buf_2
Xmax_cap93 _7422_/B VGND VGND VPWR VPWR _6939_/B sky130_fd_sc_hd__buf_6
XFILLER_15_151 VGND VGND VPWR VPWR sky130_fd_sc_hd__decap_3
XFILLER_15_162 VGND VGND VPWR VPWR sky130_fd_sc_hd__decap_3
XFILLER_94_6 VGND VGND VPWR VPWR sky130_fd_sc_hd__decap_3
XFILLER_30_110 VGND VGND VPWR VPWR sky130_fd_sc_hd__decap_3
XFILLER_15_184 VGND VGND VPWR VPWR sky130_fd_sc_hd__decap_3
XTAP_TAPCELL_ROW_100_1631 VGND VPWR sky130_fd_sc_hd__tapvpwrvgnd_1
XFILLER_31_688 VGND VGND VPWR VPWR sky130_fd_sc_hd__fill_1
XFILLER_30_165 VGND VGND VPWR VPWR sky130_fd_sc_hd__fill_2
X_4530_ _9018_/Q hold839/X _4544_/S VGND VGND VPWR VPWR _4530_/X sky130_fd_sc_hd__mux2_2
XFILLER_117_705 VGND VGND VPWR VPWR sky130_fd_sc_hd__fill_1
XFILLER_7_42 VGND VGND VPWR VPWR sky130_fd_sc_hd__decap_3
XFILLER_11_390 VGND VGND VPWR VPWR sky130_fd_sc_hd__fill_2
XFILLER_129_576 VGND VGND VPWR VPWR sky130_fd_sc_hd__decap_3
XFILLER_117_727 VGND VGND VPWR VPWR sky130_fd_sc_hd__fill_1
XFILLER_7_97 VGND VGND VPWR VPWR sky130_fd_sc_hd__fill_1
X_6200_ _6041_/B _6041_/A _6199_/X VGND VGND VPWR VPWR _6203_/B sky130_fd_sc_hd__o21ai_2
X_7180_ _7181_/A _7182_/A1 _6418_/A VGND VGND VPWR VPWR _7180_/X sky130_fd_sc_hd__o21a_2
XFILLER_125_771 VGND VGND VPWR VPWR sky130_fd_sc_hd__decap_3
XFILLER_98_611 VGND VGND VPWR VPWR sky130_fd_sc_hd__decap_3
X_6131_ _6131_/A _6798_/S VGND VGND VPWR VPWR _6131_/Y sky130_fd_sc_hd__nor2_2
XFILLER_112_410 VGND VGND VPWR VPWR sky130_fd_sc_hd__decap_3
XFILLER_112_443 VGND VGND VPWR VPWR sky130_fd_sc_hd__decap_3
X_6062_ _6064_/A1 _5903_/A _5902_/Y VGND VGND VPWR VPWR _6063_/B sky130_fd_sc_hd__o21ai_2
XFILLER_98_688 VGND VGND VPWR VPWR sky130_fd_sc_hd__fill_2
XFILLER_85_305 VGND VGND VPWR VPWR sky130_fd_sc_hd__fill_2
XFILLER_112_465 VGND VGND VPWR VPWR sky130_fd_sc_hd__fill_2
Xload_slew253 _6206_/C VGND VGND VPWR VPWR _5106_/A1 sky130_fd_sc_hd__buf_2
XFILLER_39_700 VGND VGND VPWR VPWR sky130_fd_sc_hd__decap_3
Xload_slew264 _5196_/B VGND VGND VPWR VPWR _6206_/B sky130_fd_sc_hd__buf_4
Xhold1006 _9323_/Q VGND VGND VPWR VPWR _8997_/A1 sky130_fd_sc_hd__dlygate4sd3_1
XTAP_TAPCELL_ROW_111_1782 VGND VPWR sky130_fd_sc_hd__tapvpwrvgnd_1
Xload_slew275 _5949_/B VGND VGND VPWR VPWR _7181_/A sky130_fd_sc_hd__buf_2
Xhold1017 _4832_/X VGND VGND VPWR VPWR _4833_/A sky130_fd_sc_hd__dlygate4sd3_1
X_5013_ _6206_/A _4978_/Y _4981_/Y _5283_/A VGND VGND VPWR VPWR _5014_/A sky130_fd_sc_hd__a211oi_2
XFILLER_39_733 VGND VGND VPWR VPWR sky130_fd_sc_hd__decap_3
Xhold1028 _9023_/Q VGND VGND VPWR VPWR _4575_/A1 sky130_fd_sc_hd__dlygate4sd3_1
Xload_slew297 _7729_/C1 VGND VGND VPWR VPWR _7229_/A sky130_fd_sc_hd__buf_4
Xhold1039 _8953_/X VGND VGND VPWR VPWR _8954_/A sky130_fd_sc_hd__dlygate4sd3_1
XFILLER_66_530 VGND VGND VPWR VPWR sky130_fd_sc_hd__fill_2
XFILLER_38_243 VGND VGND VPWR VPWR sky130_fd_sc_hd__decap_3
XFILLER_66_563 VGND VGND VPWR VPWR sky130_fd_sc_hd__decap_3
XFILLER_66_585 VGND VGND VPWR VPWR sky130_fd_sc_hd__decap_3
XFILLER_26_416 VGND VGND VPWR VPWR sky130_fd_sc_hd__decap_3
XFILLER_53_213 VGND VGND VPWR VPWR sky130_fd_sc_hd__fill_1
XFILLER_38_287 VGND VGND VPWR VPWR sky130_fd_sc_hd__decap_3
XFILLER_26_427 VGND VGND VPWR VPWR sky130_fd_sc_hd__decap_3
XFILLER_26_29 VGND VGND VPWR VPWR sky130_fd_sc_hd__fill_1
XPHY_EDGE_ROW_5_Right_5 VGND VGND VPWR VPWR sky130_fd_sc_hd__decap_3
XFILLER_93_393 VGND VGND VPWR VPWR sky130_fd_sc_hd__decap_3
X_6964_ _6723_/A _6962_/X _6963_/X VGND VGND VPWR VPWR _6967_/A sky130_fd_sc_hd__o21ai_4
Xclkbuf_leaf_18_clk clkbuf_leaf_9_clk/A VGND VGND VPWR VPWR _9345_/CLK sky130_fd_sc_hd__clkbuf_8
XFILLER_81_577 VGND VGND VPWR VPWR sky130_fd_sc_hd__decap_3
X_8703_ _9227_/Q _8739_/B _8696_/X _8699_/X _8702_/X VGND VGND VPWR VPWR _8704_/B
+ sky130_fd_sc_hd__o311a_2
XTAP_TAPCELL_ROW_24_606 VGND VPWR sky130_fd_sc_hd__tapvpwrvgnd_1
X_5915_ _5815_/X _5914_/X _6270_/S VGND VGND VPWR VPWR _5916_/A sky130_fd_sc_hd__mux2_2
XFILLER_53_279 VGND VGND VPWR VPWR sky130_fd_sc_hd__fill_1
XFILLER_34_460 VGND VGND VPWR VPWR sky130_fd_sc_hd__decap_3
XFILLER_22_600 VGND VGND VPWR VPWR sky130_fd_sc_hd__decap_3
X_6895_ _6840_/B _6899_/B _6894_/Y VGND VGND VPWR VPWR _6895_/X sky130_fd_sc_hd__o21a_2
XTAP_TAPCELL_ROW_62_1114 VGND VPWR sky130_fd_sc_hd__tapvpwrvgnd_1
XTAP_TAPCELL_ROW_62_1125 VGND VPWR sky130_fd_sc_hd__tapvpwrvgnd_1
XFILLER_22_622 VGND VGND VPWR VPWR sky130_fd_sc_hd__decap_3
X_5846_ _5713_/Y _5711_/Y _5845_/X VGND VGND VPWR VPWR wire76/A sky130_fd_sc_hd__o21ai_2
X_8634_ _8512_/A _8577_/Y _8578_/Y VGND VGND VPWR VPWR _8636_/B sky130_fd_sc_hd__o21ai_2
XFILLER_22_666 VGND VGND VPWR VPWR sky130_fd_sc_hd__decap_3
X_5777_ hold847/X _5776_/X _6270_/S VGND VGND VPWR VPWR _5778_/A sky130_fd_sc_hd__mux2_2
X_8565_ _8521_/S _8559_/Y _8564_/X VGND VGND VPWR VPWR _8585_/A sky130_fd_sc_hd__a21o_2
Xrebuffer425 _9235_/Q VGND VGND VPWR VPWR _5989_/S sky130_fd_sc_hd__buf_4
XFILLER_21_198 VGND VGND VPWR VPWR sky130_fd_sc_hd__decap_3
X_4728_ _4728_/A VGND VGND VPWR VPWR _9111_/D sky130_fd_sc_hd__buf_1
X_7516_ _7661_/B _7659_/A VGND VGND VPWR VPWR _7518_/C sky130_fd_sc_hd__and2_2
Xrebuffer436 wire117/X VGND VGND VPWR VPWR _6626_/B sky130_fd_sc_hd__buf_2
X_8496_ _7569_/A _8177_/B _8496_/S VGND VGND VPWR VPWR _8496_/X sky130_fd_sc_hd__mux2_2
Xrebuffer447 _7566_/Y VGND VGND VPWR VPWR rebuffer447/X sky130_fd_sc_hd__buf_2
Xrebuffer458 _7404_/B VGND VGND VPWR VPWR _5276_/A sky130_fd_sc_hd__buf_2
Xrebuffer469 _5386_/Y VGND VGND VPWR VPWR _5483_/A3 sky130_fd_sc_hd__buf_2
X_7447_ _6741_/A _6616_/B _7799_/A VGND VGND VPWR VPWR _7448_/B sky130_fd_sc_hd__a21o_2
X_4659_ _4659_/A VGND VGND VPWR VPWR _9078_/D sky130_fd_sc_hd__buf_1
XFILLER_116_760 VGND VGND VPWR VPWR sky130_fd_sc_hd__decap_3
X_7378_ _7496_/B _7380_/B _7382_/B VGND VGND VPWR VPWR _7379_/A sky130_fd_sc_hd__o21ai_2
Xhold840 _4530_/X VGND VGND VPWR VPWR _4531_/A sky130_fd_sc_hd__dlygate4sd3_1
Xhold851 _4859_/X VGND VGND VPWR VPWR _4860_/A sky130_fd_sc_hd__dlygate4sd3_1
XFILLER_122_218 VGND VGND VPWR VPWR sky130_fd_sc_hd__decap_3
XFILLER_107_21 VGND VGND VPWR VPWR sky130_fd_sc_hd__decap_3
Xhold862 _9254_/Q VGND VGND VPWR VPWR hold862/X sky130_fd_sc_hd__dlygate4sd3_1
Xhold873 _4746_/X VGND VGND VPWR VPWR _4747_/A sky130_fd_sc_hd__dlygate4sd3_1
X_6329_ _5041_/B _7065_/B _6180_/A _6180_/B VGND VGND VPWR VPWR _6329_/X sky130_fd_sc_hd__o31a_2
Xhold884 _9056_/Q VGND VGND VPWR VPWR hold884/X sky130_fd_sc_hd__dlygate4sd3_1
X_9117_ _9171_/CLK _9117_/D load_slew393/X VGND VGND VPWR VPWR _9117_/Q sky130_fd_sc_hd__dfrtp_2
XFILLER_115_281 VGND VGND VPWR VPWR sky130_fd_sc_hd__fill_2
Xhold895 _4851_/X VGND VGND VPWR VPWR _4852_/A sky130_fd_sc_hd__dlygate4sd3_1
XTAP_TAPCELL_ROW_73_1265 VGND VPWR sky130_fd_sc_hd__tapvpwrvgnd_1
XFILLER_49_508 VGND VGND VPWR VPWR sky130_fd_sc_hd__decap_3
X_9048_ _9142_/CLK _9048_/D load_slew404/X VGND VGND VPWR VPWR _9048_/Q sky130_fd_sc_hd__dfrtp_2
XFILLER_88_154 VGND VGND VPWR VPWR sky130_fd_sc_hd__decap_3
XFILLER_130_240 VGND VGND VPWR VPWR sky130_fd_sc_hd__decap_3
XFILLER_89_688 VGND VGND VPWR VPWR sky130_fd_sc_hd__decap_3
XFILLER_67_47 VGND VGND VPWR VPWR sky130_fd_sc_hd__decap_3
XFILLER_130_262 VGND VGND VPWR VPWR sky130_fd_sc_hd__decap_3
XFILLER_103_498 VGND VGND VPWR VPWR sky130_fd_sc_hd__decap_3
XTAP_TAPCELL_ROW_4_331 VGND VPWR sky130_fd_sc_hd__tapvpwrvgnd_1
XTAP_TAPCELL_ROW_4_342 VGND VPWR sky130_fd_sc_hd__tapvpwrvgnd_1
XFILLER_76_349 VGND VGND VPWR VPWR sky130_fd_sc_hd__fill_1
XFILLER_57_541 VGND VGND VPWR VPWR sky130_fd_sc_hd__decap_3
XFILLER_123_42 VGND VGND VPWR VPWR sky130_fd_sc_hd__decap_3
XFILLER_45_714 VGND VGND VPWR VPWR sky130_fd_sc_hd__decap_3
XFILLER_17_405 VGND VGND VPWR VPWR sky130_fd_sc_hd__decap_3
XFILLER_123_75 VGND VGND VPWR VPWR sky130_fd_sc_hd__decap_3
XFILLER_72_533 VGND VGND VPWR VPWR sky130_fd_sc_hd__decap_3
XFILLER_44_224 VGND VGND VPWR VPWR sky130_fd_sc_hd__decap_3
XFILLER_29_298 VGND VGND VPWR VPWR sky130_fd_sc_hd__decap_3
XFILLER_72_544 VGND VGND VPWR VPWR sky130_fd_sc_hd__decap_3
XFILLER_17_449 VGND VGND VPWR VPWR sky130_fd_sc_hd__decap_3
XFILLER_83_57 VGND VGND VPWR VPWR sky130_fd_sc_hd__decap_3
XFILLER_83_79 VGND VGND VPWR VPWR sky130_fd_sc_hd__decap_3
XFILLER_72_566 VGND VGND VPWR VPWR sky130_fd_sc_hd__decap_3
XFILLER_60_739 VGND VGND VPWR VPWR sky130_fd_sc_hd__decap_3
XFILLER_16_62 VGND VGND VPWR VPWR sky130_fd_sc_hd__decap_3
XFILLER_12_110 VGND VGND VPWR VPWR sky130_fd_sc_hd__decap_3
XFILLER_9_615 VGND VGND VPWR VPWR sky130_fd_sc_hd__fill_1
XTAP_TAPCELL_ROW_51_970 VGND VPWR sky130_fd_sc_hd__tapvpwrvgnd_1
XFILLER_13_688 VGND VGND VPWR VPWR sky130_fd_sc_hd__decap_3
XFILLER_12_165 VGND VGND VPWR VPWR sky130_fd_sc_hd__fill_1
XFILLER_8_125 VGND VGND VPWR VPWR sky130_fd_sc_hd__fill_2
XFILLER_12_176 VGND VGND VPWR VPWR sky130_fd_sc_hd__decap_3
XFILLER_8_147 VGND VGND VPWR VPWR sky130_fd_sc_hd__decap_3
XFILLER_32_50 VGND VGND VPWR VPWR sky130_fd_sc_hd__decap_3
XFILLER_32_83 VGND VGND VPWR VPWR sky130_fd_sc_hd__fill_1
XFILLER_32_94 VGND VGND VPWR VPWR sky130_fd_sc_hd__fill_2
XFILLER_126_513 VGND VGND VPWR VPWR sky130_fd_sc_hd__fill_2
XFILLER_126_524 VGND VGND VPWR VPWR sky130_fd_sc_hd__decap_3
XFILLER_114_719 VGND VGND VPWR VPWR sky130_fd_sc_hd__decap_3
XFILLER_4_386 VGND VGND VPWR VPWR sky130_fd_sc_hd__decap_3
XFILLER_122_730 VGND VGND VPWR VPWR sky130_fd_sc_hd__decap_3
XFILLER_106_292 VGND VGND VPWR VPWR sky130_fd_sc_hd__decap_3
XFILLER_122_763 VGND VGND VPWR VPWR sky130_fd_sc_hd__decap_3
XFILLER_95_614 VGND VGND VPWR VPWR sky130_fd_sc_hd__fill_2
XFILLER_0_570 VGND VGND VPWR VPWR sky130_fd_sc_hd__decap_3
XFILLER_95_647 VGND VGND VPWR VPWR sky130_fd_sc_hd__fill_1
XFILLER_0_592 VGND VGND VPWR VPWR sky130_fd_sc_hd__decap_3
XFILLER_67_349 VGND VGND VPWR VPWR sky130_fd_sc_hd__fill_2
XFILLER_95_669 VGND VGND VPWR VPWR sky130_fd_sc_hd__decap_3
XFILLER_48_530 VGND VGND VPWR VPWR sky130_fd_sc_hd__fill_2
XFILLER_94_168 VGND VGND VPWR VPWR sky130_fd_sc_hd__fill_2
XFILLER_48_563 VGND VGND VPWR VPWR sky130_fd_sc_hd__fill_2
XFILLER_36_747 VGND VGND VPWR VPWR sky130_fd_sc_hd__decap_3
XFILLER_63_555 VGND VGND VPWR VPWR sky130_fd_sc_hd__fill_1
XFILLER_35_246 VGND VGND VPWR VPWR sky130_fd_sc_hd__decap_3
XFILLER_51_717 VGND VGND VPWR VPWR sky130_fd_sc_hd__decap_3
XFILLER_90_363 VGND VGND VPWR VPWR sky130_fd_sc_hd__fill_1
XFILLER_63_588 VGND VGND VPWR VPWR sky130_fd_sc_hd__decap_3
XFILLER_90_374 VGND VGND VPWR VPWR sky130_fd_sc_hd__decap_3
XFILLER_51_739 VGND VGND VPWR VPWR sky130_fd_sc_hd__decap_3
XFILLER_90_396 VGND VGND VPWR VPWR sky130_fd_sc_hd__fill_1
X_5700_ _5700_/A _5700_/B VGND VGND VPWR VPWR _5703_/A sky130_fd_sc_hd__xnor2_2
X_6680_ _7445_/A _6680_/B VGND VGND VPWR VPWR _6684_/A sky130_fd_sc_hd__nand2_2
XFILLER_31_430 VGND VGND VPWR VPWR sky130_fd_sc_hd__decap_3
X_5631_ _9203_/Q _5631_/B VGND VGND VPWR VPWR _5632_/B sky130_fd_sc_hd__nand2_2
XFILLER_31_496 VGND VGND VPWR VPWR sky130_fd_sc_hd__fill_1
X_8350_ _8350_/A _8350_/B VGND VGND VPWR VPWR _8402_/A sky130_fd_sc_hd__nor2_2
XFILLER_129_340 VGND VGND VPWR VPWR sky130_fd_sc_hd__fill_2
X_5562_ _5562_/A0 _5561_/Y _5968_/S VGND VGND VPWR VPWR _5562_/X sky130_fd_sc_hd__mux2_2
XFILLER_117_502 VGND VGND VPWR VPWR sky130_fd_sc_hd__fill_2
X_7301_ _7301_/A _7301_/B VGND VGND VPWR VPWR _7301_/X sky130_fd_sc_hd__or2_2
X_4513_ _8174_/A _7472_/A _5737_/B VGND VGND VPWR VPWR _4513_/Y sky130_fd_sc_hd__nor3_4
X_8281_ _8283_/B _8299_/B VGND VGND VPWR VPWR _8281_/Y sky130_fd_sc_hd__nor2_2
X_5493_ _5493_/A _5493_/B _5493_/C VGND VGND VPWR VPWR _5495_/A sky130_fd_sc_hd__and3_2
XFILLER_7_180 VGND VGND VPWR VPWR sky130_fd_sc_hd__decap_3
XFILLER_105_719 VGND VGND VPWR VPWR sky130_fd_sc_hd__fill_2
X_7232_ _7522_/B _7232_/B VGND VGND VPWR VPWR _7233_/B sky130_fd_sc_hd__xnor2_2
Xclkbuf_leaf_7_clk clkload1/A VGND VGND VPWR VPWR _9133_/CLK sky130_fd_sc_hd__clkbuf_8
XTAP_TAPCELL_ROW_113_1811 VGND VPWR sky130_fd_sc_hd__tapvpwrvgnd_1
X_7163_ _7163_/A _7163_/B VGND VGND VPWR VPWR _7163_/Y sky130_fd_sc_hd__nor2_2
X_6114_ _6117_/B2 _6112_/X _6113_/X _5935_/X VGND VGND VPWR VPWR _6114_/X sky130_fd_sc_hd__a22o_2
XTAP_TAPCELL_ROW_129_2018 VGND VPWR sky130_fd_sc_hd__tapvpwrvgnd_1
XTAP_TAPCELL_ROW_129_2029 VGND VPWR sky130_fd_sc_hd__tapvpwrvgnd_1
X_7094_ _7095_/A _7094_/B VGND VGND VPWR VPWR _7094_/X sky130_fd_sc_hd__or2_2
XFILLER_98_474 VGND VGND VPWR VPWR sky130_fd_sc_hd__fill_2
XFILLER_86_625 VGND VGND VPWR VPWR sky130_fd_sc_hd__decap_3
XFILLER_98_496 VGND VGND VPWR VPWR sky130_fd_sc_hd__decap_3
XFILLER_85_113 VGND VGND VPWR VPWR sky130_fd_sc_hd__fill_1
XFILLER_58_338 VGND VGND VPWR VPWR sky130_fd_sc_hd__decap_3
X_6045_ _6186_/B _6186_/A VGND VGND VPWR VPWR _6215_/B sky130_fd_sc_hd__xor2_4
XFILLER_86_669 VGND VGND VPWR VPWR sky130_fd_sc_hd__decap_3
XFILLER_85_157 VGND VGND VPWR VPWR sky130_fd_sc_hd__decap_3
XTAP_TAPCELL_ROW_1_301 VGND VPWR sky130_fd_sc_hd__tapvpwrvgnd_1
XFILLER_66_360 VGND VGND VPWR VPWR sky130_fd_sc_hd__decap_3
XFILLER_66_371 VGND VGND VPWR VPWR sky130_fd_sc_hd__decap_3
XFILLER_27_758 VGND VGND VPWR VPWR sky130_fd_sc_hd__decap_3
XFILLER_54_544 VGND VGND VPWR VPWR sky130_fd_sc_hd__decap_3
X_7996_ _7857_/B _7856_/A _7995_/X _7857_/A VGND VGND VPWR VPWR _7996_/X sky130_fd_sc_hd__a22o_2
XTAP_TAPCELL_ROW_37_775 VGND VPWR sky130_fd_sc_hd__tapvpwrvgnd_1
XTAP_TAPCELL_ROW_124_1951 VGND VPWR sky130_fd_sc_hd__tapvpwrvgnd_1
XFILLER_42_728 VGND VGND VPWR VPWR sky130_fd_sc_hd__decap_3
XTAP_TAPCELL_ROW_124_1962 VGND VPWR sky130_fd_sc_hd__tapvpwrvgnd_1
XFILLER_81_374 VGND VGND VPWR VPWR sky130_fd_sc_hd__decap_3
XFILLER_53_27 VGND VGND VPWR VPWR sky130_fd_sc_hd__decap_3
XFILLER_41_205 VGND VGND VPWR VPWR sky130_fd_sc_hd__decap_3
X_6947_ _9212_/Q _6947_/B VGND VGND VPWR VPWR _6948_/B sky130_fd_sc_hd__xnor2_2
XTAP_TAPCELL_ROW_37_786 VGND VPWR sky130_fd_sc_hd__tapvpwrvgnd_1
XFILLER_81_396 VGND VGND VPWR VPWR sky130_fd_sc_hd__decap_3
X_6878_ _7195_/A _6878_/B VGND VGND VPWR VPWR _6879_/B sky130_fd_sc_hd__xnor2_2
XFILLER_10_603 VGND VGND VPWR VPWR sky130_fd_sc_hd__decap_3
X_8617_ _8581_/Y _8398_/B _8695_/B _8616_/X VGND VGND VPWR VPWR _8617_/X sky130_fd_sc_hd__a22o_2
X_5829_ wire122/X _6546_/A2 _5743_/Y _6687_/B1 VGND VGND VPWR VPWR _5834_/A sky130_fd_sc_hd__a211o_2
XFILLER_108_502 VGND VGND VPWR VPWR sky130_fd_sc_hd__fill_2
X_8548_ _8548_/A VGND VGND VPWR VPWR _8627_/A sky130_fd_sc_hd__clkbuf_1
XFILLER_10_669 VGND VGND VPWR VPWR sky130_fd_sc_hd__fill_2
XFILLER_5_128 VGND VGND VPWR VPWR sky130_fd_sc_hd__decap_3
X_8479_ _8447_/X _8473_/X _8475_/X _8478_/X VGND VGND VPWR VPWR _8502_/A sky130_fd_sc_hd__o211a_2
XTAP_TAPCELL_ROW_9_401 VGND VPWR sky130_fd_sc_hd__tapvpwrvgnd_1
XFILLER_123_505 VGND VGND VPWR VPWR sky130_fd_sc_hd__decap_3
XFILLER_118_53 VGND VGND VPWR VPWR sky130_fd_sc_hd__decap_3
XFILLER_123_549 VGND VGND VPWR VPWR sky130_fd_sc_hd__decap_3
XFILLER_118_97 VGND VGND VPWR VPWR sky130_fd_sc_hd__decap_3
XFILLER_89_441 VGND VGND VPWR VPWR sky130_fd_sc_hd__decap_3
XFILLER_89_452 VGND VGND VPWR VPWR sky130_fd_sc_hd__decap_3
XFILLER_89_474 VGND VGND VPWR VPWR sky130_fd_sc_hd__decap_3
XFILLER_103_262 VGND VGND VPWR VPWR sky130_fd_sc_hd__decap_3
XFILLER_76_113 VGND VGND VPWR VPWR sky130_fd_sc_hd__decap_3
XFILLER_94_12 VGND VGND VPWR VPWR sky130_fd_sc_hd__decap_3
XFILLER_57_360 VGND VGND VPWR VPWR sky130_fd_sc_hd__decap_3
XFILLER_91_116 VGND VGND VPWR VPWR sky130_fd_sc_hd__decap_3
XFILLER_45_511 VGND VGND VPWR VPWR sky130_fd_sc_hd__decap_3
XFILLER_18_725 VGND VGND VPWR VPWR sky130_fd_sc_hd__decap_3
XFILLER_85_680 VGND VGND VPWR VPWR sky130_fd_sc_hd__decap_3
XFILLER_17_213 VGND VGND VPWR VPWR sky130_fd_sc_hd__decap_3
XFILLER_57_393 VGND VGND VPWR VPWR sky130_fd_sc_hd__decap_3
XFILLER_27_50 VGND VGND VPWR VPWR sky130_fd_sc_hd__decap_3
XTAP_TAPCELL_ROW_86_1445 VGND VPWR sky130_fd_sc_hd__tapvpwrvgnd_1
XFILLER_18_769 VGND VGND VPWR VPWR sky130_fd_sc_hd__decap_3
XFILLER_17_246 VGND VGND VPWR VPWR sky130_fd_sc_hd__decap_3
XFILLER_72_341 VGND VGND VPWR VPWR sky130_fd_sc_hd__fill_1
XFILLER_72_352 VGND VGND VPWR VPWR sky130_fd_sc_hd__fill_1
XFILLER_27_94 VGND VGND VPWR VPWR sky130_fd_sc_hd__fill_2
XFILLER_60_514 VGND VGND VPWR VPWR sky130_fd_sc_hd__fill_1
XFILLER_45_588 VGND VGND VPWR VPWR sky130_fd_sc_hd__decap_3
XFILLER_43_60 VGND VGND VPWR VPWR sky130_fd_sc_hd__decap_3
XFILLER_9_434 VGND VGND VPWR VPWR sky130_fd_sc_hd__decap_3
XFILLER_43_93 VGND VGND VPWR VPWR sky130_fd_sc_hd__fill_1
XFILLER_13_496 VGND VGND VPWR VPWR sky130_fd_sc_hd__decap_3
XFILLER_126_332 VGND VGND VPWR VPWR sky130_fd_sc_hd__decap_3
XTAP_TAPCELL_ROW_97_1585 VGND VPWR sky130_fd_sc_hd__tapvpwrvgnd_1
XFILLER_57_6 VGND VGND VPWR VPWR sky130_fd_sc_hd__decap_3
XTAP_TAPCELL_ROW_97_1596 VGND VPWR sky130_fd_sc_hd__tapvpwrvgnd_1
XFILLER_5_662 VGND VGND VPWR VPWR sky130_fd_sc_hd__decap_3
XFILLER_126_365 VGND VGND VPWR VPWR sky130_fd_sc_hd__decap_3
XFILLER_5_673 VGND VGND VPWR VPWR sky130_fd_sc_hd__decap_3
XFILLER_4_21 VGND VGND VPWR VPWR sky130_fd_sc_hd__decap_3
XFILLER_4_32 VGND VGND VPWR VPWR sky130_fd_sc_hd__decap_3
XFILLER_122_560 VGND VGND VPWR VPWR sky130_fd_sc_hd__decap_3
XFILLER_67_102 VGND VGND VPWR VPWR sky130_fd_sc_hd__fill_2
XFILLER_67_113 VGND VGND VPWR VPWR sky130_fd_sc_hd__decap_3
XFILLER_95_444 VGND VGND VPWR VPWR sky130_fd_sc_hd__decap_3
XFILLER_83_617 VGND VGND VPWR VPWR sky130_fd_sc_hd__fill_1
XFILLER_83_628 VGND VGND VPWR VPWR sky130_fd_sc_hd__decap_3
XFILLER_82_105 VGND VGND VPWR VPWR sky130_fd_sc_hd__decap_3
XFILLER_55_319 VGND VGND VPWR VPWR sky130_fd_sc_hd__decap_3
XFILLER_48_371 VGND VGND VPWR VPWR sky130_fd_sc_hd__fill_2
XFILLER_36_511 VGND VGND VPWR VPWR sky130_fd_sc_hd__decap_3
XFILLER_36_533 VGND VGND VPWR VPWR sky130_fd_sc_hd__decap_3
X_7850_ _7899_/B _7850_/B VGND VGND VPWR VPWR _7850_/Y sky130_fd_sc_hd__xnor2_2
XFILLER_24_717 VGND VGND VPWR VPWR sky130_fd_sc_hd__decap_3
X_6801_ _6801_/A _6801_/B VGND VGND VPWR VPWR _6835_/A sky130_fd_sc_hd__xnor2_2
X_4993_ _5624_/C VGND VGND VPWR VPWR _5442_/A sky130_fd_sc_hd__clkbuf_2
X_7781_ _7781_/A _7781_/B VGND VGND VPWR VPWR _7782_/B sky130_fd_sc_hd__xor2_2
XFILLER_63_396 VGND VGND VPWR VPWR sky130_fd_sc_hd__decap_3
XTAP_TAPCELL_ROW_34_734 VGND VPWR sky130_fd_sc_hd__tapvpwrvgnd_1
XTAP_TAPCELL_ROW_34_745 VGND VPWR sky130_fd_sc_hd__tapvpwrvgnd_1
X_6732_ _6732_/A _7016_/A _6732_/C _6732_/D VGND VGND VPWR VPWR _6733_/A sky130_fd_sc_hd__or4_4
XFILLER_16_290 VGND VGND VPWR VPWR sky130_fd_sc_hd__decap_3
XFILLER_51_569 VGND VGND VPWR VPWR sky130_fd_sc_hd__decap_3
X_6663_ _6664_/C _6664_/B _6662_/X VGND VGND VPWR VPWR _6777_/B sky130_fd_sc_hd__a21bo_2
XFILLER_31_271 VGND VGND VPWR VPWR sky130_fd_sc_hd__decap_3
X_5614_ _9342_/Q _9138_/Q _6342_/B VGND VGND VPWR VPWR _5614_/X sky130_fd_sc_hd__mux2_2
X_8402_ _8402_/A _8402_/B VGND VGND VPWR VPWR _8402_/Y sky130_fd_sc_hd__nand2_2
X_6594_ _6705_/B _6705_/C _6705_/A VGND VGND VPWR VPWR _7010_/B sky130_fd_sc_hd__nand3_2
X_5545_ _5949_/B _5930_/C _5319_/Y VGND VGND VPWR VPWR _5548_/A sky130_fd_sc_hd__o21ai_2
X_8333_ _8418_/B _8333_/B VGND VGND VPWR VPWR _8334_/B sky130_fd_sc_hd__xnor2_2
XFILLER_129_181 VGND VGND VPWR VPWR sky130_fd_sc_hd__decap_3
XFILLER_117_343 VGND VGND VPWR VPWR sky130_fd_sc_hd__decap_3
XFILLER_105_505 VGND VGND VPWR VPWR sky130_fd_sc_hd__decap_3
X_8264_ _8264_/A _8264_/B VGND VGND VPWR VPWR _8265_/A sky130_fd_sc_hd__xnor2_2
X_5476_ _5476_/A VGND VGND VPWR VPWR _5476_/X sky130_fd_sc_hd__clkbuf_2
XFILLER_2_109 VGND VGND VPWR VPWR sky130_fd_sc_hd__decap_3
XFILLER_105_538 VGND VGND VPWR VPWR sky130_fd_sc_hd__decap_3
XTAP_TAPCELL_ROW_57_1046 VGND VPWR sky130_fd_sc_hd__tapvpwrvgnd_1
XTAP_TAPCELL_ROW_57_1057 VGND VPWR sky130_fd_sc_hd__tapvpwrvgnd_1
X_7215_ _7215_/A _7215_/B VGND VGND VPWR VPWR _7216_/B sky130_fd_sc_hd__xnor2_2
X_8195_ _7908_/X _8196_/C _8268_/S VGND VGND VPWR VPWR _8195_/X sky130_fd_sc_hd__mux2_2
Xfanout402 fanout407/A VGND VGND VPWR VPWR fanout402/X sky130_fd_sc_hd__clkdlybuf4s25_1
Xfanout413 input1/X VGND VGND VPWR VPWR fanout413/X sky130_fd_sc_hd__clkdlybuf4s25_1
X_7146_ _7025_/A _7140_/X _7143_/X _7145_/Y VGND VGND VPWR VPWR _7147_/B sky130_fd_sc_hd__a211o_4
XFILLER_59_614 VGND VGND VPWR VPWR sky130_fd_sc_hd__fill_2
XTAP_TAPCELL_ROW_70_1224 VGND VPWR sky130_fd_sc_hd__tapvpwrvgnd_1
XFILLER_48_27 VGND VGND VPWR VPWR sky130_fd_sc_hd__fill_1
XFILLER_113_571 VGND VGND VPWR VPWR sky130_fd_sc_hd__decap_3
XFILLER_101_722 VGND VGND VPWR VPWR sky130_fd_sc_hd__decap_3
XFILLER_86_433 VGND VGND VPWR VPWR sky130_fd_sc_hd__decap_3
XFILLER_59_647 VGND VGND VPWR VPWR sky130_fd_sc_hd__decap_3
XFILLER_113_593 VGND VGND VPWR VPWR sky130_fd_sc_hd__decap_3
X_7077_ _7069_/Y _7077_/B _7077_/C VGND VGND VPWR VPWR _7077_/X sky130_fd_sc_hd__and3b_2
XFILLER_59_669 VGND VGND VPWR VPWR sky130_fd_sc_hd__decap_3
XFILLER_100_243 VGND VGND VPWR VPWR sky130_fd_sc_hd__decap_3
XFILLER_86_466 VGND VGND VPWR VPWR sky130_fd_sc_hd__decap_3
XFILLER_86_477 VGND VGND VPWR VPWR sky130_fd_sc_hd__decap_3
X_6028_ _5443_/B _6756_/B _6028_/S VGND VGND VPWR VPWR _6035_/B sky130_fd_sc_hd__mux2_2
XFILLER_74_639 VGND VGND VPWR VPWR sky130_fd_sc_hd__decap_3
XFILLER_27_500 VGND VGND VPWR VPWR sky130_fd_sc_hd__decap_3
XFILLER_104_44 VGND VGND VPWR VPWR sky130_fd_sc_hd__decap_3
XFILLER_67_691 VGND VGND VPWR VPWR sky130_fd_sc_hd__decap_3
XFILLER_39_393 VGND VGND VPWR VPWR sky130_fd_sc_hd__decap_3
XFILLER_104_88 VGND VGND VPWR VPWR sky130_fd_sc_hd__fill_2
XFILLER_27_544 VGND VGND VPWR VPWR sky130_fd_sc_hd__decap_3
XFILLER_64_37 VGND VGND VPWR VPWR sky130_fd_sc_hd__decap_3
XFILLER_104_99 VGND VGND VPWR VPWR sky130_fd_sc_hd__fill_1
XFILLER_15_706 VGND VGND VPWR VPWR sky130_fd_sc_hd__decap_3
XFILLER_54_352 VGND VGND VPWR VPWR sky130_fd_sc_hd__fill_1
XFILLER_82_672 VGND VGND VPWR VPWR sky130_fd_sc_hd__fill_1
XFILLER_82_683 VGND VGND VPWR VPWR sky130_fd_sc_hd__decap_3
XFILLER_27_588 VGND VGND VPWR VPWR sky130_fd_sc_hd__decap_3
XFILLER_14_216 VGND VGND VPWR VPWR sky130_fd_sc_hd__fill_2
X_7979_ _7979_/A _7979_/B VGND VGND VPWR VPWR _7983_/A sky130_fd_sc_hd__xnor2_2
XTAP_TAPCELL_ROW_68_1197 VGND VPWR sky130_fd_sc_hd__tapvpwrvgnd_1
XFILLER_54_396 VGND VGND VPWR VPWR sky130_fd_sc_hd__decap_3
XFILLER_42_536 VGND VGND VPWR VPWR sky130_fd_sc_hd__fill_1
XFILLER_120_21 VGND VGND VPWR VPWR sky130_fd_sc_hd__decap_3
XFILLER_42_547 VGND VGND VPWR VPWR sky130_fd_sc_hd__decap_3
XFILLER_120_32 VGND VGND VPWR VPWR sky130_fd_sc_hd__decap_3
XFILLER_23_750 VGND VGND VPWR VPWR sky130_fd_sc_hd__decap_3
XFILLER_120_65 VGND VGND VPWR VPWR sky130_fd_sc_hd__decap_3
XTAP_TAPCELL_ROW_81_1375 VGND VPWR sky130_fd_sc_hd__tapvpwrvgnd_1
XFILLER_80_58 VGND VGND VPWR VPWR sky130_fd_sc_hd__decap_3
XTAP_TAPCELL_ROW_12_439 VGND VPWR sky130_fd_sc_hd__tapvpwrvgnd_1
XFILLER_22_282 VGND VGND VPWR VPWR sky130_fd_sc_hd__decap_3
XFILLER_13_30 VGND VGND VPWR VPWR sky130_fd_sc_hd__decap_3
XFILLER_128_619 VGND VGND VPWR VPWR sky130_fd_sc_hd__decap_3
XFILLER_10_433 VGND VGND VPWR VPWR sky130_fd_sc_hd__decap_3
XFILLER_129_30 VGND VGND VPWR VPWR sky130_fd_sc_hd__decap_3
XFILLER_10_477 VGND VGND VPWR VPWR sky130_fd_sc_hd__decap_3
XFILLER_89_12 VGND VGND VPWR VPWR sky130_fd_sc_hd__decap_3
XFILLER_6_448 VGND VGND VPWR VPWR sky130_fd_sc_hd__decap_3
XFILLER_129_63 VGND VGND VPWR VPWR sky130_fd_sc_hd__decap_3
XFILLER_89_34 VGND VGND VPWR VPWR sky130_fd_sc_hd__fill_2
XFILLER_108_365 VGND VGND VPWR VPWR sky130_fd_sc_hd__decap_3
XFILLER_129_96 VGND VGND VPWR VPWR sky130_fd_sc_hd__decap_3
XFILLER_108_376 VGND VGND VPWR VPWR sky130_fd_sc_hd__decap_3
XFILLER_2_610 VGND VGND VPWR VPWR sky130_fd_sc_hd__decap_3
XFILLER_123_335 VGND VGND VPWR VPWR sky130_fd_sc_hd__fill_1
XFILLER_123_346 VGND VGND VPWR VPWR sky130_fd_sc_hd__decap_3
XFILLER_2_643 VGND VGND VPWR VPWR sky130_fd_sc_hd__fill_1
XFILLER_2_654 VGND VGND VPWR VPWR sky130_fd_sc_hd__decap_3
XFILLER_1_131 VGND VGND VPWR VPWR sky130_fd_sc_hd__fill_2
XFILLER_111_508 VGND VGND VPWR VPWR sky130_fd_sc_hd__decap_3
XFILLER_123_379 VGND VGND VPWR VPWR sky130_fd_sc_hd__decap_3
XFILLER_49_102 VGND VGND VPWR VPWR sky130_fd_sc_hd__decap_3
XFILLER_2_687 VGND VGND VPWR VPWR sky130_fd_sc_hd__decap_3
XFILLER_49_113 VGND VGND VPWR VPWR sky130_fd_sc_hd__decap_3
XFILLER_77_455 VGND VGND VPWR VPWR sky130_fd_sc_hd__decap_3
XFILLER_49_146 VGND VGND VPWR VPWR sky130_fd_sc_hd__decap_3
XFILLER_65_617 VGND VGND VPWR VPWR sky130_fd_sc_hd__decap_3
XFILLER_77_488 VGND VGND VPWR VPWR sky130_fd_sc_hd__decap_3
XFILLER_37_319 VGND VGND VPWR VPWR sky130_fd_sc_hd__fill_2
XFILLER_18_511 VGND VGND VPWR VPWR sky130_fd_sc_hd__fill_2
XFILLER_58_680 VGND VGND VPWR VPWR sky130_fd_sc_hd__decap_3
XFILLER_92_458 VGND VGND VPWR VPWR sky130_fd_sc_hd__decap_3
XFILLER_33_503 VGND VGND VPWR VPWR sky130_fd_sc_hd__fill_1
XFILLER_33_514 VGND VGND VPWR VPWR sky130_fd_sc_hd__decap_3
XFILLER_72_182 VGND VGND VPWR VPWR sky130_fd_sc_hd__fill_1
XFILLER_45_396 VGND VGND VPWR VPWR sky130_fd_sc_hd__fill_2
XFILLER_33_558 VGND VGND VPWR VPWR sky130_fd_sc_hd__fill_2
XFILLER_54_92 VGND VGND VPWR VPWR sky130_fd_sc_hd__fill_1
XTAP_TAPCELL_ROW_31_704 VGND VPWR sky130_fd_sc_hd__tapvpwrvgnd_1
XFILLER_14_772 VGND VGND VPWR VPWR sky130_fd_sc_hd__decap_3
XFILLER_20_219 VGND VGND VPWR VPWR sky130_fd_sc_hd__decap_3
XFILLER_13_260 VGND VGND VPWR VPWR sky130_fd_sc_hd__decap_3
XTAP_TAPCELL_ROW_99_1614 VGND VPWR sky130_fd_sc_hd__tapvpwrvgnd_1
XFILLER_9_242 VGND VGND VPWR VPWR sky130_fd_sc_hd__decap_3
XFILLER_9_264 VGND VGND VPWR VPWR sky130_fd_sc_hd__decap_3
XFILLER_118_118 VGND VGND VPWR VPWR sky130_fd_sc_hd__decap_3
Xclkload12 _9296_/CLK VGND VGND VPWR VPWR clkload12/Y sky130_fd_sc_hd__clkinv_2
Xclkload23 _9333_/CLK VGND VGND VPWR VPWR clkload23/Y sky130_fd_sc_hd__inv_4
XFILLER_127_641 VGND VGND VPWR VPWR sky130_fd_sc_hd__decap_3
X_5330_ _5330_/A _5330_/B VGND VGND VPWR VPWR _5525_/A sky130_fd_sc_hd__nor2_2
XFILLER_55_3 VGND VGND VPWR VPWR sky130_fd_sc_hd__decap_3
XFILLER_127_685 VGND VGND VPWR VPWR sky130_fd_sc_hd__decap_3
XFILLER_126_162 VGND VGND VPWR VPWR sky130_fd_sc_hd__decap_3
XFILLER_114_324 VGND VGND VPWR VPWR sky130_fd_sc_hd__decap_3
X_5261_ _9323_/Q _5880_/B _6604_/C VGND VGND VPWR VPWR _5261_/X sky130_fd_sc_hd__and3_2
XFILLER_126_195 VGND VGND VPWR VPWR sky130_fd_sc_hd__fill_1
XFILLER_88_709 VGND VGND VPWR VPWR sky130_fd_sc_hd__decap_3
X_7000_ _7000_/A _7000_/B VGND VGND VPWR VPWR _7009_/A sky130_fd_sc_hd__xnor2_2
XFILLER_114_368 VGND VGND VPWR VPWR sky130_fd_sc_hd__decap_3
XFILLER_102_519 VGND VGND VPWR VPWR sky130_fd_sc_hd__decap_3
X_5192_ _7313_/C VGND VGND VPWR VPWR _5193_/B sky130_fd_sc_hd__clkbuf_2
XFILLER_96_720 VGND VGND VPWR VPWR sky130_fd_sc_hd__decap_3
XFILLER_110_530 VGND VGND VPWR VPWR sky130_fd_sc_hd__fill_2
XFILLER_68_455 VGND VGND VPWR VPWR sky130_fd_sc_hd__decap_3
XTAP_TAPCELL_ROW_39_804 VGND VPWR sky130_fd_sc_hd__tapvpwrvgnd_1
XFILLER_68_477 VGND VGND VPWR VPWR sky130_fd_sc_hd__decap_3
XFILLER_56_617 VGND VGND VPWR VPWR sky130_fd_sc_hd__decap_3
XFILLER_95_274 VGND VGND VPWR VPWR sky130_fd_sc_hd__decap_3
X_8951_ hold829/X _8951_/A1 _8967_/S VGND VGND VPWR VPWR _8952_/A sky130_fd_sc_hd__mux2_2
XFILLER_55_116 VGND VGND VPWR VPWR sky130_fd_sc_hd__fill_1
XFILLER_110_585 VGND VGND VPWR VPWR sky130_fd_sc_hd__decap_3
XFILLER_95_296 VGND VGND VPWR VPWR sky130_fd_sc_hd__fill_2
XFILLER_55_138 VGND VGND VPWR VPWR sky130_fd_sc_hd__decap_3
X_7902_ _7847_/A _7847_/B _7901_/X VGND VGND VPWR VPWR _7902_/X sky130_fd_sc_hd__o21a_2
XTAP_TAPCELL_ROW_108_1743 VGND VPWR sky130_fd_sc_hd__tapvpwrvgnd_1
XFILLER_36_330 VGND VGND VPWR VPWR sky130_fd_sc_hd__decap_3
X_8882_ _8882_/A VGND VGND VPWR VPWR _9284_/D sky130_fd_sc_hd__buf_1
XFILLER_24_503 VGND VGND VPWR VPWR sky130_fd_sc_hd__decap_3
X_7833_ _7924_/A VGND VGND VPWR VPWR _7840_/B sky130_fd_sc_hd__inv_2
XFILLER_64_694 VGND VGND VPWR VPWR sky130_fd_sc_hd__decap_3
XFILLER_51_311 VGND VGND VPWR VPWR sky130_fd_sc_hd__decap_3
XFILLER_24_525 VGND VGND VPWR VPWR sky130_fd_sc_hd__fill_2
XTAP_TAPCELL_ROW_121_1910 VGND VPWR sky130_fd_sc_hd__tapvpwrvgnd_1
XFILLER_63_182 VGND VGND VPWR VPWR sky130_fd_sc_hd__decap_3
XFILLER_36_396 VGND VGND VPWR VPWR sky130_fd_sc_hd__decap_3
XTAP_TAPCELL_ROW_121_1921 VGND VPWR sky130_fd_sc_hd__tapvpwrvgnd_1
X_7764_ _7764_/A _7764_/B VGND VGND VPWR VPWR _7764_/Y sky130_fd_sc_hd__nor2_2
X_4976_ _7098_/A VGND VGND VPWR VPWR _5016_/A sky130_fd_sc_hd__clkbuf_2
XFILLER_51_377 VGND VGND VPWR VPWR sky130_fd_sc_hd__decap_3
X_6715_ _5743_/B _6715_/A2 _5273_/Y _7430_/C VGND VGND VPWR VPWR _6965_/A sky130_fd_sc_hd__a211o_2
XFILLER_51_399 VGND VGND VPWR VPWR sky130_fd_sc_hd__decap_3
X_7695_ _7744_/A _7695_/B VGND VGND VPWR VPWR _7696_/B sky130_fd_sc_hd__xnor2_2
XFILLER_20_731 VGND VGND VPWR VPWR sky130_fd_sc_hd__decap_3
Xclkload6 clkload6/A VGND VGND VPWR VPWR clkload6/X sky130_fd_sc_hd__clkbuf_4
X_6646_ _6657_/A _6656_/B _6656_/A VGND VGND VPWR VPWR _6650_/C sky130_fd_sc_hd__a21oi_2
XFILLER_20_775 VGND VGND VPWR VPWR sky130_fd_sc_hd__fill_2
XFILLER_126_9 VGND VGND VPWR VPWR sky130_fd_sc_hd__decap_3
XFILLER_118_641 VGND VGND VPWR VPWR sky130_fd_sc_hd__decap_3
X_6577_ _6695_/A _6695_/B VGND VGND VPWR VPWR _6581_/A sky130_fd_sc_hd__nand2_2
XTAP_TAPCELL_ROW_119_1883 VGND VPWR sky130_fd_sc_hd__tapvpwrvgnd_1
XFILLER_118_663 VGND VGND VPWR VPWR sky130_fd_sc_hd__decap_3
X_8316_ _8315_/A _8322_/A _8232_/A VGND VGND VPWR VPWR _8408_/B sky130_fd_sc_hd__a21oi_2
XTAP_TAPCELL_ROW_119_1894 VGND VPWR sky130_fd_sc_hd__tapvpwrvgnd_1
XFILLER_105_302 VGND VGND VPWR VPWR sky130_fd_sc_hd__fill_1
X_5528_ _5528_/A _5528_/B _5528_/C VGND VGND VPWR VPWR _5529_/B sky130_fd_sc_hd__or3_2
XFILLER_118_685 VGND VGND VPWR VPWR sky130_fd_sc_hd__decap_3
X_9296_ _9296_/CLK _9296_/D fanout379/A VGND VGND VPWR VPWR _9296_/Q sky130_fd_sc_hd__dfrtp_2
XFILLER_3_429 VGND VGND VPWR VPWR sky130_fd_sc_hd__decap_3
XFILLER_117_184 VGND VGND VPWR VPWR sky130_fd_sc_hd__fill_2
X_5459_ _5611_/S _9025_/Q _5463_/C VGND VGND VPWR VPWR _5459_/X sky130_fd_sc_hd__and3b_2
X_8247_ _8162_/A _8163_/A _8246_/X VGND VGND VPWR VPWR _8427_/B sky130_fd_sc_hd__o21a_2
X_8178_ _8178_/A _8178_/B VGND VGND VPWR VPWR _8179_/B sky130_fd_sc_hd__xnor2_2
XFILLER_59_411 VGND VGND VPWR VPWR sky130_fd_sc_hd__decap_3
XFILLER_115_21 VGND VGND VPWR VPWR sky130_fd_sc_hd__decap_3
X_7129_ _7374_/A _7374_/B _7127_/Y _7128_/X VGND VGND VPWR VPWR _7388_/A sky130_fd_sc_hd__o211a_4
Xfanout265 fanout265/A VGND VGND VPWR VPWR _8777_/B sky130_fd_sc_hd__dlymetal6s4s_1
XFILLER_115_54 VGND VGND VPWR VPWR sky130_fd_sc_hd__fill_2
Xfanout276 hold753/X VGND VGND VPWR VPWR _5513_/A sky130_fd_sc_hd__buf_4
XFILLER_87_775 VGND VGND VPWR VPWR sky130_fd_sc_hd__fill_2
Xfanout287 input5/X VGND VGND VPWR VPWR _8011_/A sky130_fd_sc_hd__clkdlybuf4s25_1
XFILLER_47_617 VGND VGND VPWR VPWR sky130_fd_sc_hd__decap_3
XFILLER_19_308 VGND VGND VPWR VPWR sky130_fd_sc_hd__decap_3
XFILLER_86_263 VGND VGND VPWR VPWR sky130_fd_sc_hd__decap_3
XFILLER_101_585 VGND VGND VPWR VPWR sky130_fd_sc_hd__fill_2
Xfanout298 _7174_/B VGND VGND VPWR VPWR _6431_/A sky130_fd_sc_hd__clkdlybuf4s25_1
XFILLER_59_499 VGND VGND VPWR VPWR sky130_fd_sc_hd__decap_3
XFILLER_115_98 VGND VGND VPWR VPWR sky130_fd_sc_hd__decap_3
XFILLER_46_127 VGND VGND VPWR VPWR sky130_fd_sc_hd__decap_3
XFILLER_55_650 VGND VGND VPWR VPWR sky130_fd_sc_hd__decap_3
XTAP_TAPCELL_ROW_17_509 VGND VPWR sky130_fd_sc_hd__tapvpwrvgnd_1
XTAP_TAPCELL_ROW_83_1404 VGND VPWR sky130_fd_sc_hd__tapvpwrvgnd_1
XFILLER_61_119 VGND VGND VPWR VPWR sky130_fd_sc_hd__decap_3
XFILLER_42_300 VGND VGND VPWR VPWR sky130_fd_sc_hd__decap_3
XFILLER_15_525 VGND VGND VPWR VPWR sky130_fd_sc_hd__decap_3
XFILLER_70_642 VGND VGND VPWR VPWR sky130_fd_sc_hd__fill_2
XFILLER_15_558 VGND VGND VPWR VPWR sky130_fd_sc_hd__fill_2
XFILLER_91_57 VGND VGND VPWR VPWR sky130_fd_sc_hd__decap_3
XFILLER_91_68 VGND VGND VPWR VPWR sky130_fd_sc_hd__decap_3
XFILLER_30_517 VGND VGND VPWR VPWR sky130_fd_sc_hd__decap_3
XFILLER_70_686 VGND VGND VPWR VPWR sky130_fd_sc_hd__decap_3
XFILLER_42_377 VGND VGND VPWR VPWR sky130_fd_sc_hd__decap_3
XPHY_EDGE_ROW_59_Left_190 VGND VGND VPWR VPWR sky130_fd_sc_hd__decap_3
XFILLER_24_62 VGND VGND VPWR VPWR sky130_fd_sc_hd__decap_3
XFILLER_11_720 VGND VGND VPWR VPWR sky130_fd_sc_hd__decap_3
XFILLER_23_591 VGND VGND VPWR VPWR sky130_fd_sc_hd__fill_1
XFILLER_24_95 VGND VGND VPWR VPWR sky130_fd_sc_hd__fill_2
XFILLER_11_753 VGND VGND VPWR VPWR sky130_fd_sc_hd__decap_3
XFILLER_7_713 VGND VGND VPWR VPWR sky130_fd_sc_hd__decap_3
XFILLER_7_735 VGND VGND VPWR VPWR sky130_fd_sc_hd__decap_3
XFILLER_6_212 VGND VGND VPWR VPWR sky130_fd_sc_hd__decap_3
XFILLER_7_768 VGND VGND VPWR VPWR sky130_fd_sc_hd__decap_3
XFILLER_124_600 VGND VGND VPWR VPWR sky130_fd_sc_hd__fill_2
XFILLER_109_685 VGND VGND VPWR VPWR sky130_fd_sc_hd__decap_3
XTAP_TAPCELL_ROW_94_1544 VGND VPWR sky130_fd_sc_hd__tapvpwrvgnd_1
XFILLER_124_622 VGND VGND VPWR VPWR sky130_fd_sc_hd__decap_3
XTAP_TAPCELL_ROW_94_1555 VGND VPWR sky130_fd_sc_hd__tapvpwrvgnd_1
XFILLER_40_94 VGND VGND VPWR VPWR sky130_fd_sc_hd__decap_3
XFILLER_41_9 VGND VGND VPWR VPWR sky130_fd_sc_hd__decap_3
XFILLER_123_143 VGND VGND VPWR VPWR sky130_fd_sc_hd__decap_3
XFILLER_97_517 VGND VGND VPWR VPWR sky130_fd_sc_hd__fill_2
XFILLER_123_187 VGND VGND VPWR VPWR sky130_fd_sc_hd__decap_3
XFILLER_111_349 VGND VGND VPWR VPWR sky130_fd_sc_hd__decap_3
XFILLER_49_81 VGND VGND VPWR VPWR sky130_fd_sc_hd__decap_3
XFILLER_38_617 VGND VGND VPWR VPWR sky130_fd_sc_hd__fill_2
XFILLER_93_712 VGND VGND VPWR VPWR sky130_fd_sc_hd__decap_3
XFILLER_92_200 VGND VGND VPWR VPWR sky130_fd_sc_hd__fill_2
XFILLER_37_105 VGND VGND VPWR VPWR sky130_fd_sc_hd__decap_3
XFILLER_92_211 VGND VGND VPWR VPWR sky130_fd_sc_hd__fill_2
XFILLER_37_116 VGND VGND VPWR VPWR sky130_fd_sc_hd__decap_3
XFILLER_1_33 VGND VGND VPWR VPWR sky130_fd_sc_hd__decap_3
XFILLER_65_458 VGND VGND VPWR VPWR sky130_fd_sc_hd__decap_3
XFILLER_1_66 VGND VGND VPWR VPWR sky130_fd_sc_hd__decap_3
XFILLER_1_88 VGND VGND VPWR VPWR sky130_fd_sc_hd__decap_3
XFILLER_46_661 VGND VGND VPWR VPWR sky130_fd_sc_hd__decap_3
XFILLER_18_352 VGND VGND VPWR VPWR sky130_fd_sc_hd__decap_3
XFILLER_18_374 VGND VGND VPWR VPWR sky130_fd_sc_hd__decap_3
XFILLER_80_439 VGND VGND VPWR VPWR sky130_fd_sc_hd__decap_3
XFILLER_65_91 VGND VGND VPWR VPWR sky130_fd_sc_hd__decap_3
XFILLER_73_491 VGND VGND VPWR VPWR sky130_fd_sc_hd__decap_3
XFILLER_61_642 VGND VGND VPWR VPWR sky130_fd_sc_hd__decap_3
X_4830_ _9160_/Q _4830_/A1 _4840_/S VGND VGND VPWR VPWR _4830_/X sky130_fd_sc_hd__mux2_2
XFILLER_60_141 VGND VGND VPWR VPWR sky130_fd_sc_hd__decap_3
XTAP_TAPCELL_ROW_44_873 VGND VPWR sky130_fd_sc_hd__tapvpwrvgnd_1
X_4761_ _4794_/A1 _4761_/A1 _4777_/S VGND VGND VPWR VPWR _4762_/A sky130_fd_sc_hd__mux2_2
XTAP_TAPCELL_ROW_103_1673 VGND VPWR sky130_fd_sc_hd__tapvpwrvgnd_1
X_6500_ _6500_/A _6430_/B VGND VGND VPWR VPWR _6500_/X sky130_fd_sc_hd__or2b_2
X_7480_ _9213_/Q _9214_/Q _7480_/C VGND VGND VPWR VPWR _7480_/X sky130_fd_sc_hd__or3_2
X_4692_ _4692_/A VGND VGND VPWR VPWR _9094_/D sky130_fd_sc_hd__buf_1
XFILLER_119_449 VGND VGND VPWR VPWR sky130_fd_sc_hd__decap_3
X_6431_ _6431_/A _6431_/B VGND VGND VPWR VPWR _6432_/B sky130_fd_sc_hd__nand2_2
X_6362_ _6362_/A _6526_/A VGND VGND VPWR VPWR _6363_/A sky130_fd_sc_hd__xor2_2
X_9150_ _9339_/CLK _9150_/D fanout383/X VGND VGND VPWR VPWR _9150_/Q sky130_fd_sc_hd__dfrtp_2
XFILLER_127_493 VGND VGND VPWR VPWR sky130_fd_sc_hd__decap_3
X_5313_ _5313_/A0 _5312_/Y _6270_/S VGND VGND VPWR VPWR _5314_/A sky130_fd_sc_hd__mux2_2
X_8101_ _9218_/Q wire67/A _8104_/C _8100_/Y _8344_/A VGND VGND VPWR VPWR _8101_/X
+ sky130_fd_sc_hd__a32o_2
XFILLER_114_110 VGND VGND VPWR VPWR sky130_fd_sc_hd__decap_3
X_6293_ _6293_/A _6293_/B VGND VGND VPWR VPWR _6297_/C sky130_fd_sc_hd__nand2_2
X_9081_ _9317_/CLK _9081_/D wire406/X VGND VGND VPWR VPWR _9081_/Q sky130_fd_sc_hd__dfrtp_2
XTAP_TAPCELL_ROW_54_1005 VGND VPWR sky130_fd_sc_hd__tapvpwrvgnd_1
XTAP_TAPCELL_ROW_54_1016 VGND VPWR sky130_fd_sc_hd__tapvpwrvgnd_1
XFILLER_115_666 VGND VGND VPWR VPWR sky130_fd_sc_hd__decap_3
XFILLER_115_688 VGND VGND VPWR VPWR sky130_fd_sc_hd__decap_3
X_5244_ _5244_/A _5410_/B VGND VGND VPWR VPWR _5244_/Y sky130_fd_sc_hd__nand2_2
X_8032_ _8011_/A _7885_/Y _8035_/S _7877_/X VGND VGND VPWR VPWR _8032_/X sky130_fd_sc_hd__o31a_2
XFILLER_114_187 VGND VGND VPWR VPWR sky130_fd_sc_hd__decap_3
XFILLER_102_338 VGND VGND VPWR VPWR sky130_fd_sc_hd__decap_3
X_5175_ _9070_/Q _5175_/B _5879_/B VGND VGND VPWR VPWR _5175_/X sky130_fd_sc_hd__and3_2
XFILLER_130_669 VGND VGND VPWR VPWR sky130_fd_sc_hd__decap_3
XFILLER_84_701 VGND VGND VPWR VPWR sky130_fd_sc_hd__decap_3
XFILLER_96_583 VGND VGND VPWR VPWR sky130_fd_sc_hd__decap_3
XFILLER_110_371 VGND VGND VPWR VPWR sky130_fd_sc_hd__decap_3
XFILLER_83_211 VGND VGND VPWR VPWR sky130_fd_sc_hd__fill_1
XFILLER_83_233 VGND VGND VPWR VPWR sky130_fd_sc_hd__fill_1
X_8934_ _8967_/A1 _9293_/Q _8946_/S VGND VGND VPWR VPWR _8934_/X sky130_fd_sc_hd__mux2_2
XFILLER_45_39 VGND VGND VPWR VPWR sky130_fd_sc_hd__decap_3
XFILLER_43_108 VGND VGND VPWR VPWR sky130_fd_sc_hd__decap_3
XFILLER_71_428 VGND VGND VPWR VPWR sky130_fd_sc_hd__decap_3
X_8865_ hold878/X _8865_/A1 _8883_/S VGND VGND VPWR VPWR _8866_/A sky130_fd_sc_hd__mux2_2
XFILLER_37_694 VGND VGND VPWR VPWR sky130_fd_sc_hd__fill_1
XFILLER_101_12 VGND VGND VPWR VPWR sky130_fd_sc_hd__decap_3
X_7816_ _7816_/A _7816_/B VGND VGND VPWR VPWR _7816_/Y sky130_fd_sc_hd__nor2_2
XTAP_TAPCELL_ROW_65_1156 VGND VPWR sky130_fd_sc_hd__tapvpwrvgnd_1
XFILLER_52_664 VGND VGND VPWR VPWR sky130_fd_sc_hd__fill_1
X_8796_ _8796_/A VGND VGND VPWR VPWR _9243_/D sky130_fd_sc_hd__buf_1
XFILLER_52_697 VGND VGND VPWR VPWR sky130_fd_sc_hd__decap_3
XFILLER_24_388 VGND VGND VPWR VPWR sky130_fd_sc_hd__fill_1
XFILLER_61_27 VGND VGND VPWR VPWR sky130_fd_sc_hd__decap_3
XFILLER_12_539 VGND VGND VPWR VPWR sky130_fd_sc_hd__decap_3
X_7747_ _7694_/A _7742_/Y _7745_/X _7857_/A VGND VGND VPWR VPWR _7747_/X sky130_fd_sc_hd__a22o_2
X_4959_ _6607_/C VGND VGND VPWR VPWR _6758_/C sky130_fd_sc_hd__buf_2
X_7678_ _6415_/A _7674_/X _7677_/X VGND VGND VPWR VPWR _7684_/A sky130_fd_sc_hd__a21oi_2
XTAP_TAPCELL_ROW_22_578 VGND VPWR sky130_fd_sc_hd__tapvpwrvgnd_1
XFILLER_20_583 VGND VGND VPWR VPWR sky130_fd_sc_hd__decap_3
XFILLER_124_6 VGND VGND VPWR VPWR sky130_fd_sc_hd__decap_3
X_6629_ _9208_/Q _8237_/A VGND VGND VPWR VPWR _6629_/Y sky130_fd_sc_hd__nand2_2
XFILLER_4_716 VGND VGND VPWR VPWR sky130_fd_sc_hd__decap_3
X_9348_ _9348_/CLK _9348_/D fanout403/X VGND VGND VPWR VPWR _9348_/Q sky130_fd_sc_hd__dfrtp_2
XFILLER_106_622 VGND VGND VPWR VPWR sky130_fd_sc_hd__decap_3
XFILLER_4_749 VGND VGND VPWR VPWR sky130_fd_sc_hd__decap_3
XFILLER_3_237 VGND VGND VPWR VPWR sky130_fd_sc_hd__decap_3
X_9279_ _9343_/CLK _9279_/D load_slew397/X VGND VGND VPWR VPWR _9279_/Q sky130_fd_sc_hd__dfrtp_2
XFILLER_10_53 VGND VGND VPWR VPWR sky130_fd_sc_hd__fill_2
XFILLER_105_143 VGND VGND VPWR VPWR sky130_fd_sc_hd__decap_3
XFILLER_79_517 VGND VGND VPWR VPWR sky130_fd_sc_hd__fill_1
XFILLER_121_614 VGND VGND VPWR VPWR sky130_fd_sc_hd__fill_2
XFILLER_106_699 VGND VGND VPWR VPWR sky130_fd_sc_hd__fill_1
XFILLER_126_53 VGND VGND VPWR VPWR sky130_fd_sc_hd__decap_3
XFILLER_86_24 VGND VGND VPWR VPWR sky130_fd_sc_hd__decap_3
XFILLER_120_124 VGND VGND VPWR VPWR sky130_fd_sc_hd__decap_3
XFILLER_126_97 VGND VGND VPWR VPWR sky130_fd_sc_hd__decap_3
XFILLER_121_669 VGND VGND VPWR VPWR sky130_fd_sc_hd__decap_3
XFILLER_87_561 VGND VGND VPWR VPWR sky130_fd_sc_hd__decap_3
XFILLER_120_168 VGND VGND VPWR VPWR sky130_fd_sc_hd__decap_3
XFILLER_47_414 VGND VGND VPWR VPWR sky130_fd_sc_hd__decap_3
XFILLER_19_116 VGND VGND VPWR VPWR sky130_fd_sc_hd__decap_3
XFILLER_47_447 VGND VGND VPWR VPWR sky130_fd_sc_hd__fill_1
XFILLER_74_233 VGND VGND VPWR VPWR sky130_fd_sc_hd__fill_1
XFILLER_90_704 VGND VGND VPWR VPWR sky130_fd_sc_hd__decap_3
XFILLER_34_119 VGND VGND VPWR VPWR sky130_fd_sc_hd__fill_1
XFILLER_15_300 VGND VGND VPWR VPWR sky130_fd_sc_hd__fill_2
XFILLER_62_439 VGND VGND VPWR VPWR sky130_fd_sc_hd__decap_3
XFILLER_15_333 VGND VGND VPWR VPWR sky130_fd_sc_hd__decap_3
XFILLER_43_653 VGND VGND VPWR VPWR sky130_fd_sc_hd__decap_3
XFILLER_70_472 VGND VGND VPWR VPWR sky130_fd_sc_hd__decap_3
XFILLER_35_94 VGND VGND VPWR VPWR sky130_fd_sc_hd__decap_3
XFILLER_43_697 VGND VGND VPWR VPWR sky130_fd_sc_hd__decap_3
XFILLER_15_399 VGND VGND VPWR VPWR sky130_fd_sc_hd__decap_3
XTAP_TAPCELL_ROW_41_832 VGND VPWR sky130_fd_sc_hd__tapvpwrvgnd_1
XFILLER_129_703 VGND VGND VPWR VPWR sky130_fd_sc_hd__decap_3
XFILLER_89_9 VGND VGND VPWR VPWR sky130_fd_sc_hd__decap_3
XFILLER_30_347 VGND VGND VPWR VPWR sky130_fd_sc_hd__decap_3
XFILLER_129_747 VGND VGND VPWR VPWR sky130_fd_sc_hd__decap_3
XFILLER_11_561 VGND VGND VPWR VPWR sky130_fd_sc_hd__decap_3
XFILLER_51_60 VGND VGND VPWR VPWR sky130_fd_sc_hd__fill_1
XFILLER_128_224 VGND VGND VPWR VPWR sky130_fd_sc_hd__decap_3
Xmax_cap207 _5097_/X VGND VGND VPWR VPWR _7528_/B2 sky130_fd_sc_hd__buf_2
XFILLER_124_441 VGND VGND VPWR VPWR sky130_fd_sc_hd__fill_1
XFILLER_3_771 VGND VGND VPWR VPWR sky130_fd_sc_hd__decap_3
XFILLER_112_636 VGND VGND VPWR VPWR sky130_fd_sc_hd__fill_1
XFILLER_111_113 VGND VGND VPWR VPWR sky130_fd_sc_hd__decap_3
XFILLER_66_701 VGND VGND VPWR VPWR sky130_fd_sc_hd__decap_3
XFILLER_38_414 VGND VGND VPWR VPWR sky130_fd_sc_hd__decap_3
XFILLER_93_520 VGND VGND VPWR VPWR sky130_fd_sc_hd__decap_3
XFILLER_66_734 VGND VGND VPWR VPWR sky130_fd_sc_hd__decap_3
XFILLER_18_3 VGND VGND VPWR VPWR sky130_fd_sc_hd__decap_3
XTAP_TAPCELL_ROW_49_943 VGND VPWR sky130_fd_sc_hd__tapvpwrvgnd_1
XFILLER_65_222 VGND VGND VPWR VPWR sky130_fd_sc_hd__fill_2
XFILLER_65_233 VGND VGND VPWR VPWR sky130_fd_sc_hd__decap_3
XFILLER_93_553 VGND VGND VPWR VPWR sky130_fd_sc_hd__decap_3
XFILLER_93_564 VGND VGND VPWR VPWR sky130_fd_sc_hd__decap_3
XFILLER_81_704 VGND VGND VPWR VPWR sky130_fd_sc_hd__decap_3
X_6980_ _7038_/A _6980_/B VGND VGND VPWR VPWR _6982_/C sky130_fd_sc_hd__xor2_2
XFILLER_65_266 VGND VGND VPWR VPWR sky130_fd_sc_hd__fill_1
XTAP_TAPCELL_ROW_105_1702 VGND VPWR sky130_fd_sc_hd__tapvpwrvgnd_1
XFILLER_80_203 VGND VGND VPWR VPWR sky130_fd_sc_hd__decap_3
XFILLER_25_119 VGND VGND VPWR VPWR sky130_fd_sc_hd__decap_3
X_5931_ _5790_/A input3/X _7534_/B _5930_/X VGND VGND VPWR VPWR _5931_/X sky130_fd_sc_hd__a31o_2
XFILLER_65_299 VGND VGND VPWR VPWR sky130_fd_sc_hd__decap_3
XFILLER_46_480 VGND VGND VPWR VPWR sky130_fd_sc_hd__decap_3
XFILLER_34_642 VGND VGND VPWR VPWR sky130_fd_sc_hd__fill_2
X_8650_ _8674_/A _8625_/Y _8643_/X _8649_/X VGND VGND VPWR VPWR _8650_/X sky130_fd_sc_hd__a31o_2
X_5862_ _5724_/B _5863_/A VGND VGND VPWR VPWR _5862_/X sky130_fd_sc_hd__and2b_2
XFILLER_61_461 VGND VGND VPWR VPWR sky130_fd_sc_hd__decap_3
X_7601_ _7602_/A _7602_/B VGND VGND VPWR VPWR _7601_/Y sky130_fd_sc_hd__nand2_2
XFILLER_34_697 VGND VGND VPWR VPWR sky130_fd_sc_hd__decap_3
X_4813_ _4847_/A1 _9136_/Q _4819_/S VGND VGND VPWR VPWR _4813_/X sky130_fd_sc_hd__mux2_2
X_8581_ _8581_/A VGND VGND VPWR VPWR _8581_/Y sky130_fd_sc_hd__inv_2
X_5793_ _7227_/B1 _5546_/B _5793_/S VGND VGND VPWR VPWR _5794_/B sky130_fd_sc_hd__mux2_2
X_7532_ _7728_/A _7243_/A _7532_/B1 VGND VGND VPWR VPWR _7533_/B sky130_fd_sc_hd__o21ai_2
X_4744_ _4777_/A1 _9103_/Q _4756_/S VGND VGND VPWR VPWR _4744_/X sky130_fd_sc_hd__mux2_2
Xrebuffer607 _8579_/Y VGND VGND VPWR VPWR _8580_/B sky130_fd_sc_hd__buf_2
XTAP_TAPCELL_ROW_60_1086 VGND VPWR sky130_fd_sc_hd__tapvpwrvgnd_1
X_4675_ _9086_/Q hold892/X _4693_/S VGND VGND VPWR VPWR _4675_/X sky130_fd_sc_hd__mux2_2
X_7463_ _7635_/A _7635_/B VGND VGND VPWR VPWR _7465_/A sky130_fd_sc_hd__nand2_2
XTAP_TAPCELL_ROW_60_1097 VGND VPWR sky130_fd_sc_hd__tapvpwrvgnd_1
XFILLER_107_419 VGND VGND VPWR VPWR sky130_fd_sc_hd__fill_1
X_9202_ _9204_/CLK _9202_/D fanout415/A VGND VGND VPWR VPWR _9202_/Q sky130_fd_sc_hd__dfrtp_2
XFILLER_119_279 VGND VGND VPWR VPWR sky130_fd_sc_hd__fill_1
X_6414_ _6414_/A _7668_/A VGND VGND VPWR VPWR _6414_/X sky130_fd_sc_hd__xor2_4
X_7394_ _7394_/A _7394_/B VGND VGND VPWR VPWR _7394_/Y sky130_fd_sc_hd__xnor2_2
XTAP_TAPCELL_ROW_116_1842 VGND VPWR sky130_fd_sc_hd__tapvpwrvgnd_1
XTAP_TAPCELL_ROW_116_1853 VGND VPWR sky130_fd_sc_hd__tapvpwrvgnd_1
Xoutput19 _7561_/A VGND VGND VPWR VPWR wire113/A sky130_fd_sc_hd__buf_1
X_9133_ _9133_/CLK _9133_/D load_slew394/X VGND VGND VPWR VPWR _9133_/Q sky130_fd_sc_hd__dfrtp_2
XFILLER_127_290 VGND VGND VPWR VPWR sky130_fd_sc_hd__decap_3
X_6345_ _6345_/A _6345_/B _6345_/C _6345_/D VGND VGND VPWR VPWR _6345_/Y sky130_fd_sc_hd__nor4_4
XFILLER_115_441 VGND VGND VPWR VPWR sky130_fd_sc_hd__decap_3
XFILLER_115_452 VGND VGND VPWR VPWR sky130_fd_sc_hd__decap_3
XFILLER_103_614 VGND VGND VPWR VPWR sky130_fd_sc_hd__fill_2
XFILLER_0_218 VGND VGND VPWR VPWR sky130_fd_sc_hd__decap_3
X_6276_ _7445_/A _5893_/B _6274_/X _6275_/X VGND VGND VPWR VPWR _6560_/B sky130_fd_sc_hd__a211o_2
X_9064_ _9142_/CLK _9064_/D load_slew404/X VGND VGND VPWR VPWR _9064_/Q sky130_fd_sc_hd__dfrtp_2
XFILLER_102_113 VGND VGND VPWR VPWR sky130_fd_sc_hd__decap_3
XFILLER_103_658 VGND VGND VPWR VPWR sky130_fd_sc_hd__decap_3
XFILLER_102_135 VGND VGND VPWR VPWR sky130_fd_sc_hd__decap_3
XFILLER_103_669 VGND VGND VPWR VPWR sky130_fd_sc_hd__decap_3
X_5227_ _5227_/A VGND VGND VPWR VPWR _9200_/D sky130_fd_sc_hd__buf_1
X_8015_ _8015_/A _8025_/S VGND VGND VPWR VPWR _8015_/Y sky130_fd_sc_hd__nor2_2
XFILLER_130_477 VGND VGND VPWR VPWR sky130_fd_sc_hd__decap_3
XFILLER_69_572 VGND VGND VPWR VPWR sky130_fd_sc_hd__decap_3
X_5158_ _5154_/X _5157_/Y _5016_/A VGND VGND VPWR VPWR _5160_/B sky130_fd_sc_hd__o21ai_2
XFILLER_56_38 VGND VGND VPWR VPWR sky130_fd_sc_hd__decap_3
XFILLER_29_447 VGND VGND VPWR VPWR sky130_fd_sc_hd__fill_1
XFILLER_84_553 VGND VGND VPWR VPWR sky130_fd_sc_hd__decap_3
XFILLER_29_458 VGND VGND VPWR VPWR sky130_fd_sc_hd__decap_3
X_5089_ hold777/X _5669_/A _5530_/S VGND VGND VPWR VPWR _5089_/X sky130_fd_sc_hd__mux2_2
XFILLER_71_203 VGND VGND VPWR VPWR sky130_fd_sc_hd__decap_3
XFILLER_44_417 VGND VGND VPWR VPWR sky130_fd_sc_hd__decap_3
XFILLER_16_119 VGND VGND VPWR VPWR sky130_fd_sc_hd__decap_3
X_8917_ _9301_/Q hold858/X _8925_/S VGND VGND VPWR VPWR _8917_/X sky130_fd_sc_hd__mux2_2
XFILLER_71_225 VGND VGND VPWR VPWR sky130_fd_sc_hd__decap_3
XFILLER_112_44 VGND VGND VPWR VPWR sky130_fd_sc_hd__decap_3
XTAP_TAPCELL_ROW_27_648 VGND VPWR sky130_fd_sc_hd__tapvpwrvgnd_1
XTAP_TAPCELL_ROW_127_1993 VGND VPWR sky130_fd_sc_hd__tapvpwrvgnd_1
XFILLER_25_642 VGND VGND VPWR VPWR sky130_fd_sc_hd__fill_2
X_8848_ hold960/X _8848_/A1 _8862_/S VGND VGND VPWR VPWR _8849_/A sky130_fd_sc_hd__mux2_2
XFILLER_24_141 VGND VGND VPWR VPWR sky130_fd_sc_hd__decap_3
XFILLER_112_88 VGND VGND VPWR VPWR sky130_fd_sc_hd__decap_3
XFILLER_52_461 VGND VGND VPWR VPWR sky130_fd_sc_hd__decap_3
XFILLER_72_59 VGND VGND VPWR VPWR sky130_fd_sc_hd__fill_2
XFILLER_24_174 VGND VGND VPWR VPWR sky130_fd_sc_hd__decap_3
XFILLER_40_634 VGND VGND VPWR VPWR sky130_fd_sc_hd__decap_3
X_8779_ _8779_/A _8779_/B VGND VGND VPWR VPWR _9236_/D sky130_fd_sc_hd__xor2_2
XFILLER_8_307 VGND VGND VPWR VPWR sky130_fd_sc_hd__fill_1
XFILLER_122_3 VGND VGND VPWR VPWR sky130_fd_sc_hd__decap_3
XTAP_TAPCELL_ROW_78_1336 VGND VPWR sky130_fd_sc_hd__tapvpwrvgnd_1
XFILLER_21_30 VGND VGND VPWR VPWR sky130_fd_sc_hd__fill_1
XFILLER_126_728 VGND VGND VPWR VPWR sky130_fd_sc_hd__decap_3
XFILLER_125_205 VGND VGND VPWR VPWR sky130_fd_sc_hd__decap_3
XFILLER_4_513 VGND VGND VPWR VPWR sky130_fd_sc_hd__decap_3
XFILLER_125_249 VGND VGND VPWR VPWR sky130_fd_sc_hd__decap_3
XFILLER_106_430 VGND VGND VPWR VPWR sky130_fd_sc_hd__decap_3
XTAP_TAPCELL_ROW_91_1514 VGND VPWR sky130_fd_sc_hd__tapvpwrvgnd_1
XFILLER_4_568 VGND VGND VPWR VPWR sky130_fd_sc_hd__decap_3
XFILLER_106_463 VGND VGND VPWR VPWR sky130_fd_sc_hd__decap_3
XFILLER_121_433 VGND VGND VPWR VPWR sky130_fd_sc_hd__fill_2
XFILLER_0_741 VGND VGND VPWR VPWR sky130_fd_sc_hd__decap_3
XFILLER_121_466 VGND VGND VPWR VPWR sky130_fd_sc_hd__decap_3
XFILLER_0_763 VGND VGND VPWR VPWR sky130_fd_sc_hd__decap_3
XTAP_TAPCELL_ROW_7_373 VGND VPWR sky130_fd_sc_hd__tapvpwrvgnd_1
XFILLER_121_499 VGND VGND VPWR VPWR sky130_fd_sc_hd__decap_3
XFILLER_87_380 VGND VGND VPWR VPWR sky130_fd_sc_hd__decap_3
XFILLER_75_531 VGND VGND VPWR VPWR sky130_fd_sc_hd__decap_3
XFILLER_75_564 VGND VGND VPWR VPWR sky130_fd_sc_hd__decap_3
XTAP_TAPCELL_ROW_46_902 VGND VPWR sky130_fd_sc_hd__tapvpwrvgnd_1
XFILLER_90_501 VGND VGND VPWR VPWR sky130_fd_sc_hd__decap_3
XTAP_TAPCELL_ROW_89_1487 VGND VPWR sky130_fd_sc_hd__tapvpwrvgnd_1
XFILLER_63_726 VGND VGND VPWR VPWR sky130_fd_sc_hd__fill_2
XFILLER_35_417 VGND VGND VPWR VPWR sky130_fd_sc_hd__decap_3
XFILLER_75_597 VGND VGND VPWR VPWR sky130_fd_sc_hd__decap_3
Xmax_cap50 _6919_/B VGND VGND VPWR VPWR _7272_/B sky130_fd_sc_hd__clkbuf_2
XFILLER_28_480 VGND VGND VPWR VPWR sky130_fd_sc_hd__decap_3
XFILLER_46_82 VGND VGND VPWR VPWR sky130_fd_sc_hd__fill_2
XFILLER_90_556 VGND VGND VPWR VPWR sky130_fd_sc_hd__decap_3
Xmax_cap72 _7913_/A VGND VGND VPWR VPWR _8364_/B sky130_fd_sc_hd__buf_2
Xmax_cap83 _6719_/Y VGND VGND VPWR VPWR _6732_/A sky130_fd_sc_hd__clkbuf_2
Xmax_cap94 _7960_/C VGND VGND VPWR VPWR _8237_/A sky130_fd_sc_hd__buf_4
XFILLER_90_589 VGND VGND VPWR VPWR sky130_fd_sc_hd__decap_3
XFILLER_31_601 VGND VGND VPWR VPWR sky130_fd_sc_hd__decap_3
XFILLER_71_770 VGND VGND VPWR VPWR sky130_fd_sc_hd__decap_3
XFILLER_43_461 VGND VGND VPWR VPWR sky130_fd_sc_hd__decap_3
XFILLER_16_697 VGND VGND VPWR VPWR sky130_fd_sc_hd__decap_3
XFILLER_15_196 VGND VGND VPWR VPWR sky130_fd_sc_hd__fill_2
XFILLER_31_656 VGND VGND VPWR VPWR sky130_fd_sc_hd__decap_3
XFILLER_30_122 VGND VGND VPWR VPWR sky130_fd_sc_hd__decap_3
XTAP_TAPCELL_ROW_100_1632 VGND VPWR sky130_fd_sc_hd__tapvpwrvgnd_1
XFILLER_87_6 VGND VGND VPWR VPWR sky130_fd_sc_hd__fill_1
XFILLER_62_81 VGND VGND VPWR VPWR sky130_fd_sc_hd__decap_3
XFILLER_7_21 VGND VGND VPWR VPWR sky130_fd_sc_hd__decap_3
XFILLER_7_340 VGND VGND VPWR VPWR sky130_fd_sc_hd__decap_3
XFILLER_7_54 VGND VGND VPWR VPWR sky130_fd_sc_hd__fill_2
Xwire260 _5187_/C VGND VGND VPWR VPWR _5463_/C sky130_fd_sc_hd__buf_6
XFILLER_129_588 VGND VGND VPWR VPWR sky130_fd_sc_hd__decap_3
XFILLER_116_238 VGND VGND VPWR VPWR sky130_fd_sc_hd__decap_3
XFILLER_125_750 VGND VGND VPWR VPWR sky130_fd_sc_hd__decap_3
X_6130_ _6134_/B _5942_/B VGND VGND VPWR VPWR _6130_/X sky130_fd_sc_hd__or2b_2
XFILLER_98_623 VGND VGND VPWR VPWR sky130_fd_sc_hd__decap_3
XFILLER_124_271 VGND VGND VPWR VPWR sky130_fd_sc_hd__fill_2
XFILLER_98_645 VGND VGND VPWR VPWR sky130_fd_sc_hd__decap_3
XFILLER_97_122 VGND VGND VPWR VPWR sky130_fd_sc_hd__decap_3
X_6061_ _6143_/A _6143_/B _6061_/C _6064_/A1 VGND VGND VPWR VPWR _6061_/X sky130_fd_sc_hd__or4b_4
Xload_slew254 _5143_/B VGND VGND VPWR VPWR _6206_/C sky130_fd_sc_hd__buf_4
X_5012_ _4984_/Y _5043_/B _5048_/B VGND VGND VPWR VPWR _5012_/X sky130_fd_sc_hd__a21o_2
Xhold1007 _9024_/Q VGND VGND VPWR VPWR _4577_/A1 sky130_fd_sc_hd__dlygate4sd3_1
XTAP_TAPCELL_ROW_111_1783 VGND VPWR sky130_fd_sc_hd__tapvpwrvgnd_1
XFILLER_100_639 VGND VGND VPWR VPWR sky130_fd_sc_hd__decap_3
Xhold1018 _9098_/Q VGND VGND VPWR VPWR _4733_/A1 sky130_fd_sc_hd__dlygate4sd3_1
XFILLER_38_200 VGND VGND VPWR VPWR sky130_fd_sc_hd__fill_2
XFILLER_112_499 VGND VGND VPWR VPWR sky130_fd_sc_hd__fill_1
Xhold1029 _9313_/Q VGND VGND VPWR VPWR _8976_/A1 sky130_fd_sc_hd__dlygate4sd3_1
XFILLER_78_380 VGND VGND VPWR VPWR sky130_fd_sc_hd__fill_1
XFILLER_78_391 VGND VGND VPWR VPWR sky130_fd_sc_hd__fill_2
XFILLER_38_222 VGND VGND VPWR VPWR sky130_fd_sc_hd__decap_3
XFILLER_66_542 VGND VGND VPWR VPWR sky130_fd_sc_hd__fill_1
XFILLER_54_726 VGND VGND VPWR VPWR sky130_fd_sc_hd__decap_3
XFILLER_81_534 VGND VGND VPWR VPWR sky130_fd_sc_hd__decap_3
XFILLER_53_225 VGND VGND VPWR VPWR sky130_fd_sc_hd__decap_3
XFILLER_38_299 VGND VGND VPWR VPWR sky130_fd_sc_hd__decap_3
X_6963_ _6963_/A _6963_/B _6963_/C _6963_/D VGND VGND VPWR VPWR _6963_/X sky130_fd_sc_hd__or4_4
X_8702_ _9229_/Q _8666_/A _8700_/Y _8753_/A _8701_/Y VGND VGND VPWR VPWR _8702_/X
+ sky130_fd_sc_hd__o221a_2
X_5914_ _5914_/A _6514_/A VGND VGND VPWR VPWR _5914_/X sky130_fd_sc_hd__xor2_2
XTAP_TAPCELL_ROW_24_607 VGND VPWR sky130_fd_sc_hd__tapvpwrvgnd_1
X_6894_ _6894_/A VGND VGND VPWR VPWR _6894_/Y sky130_fd_sc_hd__inv_2
XTAP_TAPCELL_ROW_62_1115 VGND VPWR sky130_fd_sc_hd__tapvpwrvgnd_1
XFILLER_34_483 VGND VGND VPWR VPWR sky130_fd_sc_hd__decap_3
X_8633_ _8633_/A _8633_/B _8633_/C _8607_/B VGND VGND VPWR VPWR _8633_/X sky130_fd_sc_hd__or4b_2
XFILLER_22_634 VGND VGND VPWR VPWR sky130_fd_sc_hd__decap_3
XFILLER_21_100 VGND VGND VPWR VPWR sky130_fd_sc_hd__decap_3
X_5845_ _6160_/A1 _5844_/X _5713_/Y _5711_/Y VGND VGND VPWR VPWR _5845_/X sky130_fd_sc_hd__a22o_2
XFILLER_22_645 VGND VGND VPWR VPWR sky130_fd_sc_hd__decap_3
XFILLER_21_122 VGND VGND VPWR VPWR sky130_fd_sc_hd__decap_3
XFILLER_42_29 VGND VGND VPWR VPWR sky130_fd_sc_hd__decap_3
X_8564_ _9224_/Q wire71/X _8560_/Y _8561_/X _8563_/X VGND VGND VPWR VPWR _8564_/X
+ sky130_fd_sc_hd__o311a_2
X_5776_ _5816_/B _5816_/A VGND VGND VPWR VPWR _5776_/X sky130_fd_sc_hd__xor2_2
X_7515_ _7661_/B _7659_/A VGND VGND VPWR VPWR _7515_/X sky130_fd_sc_hd__or2_2
X_4727_ _9111_/Q _4727_/A1 _4735_/S VGND VGND VPWR VPWR _4727_/X sky130_fd_sc_hd__mux2_2
Xrebuffer426 _8706_/A VGND VGND VPWR VPWR _8771_/A sky130_fd_sc_hd__buf_2
X_8495_ _7593_/X _8350_/B _8494_/X VGND VGND VPWR VPWR _8548_/A sky130_fd_sc_hd__a21o_2
Xrebuffer437 _5272_/A VGND VGND VPWR VPWR _6715_/A2 sky130_fd_sc_hd__buf_2
Xrebuffer448 _8393_/X VGND VGND VPWR VPWR _8459_/B sky130_fd_sc_hd__buf_2
XFILLER_108_728 VGND VGND VPWR VPWR sky130_fd_sc_hd__decap_3
Xrebuffer459 _7404_/B VGND VGND VPWR VPWR _6573_/B1 sky130_fd_sc_hd__buf_2
X_7446_ _6626_/A _6626_/B _7805_/A VGND VGND VPWR VPWR _7448_/A sky130_fd_sc_hd__a21o_2
X_4658_ _4691_/A1 _4658_/A1 _4672_/S VGND VGND VPWR VPWR _4659_/A sky130_fd_sc_hd__mux2_2
Xhold830 _8984_/X VGND VGND VPWR VPWR _8985_/A sky130_fd_sc_hd__dlygate4sd3_1
X_7377_ _7377_/A _7377_/B VGND VGND VPWR VPWR _7382_/B sky130_fd_sc_hd__nand2_2
Xhold841 _9025_/Q VGND VGND VPWR VPWR hold841/X sky130_fd_sc_hd__dlygate4sd3_1
X_4589_ _9015_/S VGND VGND VPWR VPWR _4608_/S sky130_fd_sc_hd__clkbuf_2
Xhold852 _9269_/Q VGND VGND VPWR VPWR hold852/X sky130_fd_sc_hd__dlygate4sd3_1
Xhold863 _8852_/X VGND VGND VPWR VPWR _8853_/A sky130_fd_sc_hd__dlygate4sd3_1
X_9116_ _9133_/CLK _9116_/D load_slew393/X VGND VGND VPWR VPWR _9116_/Q sky130_fd_sc_hd__dfrtp_2
XFILLER_107_33 VGND VGND VPWR VPWR sky130_fd_sc_hd__decap_3
X_6328_ _6193_/A _6326_/Y _6327_/Y VGND VGND VPWR VPWR _6526_/A sky130_fd_sc_hd__a21o_4
Xhold874 _9082_/Q VGND VGND VPWR VPWR hold874/X sky130_fd_sc_hd__dlygate4sd3_1
Xhold885 _4644_/X VGND VGND VPWR VPWR _4645_/A sky130_fd_sc_hd__dlygate4sd3_1
XFILLER_89_645 VGND VGND VPWR VPWR sky130_fd_sc_hd__decap_3
XFILLER_1_538 VGND VGND VPWR VPWR sky130_fd_sc_hd__decap_3
XFILLER_103_433 VGND VGND VPWR VPWR sky130_fd_sc_hd__decap_3
XFILLER_107_55 VGND VGND VPWR VPWR sky130_fd_sc_hd__fill_1
Xhold896 _9296_/Q VGND VGND VPWR VPWR hold896/X sky130_fd_sc_hd__dlygate4sd3_1
XTAP_TAPCELL_ROW_73_1266 VGND VPWR sky130_fd_sc_hd__tapvpwrvgnd_1
XFILLER_103_455 VGND VGND VPWR VPWR sky130_fd_sc_hd__decap_3
X_9047_ _9348_/CLK _9047_/D load_slew390/X VGND VGND VPWR VPWR _9047_/Q sky130_fd_sc_hd__dfrtp_2
X_6259_ _6260_/C _6260_/B _6260_/A VGND VGND VPWR VPWR _6261_/A sky130_fd_sc_hd__a21o_4
XFILLER_76_306 VGND VGND VPWR VPWR sky130_fd_sc_hd__fill_2
XFILLER_130_274 VGND VGND VPWR VPWR sky130_fd_sc_hd__decap_3
XTAP_TAPCELL_ROW_4_332 VGND VPWR sky130_fd_sc_hd__tapvpwrvgnd_1
XFILLER_57_520 VGND VGND VPWR VPWR sky130_fd_sc_hd__decap_3
XFILLER_123_21 VGND VGND VPWR VPWR sky130_fd_sc_hd__decap_3
XFILLER_29_233 VGND VGND VPWR VPWR sky130_fd_sc_hd__decap_3
XFILLER_123_54 VGND VGND VPWR VPWR sky130_fd_sc_hd__fill_2
XFILLER_72_501 VGND VGND VPWR VPWR sky130_fd_sc_hd__decap_3
XFILLER_72_512 VGND VGND VPWR VPWR sky130_fd_sc_hd__decap_3
XFILLER_44_203 VGND VGND VPWR VPWR sky130_fd_sc_hd__decap_3
XFILLER_17_417 VGND VGND VPWR VPWR sky130_fd_sc_hd__decap_3
XFILLER_57_597 VGND VGND VPWR VPWR sky130_fd_sc_hd__fill_2
XFILLER_123_87 VGND VGND VPWR VPWR sky130_fd_sc_hd__decap_3
XFILLER_44_236 VGND VGND VPWR VPWR sky130_fd_sc_hd__decap_3
XFILLER_60_707 VGND VGND VPWR VPWR sky130_fd_sc_hd__decap_3
XFILLER_32_409 VGND VGND VPWR VPWR sky130_fd_sc_hd__decap_3
XFILLER_16_41 VGND VGND VPWR VPWR sky130_fd_sc_hd__decap_3
XFILLER_72_589 VGND VGND VPWR VPWR sky130_fd_sc_hd__decap_3
XFILLER_53_770 VGND VGND VPWR VPWR sky130_fd_sc_hd__decap_3
XFILLER_13_601 VGND VGND VPWR VPWR sky130_fd_sc_hd__fill_2
XFILLER_25_472 VGND VGND VPWR VPWR sky130_fd_sc_hd__decap_3
XFILLER_16_74 VGND VGND VPWR VPWR sky130_fd_sc_hd__decap_3
XFILLER_16_85 VGND VGND VPWR VPWR sky130_fd_sc_hd__decap_3
XPHY_EDGE_ROW_11_Right_11 VGND VGND VPWR VPWR sky130_fd_sc_hd__decap_3
XFILLER_52_291 VGND VGND VPWR VPWR sky130_fd_sc_hd__fill_2
XFILLER_12_122 VGND VGND VPWR VPWR sky130_fd_sc_hd__fill_1
XFILLER_13_667 VGND VGND VPWR VPWR sky130_fd_sc_hd__decap_3
XTAP_TAPCELL_ROW_51_971 VGND VPWR sky130_fd_sc_hd__tapvpwrvgnd_1
XFILLER_9_649 VGND VGND VPWR VPWR sky130_fd_sc_hd__fill_2
XFILLER_40_497 VGND VGND VPWR VPWR sky130_fd_sc_hd__decap_3
XFILLER_12_188 VGND VGND VPWR VPWR sky130_fd_sc_hd__decap_3
XFILLER_32_62 VGND VGND VPWR VPWR sky130_fd_sc_hd__decap_3
XFILLER_126_536 VGND VGND VPWR VPWR sky130_fd_sc_hd__decap_3
XFILLER_126_558 VGND VGND VPWR VPWR sky130_fd_sc_hd__decap_3
XFILLER_4_365 VGND VGND VPWR VPWR sky130_fd_sc_hd__decap_3
XPHY_EDGE_ROW_20_Right_20 VGND VGND VPWR VPWR sky130_fd_sc_hd__decap_3
XFILLER_122_742 VGND VGND VPWR VPWR sky130_fd_sc_hd__decap_3
XFILLER_121_241 VGND VGND VPWR VPWR sky130_fd_sc_hd__decap_3
XFILLER_122_775 VGND VGND VPWR VPWR sky130_fd_sc_hd__fill_2
XFILLER_95_626 VGND VGND VPWR VPWR sky130_fd_sc_hd__decap_3
XFILLER_121_274 VGND VGND VPWR VPWR sky130_fd_sc_hd__decap_3
XFILLER_0_582 VGND VGND VPWR VPWR sky130_fd_sc_hd__decap_3
XFILLER_121_296 VGND VGND VPWR VPWR sky130_fd_sc_hd__decap_3
XFILLER_48_542 VGND VGND VPWR VPWR sky130_fd_sc_hd__decap_3
XFILLER_82_309 VGND VGND VPWR VPWR sky130_fd_sc_hd__decap_3
XFILLER_75_361 VGND VGND VPWR VPWR sky130_fd_sc_hd__fill_1
XFILLER_36_715 VGND VGND VPWR VPWR sky130_fd_sc_hd__decap_3
XFILLER_75_383 VGND VGND VPWR VPWR sky130_fd_sc_hd__fill_2
XFILLER_35_225 VGND VGND VPWR VPWR sky130_fd_sc_hd__decap_3
XFILLER_50_217 VGND VGND VPWR VPWR sky130_fd_sc_hd__decap_3
XFILLER_16_483 VGND VGND VPWR VPWR sky130_fd_sc_hd__decap_3
X_5630_ _7430_/B VGND VGND VPWR VPWR _8050_/B sky130_fd_sc_hd__clkbuf_2
XFILLER_31_464 VGND VGND VPWR VPWR sky130_fd_sc_hd__decap_3
X_5561_ _5561_/A _5561_/B VGND VGND VPWR VPWR _5561_/Y sky130_fd_sc_hd__xnor2_2
X_7300_ _7300_/A _7300_/B VGND VGND VPWR VPWR _7301_/B sky130_fd_sc_hd__nand2_2
XFILLER_117_514 VGND VGND VPWR VPWR sky130_fd_sc_hd__decap_3
X_5492_ _5493_/C _5396_/A VGND VGND VPWR VPWR _5492_/X sky130_fd_sc_hd__or2b_2
X_8280_ _8283_/B _8278_/X _8299_/B VGND VGND VPWR VPWR _8297_/A sky130_fd_sc_hd__o21ai_2
XFILLER_117_558 VGND VGND VPWR VPWR sky130_fd_sc_hd__fill_2
X_7231_ _7231_/A _7520_/B VGND VGND VPWR VPWR _7232_/B sky130_fd_sc_hd__xnor2_2
XTAP_TAPCELL_ROW_113_1801 VGND VPWR sky130_fd_sc_hd__tapvpwrvgnd_1
XTAP_TAPCELL_ROW_113_1812 VGND VPWR sky130_fd_sc_hd__tapvpwrvgnd_1
X_7162_ _8009_/A _7159_/Y _7161_/Y _7212_/A _6859_/A VGND VGND VPWR VPWR _7163_/B
+ sky130_fd_sc_hd__o221a_2
XFILLER_113_753 VGND VGND VPWR VPWR sky130_fd_sc_hd__decap_3
X_6113_ _6113_/A _6415_/A VGND VGND VPWR VPWR _6113_/X sky130_fd_sc_hd__xor2_2
X_7093_ _7093_/A _7099_/C VGND VGND VPWR VPWR _7093_/Y sky130_fd_sc_hd__nand2_2
XTAP_TAPCELL_ROW_129_2019 VGND VPWR sky130_fd_sc_hd__tapvpwrvgnd_1
XPHY_EDGE_ROW_13_Left_144 VGND VGND VPWR VPWR sky130_fd_sc_hd__decap_3
XFILLER_86_637 VGND VGND VPWR VPWR sky130_fd_sc_hd__decap_3
XFILLER_85_103 VGND VGND VPWR VPWR sky130_fd_sc_hd__fill_1
XFILLER_58_328 VGND VGND VPWR VPWR sky130_fd_sc_hd__fill_2
X_6044_ _5849_/A _5849_/B _6043_/X VGND VGND VPWR VPWR _6186_/B sky130_fd_sc_hd__o21a_2
XFILLER_86_648 VGND VGND VPWR VPWR sky130_fd_sc_hd__decap_3
XFILLER_100_458 VGND VGND VPWR VPWR sky130_fd_sc_hd__decap_3
XFILLER_37_29 VGND VGND VPWR VPWR sky130_fd_sc_hd__fill_2
XFILLER_39_575 VGND VGND VPWR VPWR sky130_fd_sc_hd__decap_3
XFILLER_27_715 VGND VGND VPWR VPWR sky130_fd_sc_hd__decap_3
XFILLER_94_670 VGND VGND VPWR VPWR sky130_fd_sc_hd__decap_3
XFILLER_54_501 VGND VGND VPWR VPWR sky130_fd_sc_hd__decap_3
XFILLER_26_203 VGND VGND VPWR VPWR sky130_fd_sc_hd__fill_2
XFILLER_66_383 VGND VGND VPWR VPWR sky130_fd_sc_hd__decap_3
XFILLER_54_523 VGND VGND VPWR VPWR sky130_fd_sc_hd__decap_3
XFILLER_27_737 VGND VGND VPWR VPWR sky130_fd_sc_hd__decap_3
X_7995_ _7748_/S _7857_/B _7741_/Y VGND VGND VPWR VPWR _7995_/X sky130_fd_sc_hd__a21o_2
XFILLER_54_556 VGND VGND VPWR VPWR sky130_fd_sc_hd__decap_3
XFILLER_26_247 VGND VGND VPWR VPWR sky130_fd_sc_hd__decap_3
XTAP_TAPCELL_ROW_124_1952 VGND VPWR sky130_fd_sc_hd__tapvpwrvgnd_1
X_6946_ _6946_/A _6946_/B VGND VGND VPWR VPWR _6947_/B sky130_fd_sc_hd__nor2_2
XTAP_TAPCELL_ROW_37_776 VGND VPWR sky130_fd_sc_hd__tapvpwrvgnd_1
XFILLER_54_589 VGND VGND VPWR VPWR sky130_fd_sc_hd__decap_3
XTAP_TAPCELL_ROW_37_787 VGND VPWR sky130_fd_sc_hd__tapvpwrvgnd_1
XFILLER_53_39 VGND VGND VPWR VPWR sky130_fd_sc_hd__decap_3
XFILLER_41_217 VGND VGND VPWR VPWR sky130_fd_sc_hd__decap_3
XFILLER_41_228 VGND VGND VPWR VPWR sky130_fd_sc_hd__fill_1
X_6877_ _7532_/B1 _7877_/A _6876_/X VGND VGND VPWR VPWR _6878_/B sky130_fd_sc_hd__o21a_2
XFILLER_50_751 VGND VGND VPWR VPWR sky130_fd_sc_hd__decap_3
XPHY_EDGE_ROW_22_Left_153 VGND VGND VPWR VPWR sky130_fd_sc_hd__decap_3
X_8616_ _9225_/Q _8566_/A _8566_/Y _9226_/Q _8398_/A VGND VGND VPWR VPWR _8616_/X
+ sky130_fd_sc_hd__a221o_2
X_5828_ _6057_/A _6057_/B VGND VGND VPWR VPWR _5860_/A sky130_fd_sc_hd__xnor2_4
XFILLER_22_475 VGND VGND VPWR VPWR sky130_fd_sc_hd__fill_1
XFILLER_10_615 VGND VGND VPWR VPWR sky130_fd_sc_hd__decap_3
XFILLER_10_648 VGND VGND VPWR VPWR sky130_fd_sc_hd__fill_1
X_8547_ _8547_/A _8547_/B VGND VGND VPWR VPWR _8547_/Y sky130_fd_sc_hd__nand2_2
X_5759_ _5973_/A _5820_/B VGND VGND VPWR VPWR _5763_/A sky130_fd_sc_hd__xnor2_2
XFILLER_5_107 VGND VGND VPWR VPWR sky130_fd_sc_hd__decap_3
XFILLER_108_536 VGND VGND VPWR VPWR sky130_fd_sc_hd__decap_3
X_8478_ _8389_/Y _8521_/S _8476_/X _8431_/B _8477_/Y VGND VGND VPWR VPWR _8478_/X
+ sky130_fd_sc_hd__a311o_2
XFILLER_118_21 VGND VGND VPWR VPWR sky130_fd_sc_hd__decap_3
XFILLER_118_32 VGND VGND VPWR VPWR sky130_fd_sc_hd__decap_3
XTAP_TAPCELL_ROW_9_402 VGND VPWR sky130_fd_sc_hd__tapvpwrvgnd_1
X_7429_ _7430_/B _7430_/C _8405_/B _7945_/A VGND VGND VPWR VPWR _7429_/X sky130_fd_sc_hd__o22a_2
XFILLER_123_517 VGND VGND VPWR VPWR sky130_fd_sc_hd__decap_3
XFILLER_118_65 VGND VGND VPWR VPWR sky130_fd_sc_hd__decap_3
XFILLER_78_47 VGND VGND VPWR VPWR sky130_fd_sc_hd__fill_2
XPHY_EDGE_ROW_31_Left_162 VGND VGND VPWR VPWR sky130_fd_sc_hd__decap_3
XFILLER_49_306 VGND VGND VPWR VPWR sky130_fd_sc_hd__decap_3
XFILLER_89_486 VGND VGND VPWR VPWR sky130_fd_sc_hd__decap_3
XFILLER_77_626 VGND VGND VPWR VPWR sky130_fd_sc_hd__decap_3
XFILLER_103_274 VGND VGND VPWR VPWR sky130_fd_sc_hd__decap_3
XFILLER_76_125 VGND VGND VPWR VPWR sky130_fd_sc_hd__decap_3
XFILLER_18_704 VGND VGND VPWR VPWR sky130_fd_sc_hd__decap_3
XFILLER_45_501 VGND VGND VPWR VPWR sky130_fd_sc_hd__decap_3
XFILLER_91_128 VGND VGND VPWR VPWR sky130_fd_sc_hd__decap_3
XFILLER_85_692 VGND VGND VPWR VPWR sky130_fd_sc_hd__decap_3
XFILLER_18_737 VGND VGND VPWR VPWR sky130_fd_sc_hd__decap_3
XFILLER_45_534 VGND VGND VPWR VPWR sky130_fd_sc_hd__decap_3
XTAP_TAPCELL_ROW_86_1446 VGND VPWR sky130_fd_sc_hd__tapvpwrvgnd_1
XFILLER_45_556 VGND VGND VPWR VPWR sky130_fd_sc_hd__decap_3
XFILLER_27_73 VGND VGND VPWR VPWR sky130_fd_sc_hd__decap_3
XFILLER_33_707 VGND VGND VPWR VPWR sky130_fd_sc_hd__decap_3
XFILLER_17_258 VGND VGND VPWR VPWR sky130_fd_sc_hd__decap_3
XFILLER_33_729 VGND VGND VPWR VPWR sky130_fd_sc_hd__decap_3
XFILLER_32_217 VGND VGND VPWR VPWR sky130_fd_sc_hd__decap_3
XPHY_EDGE_ROW_40_Left_171 VGND VGND VPWR VPWR sky130_fd_sc_hd__decap_3
XFILLER_43_50 VGND VGND VPWR VPWR sky130_fd_sc_hd__decap_3
XFILLER_9_402 VGND VGND VPWR VPWR sky130_fd_sc_hd__decap_3
XFILLER_9_446 VGND VGND VPWR VPWR sky130_fd_sc_hd__fill_2
XFILLER_9_479 VGND VGND VPWR VPWR sky130_fd_sc_hd__decap_3
XFILLER_126_322 VGND VGND VPWR VPWR sky130_fd_sc_hd__fill_2
XFILLER_126_344 VGND VGND VPWR VPWR sky130_fd_sc_hd__decap_3
XTAP_TAPCELL_ROW_97_1586 VGND VPWR sky130_fd_sc_hd__tapvpwrvgnd_1
XTAP_TAPCELL_ROW_97_1597 VGND VPWR sky130_fd_sc_hd__tapvpwrvgnd_1
XFILLER_126_377 VGND VGND VPWR VPWR sky130_fd_sc_hd__fill_1
XFILLER_114_517 VGND VGND VPWR VPWR sky130_fd_sc_hd__decap_3
XFILLER_99_228 VGND VGND VPWR VPWR sky130_fd_sc_hd__decap_3
XFILLER_5_685 VGND VGND VPWR VPWR sky130_fd_sc_hd__decap_3
XFILLER_126_388 VGND VGND VPWR VPWR sky130_fd_sc_hd__decap_3
XFILLER_107_591 VGND VGND VPWR VPWR sky130_fd_sc_hd__decap_3
XFILLER_4_44 VGND VGND VPWR VPWR sky130_fd_sc_hd__decap_3
XFILLER_4_66 VGND VGND VPWR VPWR sky130_fd_sc_hd__fill_1
XFILLER_110_701 VGND VGND VPWR VPWR sky130_fd_sc_hd__decap_3
XFILLER_4_88 VGND VGND VPWR VPWR sky130_fd_sc_hd__decap_3
XFILLER_68_648 VGND VGND VPWR VPWR sky130_fd_sc_hd__decap_3
XFILLER_68_91 VGND VGND VPWR VPWR sky130_fd_sc_hd__fill_2
XFILLER_67_158 VGND VGND VPWR VPWR sky130_fd_sc_hd__fill_2
XFILLER_55_309 VGND VGND VPWR VPWR sky130_fd_sc_hd__fill_1
XFILLER_67_169 VGND VGND VPWR VPWR sky130_fd_sc_hd__fill_2
XFILLER_82_128 VGND VGND VPWR VPWR sky130_fd_sc_hd__decap_3
XFILLER_36_523 VGND VGND VPWR VPWR sky130_fd_sc_hd__decap_3
X_6800_ _6857_/B _6800_/B VGND VGND VPWR VPWR _6801_/B sky130_fd_sc_hd__xnor2_2
XFILLER_91_662 VGND VGND VPWR VPWR sky130_fd_sc_hd__decap_3
XFILLER_91_673 VGND VGND VPWR VPWR sky130_fd_sc_hd__decap_3
XFILLER_63_364 VGND VGND VPWR VPWR sky130_fd_sc_hd__decap_3
X_7780_ _7951_/A _8066_/B VGND VGND VPWR VPWR _7781_/B sky130_fd_sc_hd__nor2_2
XFILLER_36_589 VGND VGND VPWR VPWR sky130_fd_sc_hd__decap_3
XFILLER_24_729 VGND VGND VPWR VPWR sky130_fd_sc_hd__decap_3
X_4992_ _5880_/B _5879_/C VGND VGND VPWR VPWR _4992_/X sky130_fd_sc_hd__and2_2
XFILLER_63_386 VGND VGND VPWR VPWR sky130_fd_sc_hd__decap_3
XFILLER_23_228 VGND VGND VPWR VPWR sky130_fd_sc_hd__decap_3
X_6731_ _6732_/C _6732_/D _6732_/A _6725_/Y VGND VGND VPWR VPWR _6733_/C sky130_fd_sc_hd__o211ai_2
XTAP_TAPCELL_ROW_34_735 VGND VPWR sky130_fd_sc_hd__tapvpwrvgnd_1
XTAP_TAPCELL_ROW_34_746 VGND VPWR sky130_fd_sc_hd__tapvpwrvgnd_1
XFILLER_51_559 VGND VGND VPWR VPWR sky130_fd_sc_hd__fill_1
X_6662_ _6636_/A _6660_/Y _6661_/Y VGND VGND VPWR VPWR _6662_/X sky130_fd_sc_hd__o21a_2
X_8401_ _8353_/A _8397_/Y _8400_/X VGND VGND VPWR VPWR _8454_/A sky130_fd_sc_hd__o21ai_2
XTAP_TAPCELL_ROW_14_470 VGND VPWR sky130_fd_sc_hd__tapvpwrvgnd_1
X_5613_ _9074_/Q _5456_/B _5115_/X _9090_/Q _5612_/X VGND VGND VPWR VPWR _5613_/Y
+ sky130_fd_sc_hd__a221oi_2
X_6593_ _6042_/A _6041_/B _6041_/A _6591_/A _6592_/X VGND VGND VPWR VPWR _6705_/A
+ sky130_fd_sc_hd__o32a_4
X_8332_ _8332_/A _8421_/B VGND VGND VPWR VPWR _8333_/B sky130_fd_sc_hd__xor2_2
X_5544_ _5544_/A _5544_/B VGND VGND VPWR VPWR _5553_/A sky130_fd_sc_hd__xnor2_2
XFILLER_117_322 VGND VGND VPWR VPWR sky130_fd_sc_hd__decap_3
XFILLER_8_490 VGND VGND VPWR VPWR sky130_fd_sc_hd__fill_2
XFILLER_129_193 VGND VGND VPWR VPWR sky130_fd_sc_hd__decap_3
X_8263_ _8367_/A _8263_/B VGND VGND VPWR VPWR _8264_/B sky130_fd_sc_hd__xnor2_2
XFILLER_105_517 VGND VGND VPWR VPWR sky130_fd_sc_hd__decap_3
X_5475_ _5475_/A1 _5830_/B _5830_/A _5474_/Y VGND VGND VPWR VPWR _5476_/A sky130_fd_sc_hd__a31o_4
XTAP_TAPCELL_ROW_57_1047 VGND VPWR sky130_fd_sc_hd__tapvpwrvgnd_1
XFILLER_117_388 VGND VGND VPWR VPWR sky130_fd_sc_hd__decap_3
X_7214_ _7264_/B _7259_/A VGND VGND VPWR VPWR _7215_/B sky130_fd_sc_hd__xor2_2
X_8194_ _9218_/Q _9219_/Q _8196_/C _8193_/X VGND VGND VPWR VPWR _8194_/X sky130_fd_sc_hd__o31a_2
Xfanout403 fanout407/X VGND VGND VPWR VPWR fanout403/X sky130_fd_sc_hd__clkdlybuf4s25_1
X_7145_ _7145_/A _7145_/B VGND VGND VPWR VPWR _7145_/Y sky130_fd_sc_hd__nor2_2
XTAP_TAPCELL_ROW_70_1225 VGND VPWR sky130_fd_sc_hd__tapvpwrvgnd_1
XFILLER_98_261 VGND VGND VPWR VPWR sky130_fd_sc_hd__decap_3
XFILLER_59_626 VGND VGND VPWR VPWR sky130_fd_sc_hd__decap_3
XFILLER_113_583 VGND VGND VPWR VPWR sky130_fd_sc_hd__fill_1
XFILLER_100_222 VGND VGND VPWR VPWR sky130_fd_sc_hd__decap_3
X_7076_ _7300_/A _7300_/B _7301_/A VGND VGND VPWR VPWR _7077_/C sky130_fd_sc_hd__a21o_2
XFILLER_86_445 VGND VGND VPWR VPWR sky130_fd_sc_hd__decap_3
XFILLER_74_607 VGND VGND VPWR VPWR sky130_fd_sc_hd__decap_3
X_6027_ _6206_/A _6027_/B VGND VGND VPWR VPWR _6028_/S sky130_fd_sc_hd__nor2_2
XFILLER_46_309 VGND VGND VPWR VPWR sky130_fd_sc_hd__fill_1
XFILLER_39_350 VGND VGND VPWR VPWR sky130_fd_sc_hd__decap_3
XFILLER_86_489 VGND VGND VPWR VPWR sky130_fd_sc_hd__decap_3
XFILLER_67_670 VGND VGND VPWR VPWR sky130_fd_sc_hd__fill_2
XFILLER_100_288 VGND VGND VPWR VPWR sky130_fd_sc_hd__decap_3
XFILLER_39_372 VGND VGND VPWR VPWR sky130_fd_sc_hd__decap_3
XFILLER_27_523 VGND VGND VPWR VPWR sky130_fd_sc_hd__decap_3
XFILLER_54_320 VGND VGND VPWR VPWR sky130_fd_sc_hd__decap_3
XFILLER_82_651 VGND VGND VPWR VPWR sky130_fd_sc_hd__decap_3
XFILLER_27_556 VGND VGND VPWR VPWR sky130_fd_sc_hd__decap_3
XFILLER_27_567 VGND VGND VPWR VPWR sky130_fd_sc_hd__decap_3
XFILLER_15_718 VGND VGND VPWR VPWR sky130_fd_sc_hd__decap_3
XFILLER_15_729 VGND VGND VPWR VPWR sky130_fd_sc_hd__decap_3
X_7978_ _7978_/A _7978_/B VGND VGND VPWR VPWR _7979_/B sky130_fd_sc_hd__xnor2_2
XTAP_TAPCELL_ROW_68_1198 VGND VPWR sky130_fd_sc_hd__tapvpwrvgnd_1
XFILLER_14_239 VGND VGND VPWR VPWR sky130_fd_sc_hd__decap_3
X_6929_ _6929_/A _6929_/B VGND VGND VPWR VPWR _6944_/B sky130_fd_sc_hd__and2_2
XFILLER_42_559 VGND VGND VPWR VPWR sky130_fd_sc_hd__decap_3
XFILLER_120_44 VGND VGND VPWR VPWR sky130_fd_sc_hd__decap_3
XFILLER_23_762 VGND VGND VPWR VPWR sky130_fd_sc_hd__decap_3
XFILLER_120_77 VGND VGND VPWR VPWR sky130_fd_sc_hd__decap_3
XFILLER_120_88 VGND VGND VPWR VPWR sky130_fd_sc_hd__decap_3
XTAP_TAPCELL_ROW_81_1376 VGND VPWR sky130_fd_sc_hd__tapvpwrvgnd_1
XFILLER_50_581 VGND VGND VPWR VPWR sky130_fd_sc_hd__decap_3
XFILLER_13_53 VGND VGND VPWR VPWR sky130_fd_sc_hd__decap_3
XFILLER_127_108 VGND VGND VPWR VPWR sky130_fd_sc_hd__decap_3
XFILLER_127_119 VGND VGND VPWR VPWR sky130_fd_sc_hd__decap_3
XFILLER_129_42 VGND VGND VPWR VPWR sky130_fd_sc_hd__decap_3
XFILLER_13_97 VGND VGND VPWR VPWR sky130_fd_sc_hd__decap_3
XFILLER_10_489 VGND VGND VPWR VPWR sky130_fd_sc_hd__decap_3
XFILLER_108_333 VGND VGND VPWR VPWR sky130_fd_sc_hd__fill_1
XFILLER_129_75 VGND VGND VPWR VPWR sky130_fd_sc_hd__decap_3
XFILLER_108_388 VGND VGND VPWR VPWR sky130_fd_sc_hd__decap_3
XFILLER_2_622 VGND VGND VPWR VPWR sky130_fd_sc_hd__decap_3
XFILLER_123_358 VGND VGND VPWR VPWR sky130_fd_sc_hd__decap_3
XFILLER_96_209 VGND VGND VPWR VPWR sky130_fd_sc_hd__fill_2
XFILLER_2_666 VGND VGND VPWR VPWR sky130_fd_sc_hd__decap_3
XFILLER_89_250 VGND VGND VPWR VPWR sky130_fd_sc_hd__decap_3
XFILLER_104_583 VGND VGND VPWR VPWR sky130_fd_sc_hd__decap_3
XFILLER_2_699 VGND VGND VPWR VPWR sky130_fd_sc_hd__fill_1
XFILLER_49_125 VGND VGND VPWR VPWR sky130_fd_sc_hd__decap_3
XFILLER_77_445 VGND VGND VPWR VPWR sky130_fd_sc_hd__decap_3
XFILLER_77_467 VGND VGND VPWR VPWR sky130_fd_sc_hd__decap_3
XFILLER_49_169 VGND VGND VPWR VPWR sky130_fd_sc_hd__fill_1
XFILLER_65_629 VGND VGND VPWR VPWR sky130_fd_sc_hd__decap_3
XFILLER_38_61 VGND VGND VPWR VPWR sky130_fd_sc_hd__decap_3
XFILLER_38_83 VGND VGND VPWR VPWR sky130_fd_sc_hd__fill_1
XFILLER_92_437 VGND VGND VPWR VPWR sky130_fd_sc_hd__decap_3
XFILLER_18_523 VGND VGND VPWR VPWR sky130_fd_sc_hd__decap_3
XFILLER_64_139 VGND VGND VPWR VPWR sky130_fd_sc_hd__fill_1
Xhold1190 _9027_/Q VGND VGND VPWR VPWR _4583_/A1 sky130_fd_sc_hd__dlygate4sd3_1
XFILLER_73_651 VGND VGND VPWR VPWR sky130_fd_sc_hd__decap_3
XFILLER_73_673 VGND VGND VPWR VPWR sky130_fd_sc_hd__fill_2
XFILLER_72_150 VGND VGND VPWR VPWR sky130_fd_sc_hd__decap_3
XFILLER_18_589 VGND VGND VPWR VPWR sky130_fd_sc_hd__decap_3
XFILLER_73_684 VGND VGND VPWR VPWR sky130_fd_sc_hd__decap_3
XFILLER_60_312 VGND VGND VPWR VPWR sky130_fd_sc_hd__decap_3
XFILLER_33_526 VGND VGND VPWR VPWR sky130_fd_sc_hd__decap_3
XFILLER_14_740 VGND VGND VPWR VPWR sky130_fd_sc_hd__decap_3
XTAP_TAPCELL_ROW_31_705 VGND VPWR sky130_fd_sc_hd__tapvpwrvgnd_1
XFILLER_9_210 VGND VGND VPWR VPWR sky130_fd_sc_hd__decap_3
XTAP_TAPCELL_ROW_99_1615 VGND VPWR sky130_fd_sc_hd__tapvpwrvgnd_1
XFILLER_127_620 VGND VGND VPWR VPWR sky130_fd_sc_hd__decap_3
Xclkload13 _9331_/CLK VGND VGND VPWR VPWR clkload13/Y sky130_fd_sc_hd__clkinv_2
Xclkload24 _9215_/CLK VGND VGND VPWR VPWR clkload24/Y sky130_fd_sc_hd__inv_4
XFILLER_127_653 VGND VGND VPWR VPWR sky130_fd_sc_hd__decap_3
XFILLER_126_130 VGND VGND VPWR VPWR sky130_fd_sc_hd__decap_3
XFILLER_126_141 VGND VGND VPWR VPWR sky130_fd_sc_hd__decap_3
XFILLER_5_460 VGND VGND VPWR VPWR sky130_fd_sc_hd__fill_2
XFILLER_127_697 VGND VGND VPWR VPWR sky130_fd_sc_hd__decap_3
XFILLER_126_174 VGND VGND VPWR VPWR sky130_fd_sc_hd__decap_3
X_5260_ _9167_/Q _4516_/X _5066_/X _9151_/Q _5259_/X VGND VGND VPWR VPWR _5271_/D
+ sky130_fd_sc_hd__a221o_2
XFILLER_5_482 VGND VGND VPWR VPWR sky130_fd_sc_hd__decap_3
XFILLER_114_336 VGND VGND VPWR VPWR sky130_fd_sc_hd__decap_3
XFILLER_48_3 VGND VGND VPWR VPWR sky130_fd_sc_hd__decap_3
XFILLER_79_90 VGND VGND VPWR VPWR sky130_fd_sc_hd__decap_3
X_5191_ _5429_/A _5429_/C _5429_/B _5743_/B _9242_/Q VGND VGND VPWR VPWR _5191_/Y
+ sky130_fd_sc_hd__o32ai_4
XFILLER_96_743 VGND VGND VPWR VPWR sky130_fd_sc_hd__decap_3
XFILLER_95_220 VGND VGND VPWR VPWR sky130_fd_sc_hd__decap_3
XFILLER_122_391 VGND VGND VPWR VPWR sky130_fd_sc_hd__decap_3
XFILLER_68_467 VGND VGND VPWR VPWR sky130_fd_sc_hd__fill_2
XFILLER_110_553 VGND VGND VPWR VPWR sky130_fd_sc_hd__decap_3
XTAP_TAPCELL_ROW_39_805 VGND VPWR sky130_fd_sc_hd__tapvpwrvgnd_1
XFILLER_28_309 VGND VGND VPWR VPWR sky130_fd_sc_hd__decap_3
X_8950_ _8950_/A VGND VGND VPWR VPWR _9316_/D sky130_fd_sc_hd__buf_1
XFILLER_83_404 VGND VGND VPWR VPWR sky130_fd_sc_hd__decap_3
XFILLER_110_575 VGND VGND VPWR VPWR sky130_fd_sc_hd__decap_3
XFILLER_68_489 VGND VGND VPWR VPWR sky130_fd_sc_hd__decap_3
XFILLER_83_426 VGND VGND VPWR VPWR sky130_fd_sc_hd__decap_3
X_7901_ _7900_/Y _7650_/B _7847_/A _7847_/B VGND VGND VPWR VPWR _7901_/X sky130_fd_sc_hd__a2bb2o_2
XTAP_TAPCELL_ROW_108_1733 VGND VPWR sky130_fd_sc_hd__tapvpwrvgnd_1
XFILLER_48_180 VGND VGND VPWR VPWR sky130_fd_sc_hd__decap_3
X_8881_ _9284_/Q hold960/X _8883_/S VGND VGND VPWR VPWR _8881_/X sky130_fd_sc_hd__mux2_2
XFILLER_64_640 VGND VGND VPWR VPWR sky130_fd_sc_hd__decap_3
XTAP_TAPCELL_ROW_108_1744 VGND VPWR sky130_fd_sc_hd__tapvpwrvgnd_1
XFILLER_64_651 VGND VGND VPWR VPWR sky130_fd_sc_hd__fill_1
XTAP_TAPCELL_ROW_19_540 VGND VPWR sky130_fd_sc_hd__tapvpwrvgnd_1
X_7832_ _9214_/Q _7836_/B _7830_/Y _7831_/X _9215_/Q VGND VGND VPWR VPWR _7832_/X
+ sky130_fd_sc_hd__o32a_2
XFILLER_64_673 VGND VGND VPWR VPWR sky130_fd_sc_hd__decap_3
XFILLER_63_150 VGND VGND VPWR VPWR sky130_fd_sc_hd__decap_3
XTAP_TAPCELL_ROW_121_1911 VGND VPWR sky130_fd_sc_hd__tapvpwrvgnd_1
XFILLER_51_323 VGND VGND VPWR VPWR sky130_fd_sc_hd__decap_3
X_7763_ _7763_/A _7763_/B VGND VGND VPWR VPWR _7764_/B sky130_fd_sc_hd__nand2_2
X_4975_ _5146_/A _4975_/B VGND VGND VPWR VPWR _7098_/A sky130_fd_sc_hd__nor2_2
X_6714_ _6730_/A _6730_/B _6730_/C VGND VGND VPWR VPWR _7016_/C sky130_fd_sc_hd__nand3_2
XFILLER_51_389 VGND VGND VPWR VPWR sky130_fd_sc_hd__decap_3
XFILLER_20_710 VGND VGND VPWR VPWR sky130_fd_sc_hd__decap_3
X_7694_ _7694_/A _7744_/B VGND VGND VPWR VPWR _7695_/B sky130_fd_sc_hd__xor2_2
XFILLER_32_592 VGND VGND VPWR VPWR sky130_fd_sc_hd__fill_2
XFILLER_20_743 VGND VGND VPWR VPWR sky130_fd_sc_hd__decap_3
X_6645_ _6656_/A _6657_/A _6656_/B VGND VGND VPWR VPWR _6650_/B sky130_fd_sc_hd__and3_4
Xclkload7 clkload7/A VGND VGND VPWR VPWR clkload7/Y sky130_fd_sc_hd__clkinv_2
XFILLER_109_119 VGND VGND VPWR VPWR sky130_fd_sc_hd__decap_3
XFILLER_50_29 VGND VGND VPWR VPWR sky130_fd_sc_hd__fill_1
X_6576_ _6575_/A _6575_/B _6308_/B VGND VGND VPWR VPWR _6695_/B sky130_fd_sc_hd__a21o_2
XFILLER_119_9 VGND VGND VPWR VPWR sky130_fd_sc_hd__decap_3
X_8315_ _8315_/A _8322_/A VGND VGND VPWR VPWR _8408_/A sky130_fd_sc_hd__nor2_2
X_5527_ _5528_/B _5528_/C _5528_/A VGND VGND VPWR VPWR _5527_/Y sky130_fd_sc_hd__o21ai_2
XTAP_TAPCELL_ROW_119_1884 VGND VPWR sky130_fd_sc_hd__tapvpwrvgnd_1
X_9295_ _9343_/CLK _9295_/D load_slew401/X VGND VGND VPWR VPWR _9295_/Q sky130_fd_sc_hd__dfrtp_2
XFILLER_118_697 VGND VGND VPWR VPWR sky130_fd_sc_hd__decap_3
X_8246_ _8162_/A _8163_/A _8162_/B VGND VGND VPWR VPWR _8246_/X sky130_fd_sc_hd__a21bo_2
X_5458_ _9325_/Q _9121_/Q _5611_/S VGND VGND VPWR VPWR _5458_/X sky130_fd_sc_hd__mux2_2
XFILLER_1_9 VGND VGND VPWR VPWR sky130_fd_sc_hd__decap_3
X_8177_ _8177_/A _8177_/B VGND VGND VPWR VPWR _8178_/B sky130_fd_sc_hd__xnor2_2
X_5389_ _6972_/A VGND VGND VPWR VPWR _7413_/A sky130_fd_sc_hd__buf_4
XFILLER_87_732 VGND VGND VPWR VPWR sky130_fd_sc_hd__decap_3
X_7128_ _7375_/A _7375_/B _7127_/C VGND VGND VPWR VPWR _7128_/X sky130_fd_sc_hd__a21o_2
Xfanout244 hold1250/A VGND VGND VPWR VPWR _7472_/A sky130_fd_sc_hd__clkbuf_2
XFILLER_115_33 VGND VGND VPWR VPWR sky130_fd_sc_hd__decap_3
XFILLER_101_531 VGND VGND VPWR VPWR sky130_fd_sc_hd__fill_2
Xfanout255 _5989_/S VGND VGND VPWR VPWR _5361_/A1 sky130_fd_sc_hd__dlymetal6s2s_1
XFILLER_59_445 VGND VGND VPWR VPWR sky130_fd_sc_hd__decap_3
XFILLER_86_253 VGND VGND VPWR VPWR sky130_fd_sc_hd__fill_1
XFILLER_115_66 VGND VGND VPWR VPWR sky130_fd_sc_hd__decap_3
XFILLER_59_478 VGND VGND VPWR VPWR sky130_fd_sc_hd__decap_3
X_7059_ _7058_/B _7058_/C _6967_/A VGND VGND VPWR VPWR _7059_/X sky130_fd_sc_hd__a21bo_2
XFILLER_101_597 VGND VGND VPWR VPWR sky130_fd_sc_hd__decap_3
XFILLER_55_662 VGND VGND VPWR VPWR sky130_fd_sc_hd__decap_3
XTAP_TAPCELL_ROW_83_1405 VGND VPWR sky130_fd_sc_hd__tapvpwrvgnd_1
XFILLER_61_109 VGND VGND VPWR VPWR sky130_fd_sc_hd__decap_3
XFILLER_55_673 VGND VGND VPWR VPWR sky130_fd_sc_hd__decap_3
XFILLER_27_364 VGND VGND VPWR VPWR sky130_fd_sc_hd__decap_3
XFILLER_55_684 VGND VGND VPWR VPWR sky130_fd_sc_hd__decap_3
XFILLER_82_470 VGND VGND VPWR VPWR sky130_fd_sc_hd__fill_1
XFILLER_42_312 VGND VGND VPWR VPWR sky130_fd_sc_hd__decap_3
XFILLER_27_386 VGND VGND VPWR VPWR sky130_fd_sc_hd__decap_3
XFILLER_42_345 VGND VGND VPWR VPWR sky130_fd_sc_hd__decap_3
XFILLER_24_41 VGND VGND VPWR VPWR sky130_fd_sc_hd__decap_3
XFILLER_23_570 VGND VGND VPWR VPWR sky130_fd_sc_hd__decap_3
XFILLER_11_732 VGND VGND VPWR VPWR sky130_fd_sc_hd__decap_3
XFILLER_11_765 VGND VGND VPWR VPWR sky130_fd_sc_hd__decap_3
XFILLER_7_725 VGND VGND VPWR VPWR sky130_fd_sc_hd__decap_3
XFILLER_109_620 VGND VGND VPWR VPWR sky130_fd_sc_hd__decap_3
XFILLER_7_747 VGND VGND VPWR VPWR sky130_fd_sc_hd__decap_3
XFILLER_6_224 VGND VGND VPWR VPWR sky130_fd_sc_hd__decap_3
XFILLER_108_141 VGND VGND VPWR VPWR sky130_fd_sc_hd__decap_3
XFILLER_40_62 VGND VGND VPWR VPWR sky130_fd_sc_hd__fill_1
XTAP_TAPCELL_ROW_94_1545 VGND VPWR sky130_fd_sc_hd__tapvpwrvgnd_1
XFILLER_109_697 VGND VGND VPWR VPWR sky130_fd_sc_hd__fill_2
XTAP_TAPCELL_ROW_94_1556 VGND VPWR sky130_fd_sc_hd__tapvpwrvgnd_1
XFILLER_123_111 VGND VGND VPWR VPWR sky130_fd_sc_hd__fill_1
XFILLER_124_645 VGND VGND VPWR VPWR sky130_fd_sc_hd__decap_3
XFILLER_123_122 VGND VGND VPWR VPWR sky130_fd_sc_hd__decap_3
XFILLER_123_155 VGND VGND VPWR VPWR sky130_fd_sc_hd__decap_3
XFILLER_2_474 VGND VGND VPWR VPWR sky130_fd_sc_hd__fill_2
XFILLER_49_60 VGND VGND VPWR VPWR sky130_fd_sc_hd__decap_3
XFILLER_123_199 VGND VGND VPWR VPWR sky130_fd_sc_hd__decap_3
XFILLER_104_391 VGND VGND VPWR VPWR sky130_fd_sc_hd__decap_3
XFILLER_49_93 VGND VGND VPWR VPWR sky130_fd_sc_hd__decap_3
XFILLER_78_776 VGND VGND VPWR VPWR sky130_fd_sc_hd__fill_1
XFILLER_1_12 VGND VGND VPWR VPWR sky130_fd_sc_hd__decap_3
XFILLER_93_724 VGND VGND VPWR VPWR sky130_fd_sc_hd__decap_3
XFILLER_93_735 VGND VGND VPWR VPWR sky130_fd_sc_hd__fill_2
XFILLER_77_297 VGND VGND VPWR VPWR sky130_fd_sc_hd__decap_3
XFILLER_37_128 VGND VGND VPWR VPWR sky130_fd_sc_hd__decap_3
XFILLER_1_45 VGND VGND VPWR VPWR sky130_fd_sc_hd__decap_3
XFILLER_46_651 VGND VGND VPWR VPWR sky130_fd_sc_hd__fill_2
XFILLER_46_673 VGND VGND VPWR VPWR sky130_fd_sc_hd__decap_3
XFILLER_73_470 VGND VGND VPWR VPWR sky130_fd_sc_hd__decap_3
XFILLER_61_610 VGND VGND VPWR VPWR sky130_fd_sc_hd__decap_3
XFILLER_45_172 VGND VGND VPWR VPWR sky130_fd_sc_hd__decap_3
XFILLER_18_386 VGND VGND VPWR VPWR sky130_fd_sc_hd__decap_3
XFILLER_60_120 VGND VGND VPWR VPWR sky130_fd_sc_hd__decap_3
XFILLER_45_194 VGND VGND VPWR VPWR sky130_fd_sc_hd__decap_3
XFILLER_33_334 VGND VGND VPWR VPWR sky130_fd_sc_hd__fill_2
XFILLER_61_654 VGND VGND VPWR VPWR sky130_fd_sc_hd__decap_3
XFILLER_33_367 VGND VGND VPWR VPWR sky130_fd_sc_hd__decap_3
XTAP_TAPCELL_ROW_44_874 VGND VPWR sky130_fd_sc_hd__tapvpwrvgnd_1
XFILLER_60_153 VGND VGND VPWR VPWR sky130_fd_sc_hd__decap_3
X_4760_ _4760_/A VGND VGND VPWR VPWR _9126_/D sky130_fd_sc_hd__buf_1
XTAP_TAPCELL_ROW_103_1674 VGND VPWR sky130_fd_sc_hd__tapvpwrvgnd_1
XFILLER_33_389 VGND VGND VPWR VPWR sky130_fd_sc_hd__decap_3
XPHY_EDGE_ROW_112_Right_112 VGND VGND VPWR VPWR sky130_fd_sc_hd__decap_3
X_4691_ _4725_/A1 _4691_/A1 _4693_/S VGND VGND VPWR VPWR _4692_/A sky130_fd_sc_hd__mux2_2
XFILLER_119_417 VGND VGND VPWR VPWR sky130_fd_sc_hd__decap_3
XFILLER_119_439 VGND VGND VPWR VPWR sky130_fd_sc_hd__decap_3
X_6430_ _6501_/A _6430_/B VGND VGND VPWR VPWR _6431_/B sky130_fd_sc_hd__xnor2_2
X_6361_ _6540_/B _6361_/B VGND VGND VPWR VPWR _6362_/A sky130_fd_sc_hd__xnor2_2
XFILLER_115_601 VGND VGND VPWR VPWR sky130_fd_sc_hd__decap_3
XPHY_EDGE_ROW_49_Right_49 VGND VGND VPWR VPWR sky130_fd_sc_hd__decap_3
X_8100_ _9218_/Q _7913_/A _8099_/X VGND VGND VPWR VPWR _8100_/Y sky130_fd_sc_hd__o21ai_2
X_5312_ _5312_/A _5312_/B VGND VGND VPWR VPWR _5312_/Y sky130_fd_sc_hd__xnor2_2
XFILLER_115_634 VGND VGND VPWR VPWR sky130_fd_sc_hd__decap_3
X_9080_ _9232_/CLK _9080_/D load_slew408/X VGND VGND VPWR VPWR _9080_/Q sky130_fd_sc_hd__dfrtp_2
X_6292_ _6292_/A _6292_/B VGND VGND VPWR VPWR _6293_/A sky130_fd_sc_hd__nor2_2
XFILLER_115_656 VGND VGND VPWR VPWR sky130_fd_sc_hd__fill_1
XTAP_TAPCELL_ROW_54_1006 VGND VPWR sky130_fd_sc_hd__tapvpwrvgnd_1
XFILLER_5_290 VGND VGND VPWR VPWR sky130_fd_sc_hd__fill_2
XTAP_TAPCELL_ROW_54_1017 VGND VPWR sky130_fd_sc_hd__tapvpwrvgnd_1
X_8031_ _8031_/A _8031_/B VGND VGND VPWR VPWR _8038_/A sky130_fd_sc_hd__xnor2_2
XFILLER_130_604 VGND VGND VPWR VPWR sky130_fd_sc_hd__decap_3
X_5243_ _5244_/A _5410_/B VGND VGND VPWR VPWR _5243_/X sky130_fd_sc_hd__or2_2
XFILLER_69_710 VGND VGND VPWR VPWR sky130_fd_sc_hd__decap_3
XFILLER_130_626 VGND VGND VPWR VPWR sky130_fd_sc_hd__decap_3
XFILLER_130_648 VGND VGND VPWR VPWR sky130_fd_sc_hd__decap_3
XFILLER_69_743 VGND VGND VPWR VPWR sky130_fd_sc_hd__decap_3
X_5174_ _9200_/Q VGND VGND VPWR VPWR _5194_/A sky130_fd_sc_hd__inv_2
XFILLER_96_562 VGND VGND VPWR VPWR sky130_fd_sc_hd__decap_3
XFILLER_68_253 VGND VGND VPWR VPWR sky130_fd_sc_hd__decap_3
XFILLER_29_629 VGND VGND VPWR VPWR sky130_fd_sc_hd__decap_3
XFILLER_110_350 VGND VGND VPWR VPWR sky130_fd_sc_hd__decap_3
XFILLER_84_735 VGND VGND VPWR VPWR sky130_fd_sc_hd__fill_1
XFILLER_84_757 VGND VGND VPWR VPWR sky130_fd_sc_hd__fill_1
X_8933_ _8933_/A VGND VGND VPWR VPWR _9308_/D sky130_fd_sc_hd__buf_1
XFILLER_37_640 VGND VGND VPWR VPWR sky130_fd_sc_hd__decap_3
XPHY_EDGE_ROW_58_Right_58 VGND VGND VPWR VPWR sky130_fd_sc_hd__decap_3
XFILLER_45_18 VGND VGND VPWR VPWR sky130_fd_sc_hd__decap_3
XFILLER_37_673 VGND VGND VPWR VPWR sky130_fd_sc_hd__decap_3
X_8864_ _8969_/A VGND VGND VPWR VPWR _8883_/S sky130_fd_sc_hd__clkbuf_2
XFILLER_24_312 VGND VGND VPWR VPWR sky130_fd_sc_hd__decap_3
XFILLER_64_492 VGND VGND VPWR VPWR sky130_fd_sc_hd__decap_3
X_7815_ _7816_/A _7816_/B VGND VGND VPWR VPWR _7815_/Y sky130_fd_sc_hd__nand2_2
XFILLER_36_194 VGND VGND VPWR VPWR sky130_fd_sc_hd__fill_2
XFILLER_52_654 VGND VGND VPWR VPWR sky130_fd_sc_hd__decap_3
X_8795_ _9243_/Q _6122_/A _8799_/S VGND VGND VPWR VPWR _8795_/X sky130_fd_sc_hd__mux2_2
XTAP_TAPCELL_ROW_65_1157 VGND VPWR sky130_fd_sc_hd__tapvpwrvgnd_1
XFILLER_101_46 VGND VGND VPWR VPWR sky130_fd_sc_hd__fill_1
XFILLER_52_676 VGND VGND VPWR VPWR sky130_fd_sc_hd__decap_3
XFILLER_101_57 VGND VGND VPWR VPWR sky130_fd_sc_hd__decap_3
X_7746_ _7694_/A _7856_/B _7745_/X _7857_/A VGND VGND VPWR VPWR _7746_/Y sky130_fd_sc_hd__o22ai_2
XFILLER_51_175 VGND VGND VPWR VPWR sky130_fd_sc_hd__decap_3
XFILLER_101_79 VGND VGND VPWR VPWR sky130_fd_sc_hd__decap_3
X_4958_ _5875_/C VGND VGND VPWR VPWR _6607_/C sky130_fd_sc_hd__buf_4
XFILLER_61_39 VGND VGND VPWR VPWR sky130_fd_sc_hd__decap_3
X_7677_ _5097_/X _5803_/A _7186_/X _7676_/X VGND VGND VPWR VPWR _7677_/X sky130_fd_sc_hd__a31o_2
X_4889_ _7924_/A _4899_/B VGND VGND VPWR VPWR _4889_/Y sky130_fd_sc_hd__nor2_2
XFILLER_20_551 VGND VGND VPWR VPWR sky130_fd_sc_hd__decap_3
XTAP_TAPCELL_ROW_22_579 VGND VPWR sky130_fd_sc_hd__tapvpwrvgnd_1
X_6628_ _9209_/Q _8410_/S VGND VGND VPWR VPWR _6628_/Y sky130_fd_sc_hd__nand2_2
XPHY_EDGE_ROW_67_Right_67 VGND VGND VPWR VPWR sky130_fd_sc_hd__decap_3
XFILLER_106_601 VGND VGND VPWR VPWR sky130_fd_sc_hd__decap_3
X_9347_ _9348_/CLK _9347_/D load_slew390/X VGND VGND VPWR VPWR _9347_/Q sky130_fd_sc_hd__dfrtp_2
XFILLER_117_6 VGND VGND VPWR VPWR sky130_fd_sc_hd__decap_3
X_6559_ _6560_/B _6560_/C _6560_/A VGND VGND VPWR VPWR _6559_/X sky130_fd_sc_hd__a21o_2
XFILLER_4_728 VGND VGND VPWR VPWR sky130_fd_sc_hd__decap_3
XFILLER_105_100 VGND VGND VPWR VPWR sky130_fd_sc_hd__decap_3
XFILLER_118_483 VGND VGND VPWR VPWR sky130_fd_sc_hd__decap_3
XFILLER_106_634 VGND VGND VPWR VPWR sky130_fd_sc_hd__fill_1
XFILLER_10_21 VGND VGND VPWR VPWR sky130_fd_sc_hd__decap_3
XFILLER_106_645 VGND VGND VPWR VPWR sky130_fd_sc_hd__decap_3
XFILLER_10_32 VGND VGND VPWR VPWR sky130_fd_sc_hd__decap_3
XFILLER_105_122 VGND VGND VPWR VPWR sky130_fd_sc_hd__decap_3
X_9278_ _9341_/CLK _9278_/D fanout379/A VGND VGND VPWR VPWR _9278_/Q sky130_fd_sc_hd__dfrtp_2
XFILLER_106_656 VGND VGND VPWR VPWR sky130_fd_sc_hd__decap_3
XPHY_EDGE_ROW_5_Left_136 VGND VGND VPWR VPWR sky130_fd_sc_hd__decap_3
XFILLER_126_21 VGND VGND VPWR VPWR sky130_fd_sc_hd__decap_3
XFILLER_105_155 VGND VGND VPWR VPWR sky130_fd_sc_hd__decap_3
XFILLER_126_32 VGND VGND VPWR VPWR sky130_fd_sc_hd__decap_3
X_8229_ _8231_/B _8229_/B VGND VGND VPWR VPWR _8229_/X sky130_fd_sc_hd__or2_2
XFILLER_121_626 VGND VGND VPWR VPWR sky130_fd_sc_hd__decap_3
XFILLER_120_103 VGND VGND VPWR VPWR sky130_fd_sc_hd__decap_3
XFILLER_126_65 VGND VGND VPWR VPWR sky130_fd_sc_hd__decap_3
XFILLER_87_540 VGND VGND VPWR VPWR sky130_fd_sc_hd__decap_3
XFILLER_86_47 VGND VGND VPWR VPWR sky130_fd_sc_hd__fill_2
XFILLER_120_136 VGND VGND VPWR VPWR sky130_fd_sc_hd__decap_3
XFILLER_120_147 VGND VGND VPWR VPWR sky130_fd_sc_hd__decap_3
XFILLER_19_30 VGND VGND VPWR VPWR sky130_fd_sc_hd__fill_2
XFILLER_87_573 VGND VGND VPWR VPWR sky130_fd_sc_hd__decap_3
XFILLER_19_41 VGND VGND VPWR VPWR sky130_fd_sc_hd__decap_3
XPHY_EDGE_ROW_76_Right_76 VGND VGND VPWR VPWR sky130_fd_sc_hd__decap_3
XFILLER_47_459 VGND VGND VPWR VPWR sky130_fd_sc_hd__decap_3
XFILLER_90_727 VGND VGND VPWR VPWR sky130_fd_sc_hd__decap_3
XFILLER_62_418 VGND VGND VPWR VPWR sky130_fd_sc_hd__fill_2
XFILLER_90_749 VGND VGND VPWR VPWR sky130_fd_sc_hd__decap_3
XFILLER_15_312 VGND VGND VPWR VPWR sky130_fd_sc_hd__decap_3
XFILLER_27_194 VGND VGND VPWR VPWR sky130_fd_sc_hd__decap_3
XFILLER_43_665 VGND VGND VPWR VPWR sky130_fd_sc_hd__decap_3
XFILLER_43_676 VGND VGND VPWR VPWR sky130_fd_sc_hd__decap_3
XTAP_TAPCELL_ROW_41_833 VGND VPWR sky130_fd_sc_hd__tapvpwrvgnd_1
XFILLER_129_715 VGND VGND VPWR VPWR sky130_fd_sc_hd__decap_3
XFILLER_128_203 VGND VGND VPWR VPWR sky130_fd_sc_hd__decap_3
XFILLER_11_551 VGND VGND VPWR VPWR sky130_fd_sc_hd__decap_3
XPHY_EDGE_ROW_85_Right_85 VGND VGND VPWR VPWR sky130_fd_sc_hd__decap_3
XFILLER_129_759 VGND VGND VPWR VPWR sky130_fd_sc_hd__decap_3
XFILLER_11_573 VGND VGND VPWR VPWR sky130_fd_sc_hd__decap_3
XFILLER_7_533 VGND VGND VPWR VPWR sky130_fd_sc_hd__fill_1
XFILLER_128_236 VGND VGND VPWR VPWR sky130_fd_sc_hd__decap_3
XFILLER_128_269 VGND VGND VPWR VPWR sky130_fd_sc_hd__fill_1
Xmax_cap208 _5087_/B VGND VGND VPWR VPWR _6825_/A sky130_fd_sc_hd__clkbuf_2
XFILLER_109_461 VGND VGND VPWR VPWR sky130_fd_sc_hd__decap_3
XFILLER_7_577 VGND VGND VPWR VPWR sky130_fd_sc_hd__decap_3
XFILLER_7_599 VGND VGND VPWR VPWR sky130_fd_sc_hd__decap_3
XFILLER_3_750 VGND VGND VPWR VPWR sky130_fd_sc_hd__decap_3
XFILLER_112_626 VGND VGND VPWR VPWR sky130_fd_sc_hd__fill_1
Xload_slew414 fanout413/X VGND VGND VPWR VPWR load_slew414/X sky130_fd_sc_hd__buf_4
XFILLER_97_337 VGND VGND VPWR VPWR sky130_fd_sc_hd__decap_3
XFILLER_112_648 VGND VGND VPWR VPWR sky130_fd_sc_hd__decap_3
XPHY_EDGE_ROW_94_Right_94 VGND VGND VPWR VPWR sky130_fd_sc_hd__decap_3
XFILLER_78_551 VGND VGND VPWR VPWR sky130_fd_sc_hd__decap_3
XFILLER_111_169 VGND VGND VPWR VPWR sky130_fd_sc_hd__fill_2
XFILLER_66_746 VGND VGND VPWR VPWR sky130_fd_sc_hd__decap_3
XTAP_TAPCELL_ROW_49_944 VGND VPWR sky130_fd_sc_hd__tapvpwrvgnd_1
XFILLER_93_543 VGND VGND VPWR VPWR sky130_fd_sc_hd__decap_3
XFILLER_76_80 VGND VGND VPWR VPWR sky130_fd_sc_hd__decap_3
XFILLER_66_757 VGND VGND VPWR VPWR sky130_fd_sc_hd__decap_3
XFILLER_38_459 VGND VGND VPWR VPWR sky130_fd_sc_hd__decap_3
XFILLER_93_576 VGND VGND VPWR VPWR sky130_fd_sc_hd__decap_3
XFILLER_81_716 VGND VGND VPWR VPWR sky130_fd_sc_hd__decap_3
XFILLER_65_278 VGND VGND VPWR VPWR sky130_fd_sc_hd__fill_2
X_5930_ _5786_/Y _7195_/A _5930_/C VGND VGND VPWR VPWR _5930_/X sky130_fd_sc_hd__and3b_2
XTAP_TAPCELL_ROW_105_1703 VGND VPWR sky130_fd_sc_hd__tapvpwrvgnd_1
XFILLER_81_738 VGND VGND VPWR VPWR sky130_fd_sc_hd__fill_2
XFILLER_19_673 VGND VGND VPWR VPWR sky130_fd_sc_hd__decap_3
XFILLER_34_621 VGND VGND VPWR VPWR sky130_fd_sc_hd__fill_2
XFILLER_19_695 VGND VGND VPWR VPWR sky130_fd_sc_hd__decap_3
XFILLER_46_492 VGND VGND VPWR VPWR sky130_fd_sc_hd__decap_3
XFILLER_18_194 VGND VGND VPWR VPWR sky130_fd_sc_hd__fill_2
X_5861_ _5861_/A _5861_/B VGND VGND VPWR VPWR _5861_/Y sky130_fd_sc_hd__nand2_2
XFILLER_61_440 VGND VGND VPWR VPWR sky130_fd_sc_hd__decap_3
XFILLER_34_654 VGND VGND VPWR VPWR sky130_fd_sc_hd__decap_3
XFILLER_33_131 VGND VGND VPWR VPWR sky130_fd_sc_hd__decap_3
XFILLER_34_676 VGND VGND VPWR VPWR sky130_fd_sc_hd__decap_3
X_7600_ _7600_/A _7600_/B VGND VGND VPWR VPWR _7609_/A sky130_fd_sc_hd__xnor2_2
XFILLER_33_153 VGND VGND VPWR VPWR sky130_fd_sc_hd__decap_3
X_4812_ _4812_/A VGND VGND VPWR VPWR _9151_/D sky130_fd_sc_hd__buf_1
XFILLER_61_473 VGND VGND VPWR VPWR sky130_fd_sc_hd__fill_1
X_8580_ _8633_/C _8580_/B VGND VGND VPWR VPWR _8580_/Y sky130_fd_sc_hd__xnor2_2
X_5792_ _6406_/B _6425_/S VGND VGND VPWR VPWR _5939_/S sky130_fd_sc_hd__xnor2_2
XFILLER_21_326 VGND VGND VPWR VPWR sky130_fd_sc_hd__decap_3
XFILLER_33_197 VGND VGND VPWR VPWR sky130_fd_sc_hd__decap_3
XFILLER_21_337 VGND VGND VPWR VPWR sky130_fd_sc_hd__decap_3
X_7531_ _7670_/A _7667_/A VGND VGND VPWR VPWR _8022_/S sky130_fd_sc_hd__xnor2_2
X_4743_ _4743_/A VGND VGND VPWR VPWR _9118_/D sky130_fd_sc_hd__buf_1
Xrebuffer608 _8464_/Y VGND VGND VPWR VPWR _8510_/B1_N sky130_fd_sc_hd__buf_2
XFILLER_119_225 VGND VGND VPWR VPWR sky130_fd_sc_hd__fill_2
X_7462_ _7462_/A _7347_/C VGND VGND VPWR VPWR _7635_/B sky130_fd_sc_hd__or2b_2
X_4674_ _4842_/A VGND VGND VPWR VPWR _4693_/S sky130_fd_sc_hd__clkbuf_2
XTAP_TAPCELL_ROW_60_1087 VGND VPWR sky130_fd_sc_hd__tapvpwrvgnd_1
XTAP_TAPCELL_ROW_60_1098 VGND VPWR sky130_fd_sc_hd__tapvpwrvgnd_1
X_9201_ clkload8/A _9201_/D fanout410/X VGND VGND VPWR VPWR _9201_/Q sky130_fd_sc_hd__dfrtp_2
X_6413_ _6413_/A VGND VGND VPWR VPWR _6422_/A sky130_fd_sc_hd__inv_2
X_7393_ _7393_/A _7564_/C VGND VGND VPWR VPWR _7394_/B sky130_fd_sc_hd__or2_2
XTAP_TAPCELL_ROW_116_1843 VGND VPWR sky130_fd_sc_hd__tapvpwrvgnd_1
X_9132_ _9133_/CLK _9132_/D fanout402/X VGND VGND VPWR VPWR _9132_/Q sky130_fd_sc_hd__dfrtp_2
XTAP_TAPCELL_ROW_116_1854 VGND VPWR sky130_fd_sc_hd__tapvpwrvgnd_1
X_6344_ _6344_/A1 _9251_/Q _6339_/X _6340_/X _6343_/X VGND VGND VPWR VPWR _6345_/C
+ sky130_fd_sc_hd__a2111o_2
XFILLER_1_709 VGND VGND VPWR VPWR sky130_fd_sc_hd__decap_3
X_9063_ _9159_/CLK _9063_/D load_slew390/X VGND VGND VPWR VPWR _9063_/Q sky130_fd_sc_hd__dfrtp_2
XFILLER_115_475 VGND VGND VPWR VPWR sky130_fd_sc_hd__decap_3
XFILLER_103_626 VGND VGND VPWR VPWR sky130_fd_sc_hd__decap_3
X_6275_ _6550_/B _7430_/A _7417_/A _6010_/A VGND VGND VPWR VPWR _6275_/X sky130_fd_sc_hd__o211a_2
XFILLER_103_637 VGND VGND VPWR VPWR sky130_fd_sc_hd__decap_3
X_8014_ _8035_/S _8014_/B VGND VGND VPWR VPWR _8025_/S sky130_fd_sc_hd__xnor2_2
X_5226_ _5216_/Y hold988/X _7219_/S VGND VGND VPWR VPWR _5227_/A sky130_fd_sc_hd__mux2_2
XFILLER_69_540 VGND VGND VPWR VPWR sky130_fd_sc_hd__decap_3
XFILLER_102_169 VGND VGND VPWR VPWR sky130_fd_sc_hd__decap_3
XFILLER_29_404 VGND VGND VPWR VPWR sky130_fd_sc_hd__decap_3
XFILLER_130_489 VGND VGND VPWR VPWR sky130_fd_sc_hd__decap_3
X_5157_ _5633_/A _5157_/B VGND VGND VPWR VPWR _5157_/Y sky130_fd_sc_hd__nor2_2
XFILLER_56_17 VGND VGND VPWR VPWR sky130_fd_sc_hd__decap_3
XFILLER_57_735 VGND VGND VPWR VPWR sky130_fd_sc_hd__decap_3
XFILLER_56_234 VGND VGND VPWR VPWR sky130_fd_sc_hd__fill_1
X_5088_ _5088_/A _5088_/B VGND VGND VPWR VPWR _5669_/A sky130_fd_sc_hd__and2_2
XFILLER_56_256 VGND VGND VPWR VPWR sky130_fd_sc_hd__fill_1
XFILLER_84_576 VGND VGND VPWR VPWR sky130_fd_sc_hd__decap_3
XFILLER_112_12 VGND VGND VPWR VPWR sky130_fd_sc_hd__decap_3
X_8916_ _8916_/A VGND VGND VPWR VPWR _9300_/D sky130_fd_sc_hd__buf_1
XTAP_TAPCELL_ROW_127_1994 VGND VPWR sky130_fd_sc_hd__tapvpwrvgnd_1
XTAP_TAPCELL_ROW_27_649 VGND VPWR sky130_fd_sc_hd__tapvpwrvgnd_1
XFILLER_112_56 VGND VGND VPWR VPWR sky130_fd_sc_hd__decap_3
XFILLER_72_27 VGND VGND VPWR VPWR sky130_fd_sc_hd__fill_1
XFILLER_112_78 VGND VGND VPWR VPWR sky130_fd_sc_hd__decap_3
X_8847_ _8847_/A VGND VGND VPWR VPWR _9267_/D sky130_fd_sc_hd__buf_1
XFILLER_40_602 VGND VGND VPWR VPWR sky130_fd_sc_hd__decap_3
XFILLER_25_676 VGND VGND VPWR VPWR sky130_fd_sc_hd__decap_3
XFILLER_24_153 VGND VGND VPWR VPWR sky130_fd_sc_hd__decap_3
XFILLER_52_473 VGND VGND VPWR VPWR sky130_fd_sc_hd__decap_3
XFILLER_25_698 VGND VGND VPWR VPWR sky130_fd_sc_hd__decap_3
XFILLER_12_315 VGND VGND VPWR VPWR sky130_fd_sc_hd__decap_3
X_8778_ _8778_/A _8778_/B VGND VGND VPWR VPWR _9235_/D sky130_fd_sc_hd__xnor2_2
XFILLER_12_326 VGND VGND VPWR VPWR sky130_fd_sc_hd__decap_3
XFILLER_24_186 VGND VGND VPWR VPWR sky130_fd_sc_hd__decap_3
XFILLER_24_197 VGND VGND VPWR VPWR sky130_fd_sc_hd__fill_1
XFILLER_40_657 VGND VGND VPWR VPWR sky130_fd_sc_hd__decap_3
X_7729_ _7656_/A _7877_/A _7682_/A _7728_/X _7729_/C1 VGND VGND VPWR VPWR _7729_/X
+ sky130_fd_sc_hd__o311a_2
XFILLER_126_707 VGND VGND VPWR VPWR sky130_fd_sc_hd__decap_3
XTAP_TAPCELL_ROW_78_1337 VGND VPWR sky130_fd_sc_hd__tapvpwrvgnd_1
XFILLER_125_217 VGND VGND VPWR VPWR sky130_fd_sc_hd__decap_3
XFILLER_115_3 VGND VGND VPWR VPWR sky130_fd_sc_hd__decap_3
XFILLER_4_525 VGND VGND VPWR VPWR sky130_fd_sc_hd__decap_3
XFILLER_125_228 VGND VGND VPWR VPWR sky130_fd_sc_hd__decap_3
XFILLER_4_536 VGND VGND VPWR VPWR sky130_fd_sc_hd__decap_3
XTAP_TAPCELL_ROW_91_1504 VGND VPWR sky130_fd_sc_hd__tapvpwrvgnd_1
XFILLER_21_97 VGND VGND VPWR VPWR sky130_fd_sc_hd__decap_3
XTAP_TAPCELL_ROW_91_1515 VGND VPWR sky130_fd_sc_hd__tapvpwrvgnd_1
XFILLER_106_486 VGND VGND VPWR VPWR sky130_fd_sc_hd__decap_3
XFILLER_97_57 VGND VGND VPWR VPWR sky130_fd_sc_hd__fill_2
XFILLER_79_337 VGND VGND VPWR VPWR sky130_fd_sc_hd__decap_3
XFILLER_79_359 VGND VGND VPWR VPWR sky130_fd_sc_hd__decap_3
XFILLER_0_753 VGND VGND VPWR VPWR sky130_fd_sc_hd__decap_3
XFILLER_94_307 VGND VGND VPWR VPWR sky130_fd_sc_hd__fill_1
XTAP_TAPCELL_ROW_7_374 VGND VPWR sky130_fd_sc_hd__tapvpwrvgnd_1
XFILLER_121_478 VGND VGND VPWR VPWR sky130_fd_sc_hd__decap_3
XFILLER_0_775 VGND VGND VPWR VPWR sky130_fd_sc_hd__fill_2
XFILLER_102_670 VGND VGND VPWR VPWR sky130_fd_sc_hd__decap_3
XFILLER_87_370 VGND VGND VPWR VPWR sky130_fd_sc_hd__fill_1
XFILLER_47_212 VGND VGND VPWR VPWR sky130_fd_sc_hd__decap_3
XFILLER_101_180 VGND VGND VPWR VPWR sky130_fd_sc_hd__decap_3
XFILLER_75_543 VGND VGND VPWR VPWR sky130_fd_sc_hd__decap_3
XFILLER_48_757 VGND VGND VPWR VPWR sky130_fd_sc_hd__decap_3
XFILLER_47_234 VGND VGND VPWR VPWR sky130_fd_sc_hd__fill_2
XTAP_TAPCELL_ROW_46_903 VGND VPWR sky130_fd_sc_hd__tapvpwrvgnd_1
XTAP_TAPCELL_ROW_89_1477 VGND VPWR sky130_fd_sc_hd__tapvpwrvgnd_1
XFILLER_47_267 VGND VGND VPWR VPWR sky130_fd_sc_hd__decap_3
XTAP_TAPCELL_ROW_89_1488 VGND VPWR sky130_fd_sc_hd__tapvpwrvgnd_1
XFILLER_90_513 VGND VGND VPWR VPWR sky130_fd_sc_hd__decap_3
XFILLER_35_429 VGND VGND VPWR VPWR sky130_fd_sc_hd__decap_3
Xmax_cap40 _8276_/Y VGND VGND VPWR VPWR _8295_/S sky130_fd_sc_hd__buf_6
XFILLER_63_749 VGND VGND VPWR VPWR sky130_fd_sc_hd__decap_3
Xmax_cap51 _8514_/B VGND VGND VPWR VPWR _8547_/B sky130_fd_sc_hd__clkbuf_2
XFILLER_16_621 VGND VGND VPWR VPWR sky130_fd_sc_hd__decap_3
Xmax_cap73 _8099_/C VGND VGND VPWR VPWR _8257_/B sky130_fd_sc_hd__clkbuf_2
XFILLER_90_568 VGND VGND VPWR VPWR sky130_fd_sc_hd__decap_3
XFILLER_62_259 VGND VGND VPWR VPWR sky130_fd_sc_hd__fill_2
XFILLER_90_579 VGND VGND VPWR VPWR sky130_fd_sc_hd__decap_3
Xmax_cap95 _6579_/B VGND VGND VPWR VPWR _6578_/B sky130_fd_sc_hd__clkbuf_2
XFILLER_71_760 VGND VGND VPWR VPWR sky130_fd_sc_hd__decap_3
XFILLER_15_142 VGND VGND VPWR VPWR sky130_fd_sc_hd__decap_3
XFILLER_43_473 VGND VGND VPWR VPWR sky130_fd_sc_hd__decap_3
XFILLER_31_613 VGND VGND VPWR VPWR sky130_fd_sc_hd__decap_3
XFILLER_43_484 VGND VGND VPWR VPWR sky130_fd_sc_hd__decap_3
XFILLER_15_175 VGND VGND VPWR VPWR sky130_fd_sc_hd__fill_1
XFILLER_30_134 VGND VGND VPWR VPWR sky130_fd_sc_hd__decap_3
XTAP_TAPCELL_ROW_100_1633 VGND VPWR sky130_fd_sc_hd__tapvpwrvgnd_1
XFILLER_31_668 VGND VGND VPWR VPWR sky130_fd_sc_hd__decap_3
XFILLER_62_93 VGND VGND VPWR VPWR sky130_fd_sc_hd__decap_3
XFILLER_31_679 VGND VGND VPWR VPWR sky130_fd_sc_hd__decap_3
XFILLER_7_33 VGND VGND VPWR VPWR sky130_fd_sc_hd__decap_3
XFILLER_129_556 VGND VGND VPWR VPWR sky130_fd_sc_hd__decap_3
XFILLER_129_567 VGND VGND VPWR VPWR sky130_fd_sc_hd__decap_3
XFILLER_117_718 VGND VGND VPWR VPWR sky130_fd_sc_hd__decap_3
XFILLER_117_729 VGND VGND VPWR VPWR sky130_fd_sc_hd__decap_3
XFILLER_7_396 VGND VGND VPWR VPWR sky130_fd_sc_hd__decap_3
XFILLER_125_762 VGND VGND VPWR VPWR sky130_fd_sc_hd__decap_3
XFILLER_98_602 VGND VGND VPWR VPWR sky130_fd_sc_hd__decap_3
XFILLER_98_635 VGND VGND VPWR VPWR sky130_fd_sc_hd__decap_3
X_6060_ _6060_/A _6060_/B VGND VGND VPWR VPWR _6065_/A sky130_fd_sc_hd__xnor2_4
XFILLER_30_3 VGND VGND VPWR VPWR sky130_fd_sc_hd__decap_3
XFILLER_98_679 VGND VGND VPWR VPWR sky130_fd_sc_hd__decap_3
XFILLER_112_456 VGND VGND VPWR VPWR sky130_fd_sc_hd__decap_3
X_5011_ _5077_/B VGND VGND VPWR VPWR _5011_/X sky130_fd_sc_hd__clkbuf_1
Xload_slew266 _8777_/B VGND VGND VPWR VPWR _5738_/S sky130_fd_sc_hd__buf_4
Xhold1008 _9093_/Q VGND VGND VPWR VPWR _4723_/A1 sky130_fd_sc_hd__dlygate4sd3_1
XTAP_TAPCELL_ROW_111_1784 VGND VPWR sky130_fd_sc_hd__tapvpwrvgnd_1
Xload_slew277 _5513_/A VGND VGND VPWR VPWR _6094_/B sky130_fd_sc_hd__clkbuf_4
XFILLER_85_329 VGND VGND VPWR VPWR sky130_fd_sc_hd__fill_1
Xhold1019 _9087_/Q VGND VGND VPWR VPWR _4710_/A1 sky130_fd_sc_hd__dlygate4sd3_1
Xload_slew288 _8011_/A VGND VGND VPWR VPWR _7728_/B sky130_fd_sc_hd__clkbuf_4
XFILLER_66_521 VGND VGND VPWR VPWR sky130_fd_sc_hd__fill_1
Xload_slew299 _6431_/A VGND VGND VPWR VPWR _6470_/A sky130_fd_sc_hd__clkbuf_4
XFILLER_38_234 VGND VGND VPWR VPWR sky130_fd_sc_hd__decap_3
XPHY_EDGE_ROW_77_Left_208 VGND VGND VPWR VPWR sky130_fd_sc_hd__decap_3
XFILLER_93_351 VGND VGND VPWR VPWR sky130_fd_sc_hd__decap_3
XFILLER_54_705 VGND VGND VPWR VPWR sky130_fd_sc_hd__decap_3
XFILLER_66_576 VGND VGND VPWR VPWR sky130_fd_sc_hd__decap_3
XFILLER_26_407 VGND VGND VPWR VPWR sky130_fd_sc_hd__decap_3
XFILLER_81_513 VGND VGND VPWR VPWR sky130_fd_sc_hd__fill_2
X_6962_ _5476_/X _6963_/C _6963_/D _6963_/B VGND VGND VPWR VPWR _6962_/X sky130_fd_sc_hd__o22a_2
X_5913_ _5913_/A _5913_/B VGND VGND VPWR VPWR _6514_/A sky130_fd_sc_hd__xnor2_2
X_8701_ _9229_/Q _8657_/B _8700_/Y _8739_/B VGND VGND VPWR VPWR _8701_/Y sky130_fd_sc_hd__o211ai_2
X_6893_ _6893_/A _6893_/B VGND VGND VPWR VPWR _7148_/A sky130_fd_sc_hd__xnor2_2
XFILLER_62_760 VGND VGND VPWR VPWR sky130_fd_sc_hd__fill_2
XTAP_TAPCELL_ROW_24_608 VGND VPWR sky130_fd_sc_hd__tapvpwrvgnd_1
XFILLER_62_771 VGND VGND VPWR VPWR sky130_fd_sc_hd__decap_3
X_8632_ _8632_/A VGND VGND VPWR VPWR _8632_/Y sky130_fd_sc_hd__inv_2
XTAP_TAPCELL_ROW_62_1116 VGND VPWR sky130_fd_sc_hd__tapvpwrvgnd_1
X_5844_ _7071_/D VGND VGND VPWR VPWR _5844_/X sky130_fd_sc_hd__clkbuf_1
XFILLER_42_19 VGND VGND VPWR VPWR sky130_fd_sc_hd__decap_3
XFILLER_21_134 VGND VGND VPWR VPWR sky130_fd_sc_hd__decap_3
X_8563_ _8560_/B _8562_/X _8557_/B _8560_/A VGND VGND VPWR VPWR _8563_/X sky130_fd_sc_hd__a211o_2
X_5775_ _5773_/C _5772_/X _5773_/X _5649_/A _5774_/X VGND VGND VPWR VPWR _5816_/A
+ sky130_fd_sc_hd__o221a_4
X_7514_ _7513_/A _7513_/B _7257_/A VGND VGND VPWR VPWR _7556_/B sky130_fd_sc_hd__a21o_2
XPHY_EDGE_ROW_86_Left_217 VGND VGND VPWR VPWR sky130_fd_sc_hd__decap_3
XFILLER_21_178 VGND VGND VPWR VPWR sky130_fd_sc_hd__decap_3
X_4726_ _4726_/A VGND VGND VPWR VPWR _9110_/D sky130_fd_sc_hd__buf_1
XFILLER_21_189 VGND VGND VPWR VPWR sky130_fd_sc_hd__decap_3
X_8494_ _6757_/X _8176_/B _8496_/S _8413_/X _8313_/B VGND VGND VPWR VPWR _8494_/X
+ sky130_fd_sc_hd__o221a_2
Xrebuffer427 _8638_/Y VGND VGND VPWR VPWR _8639_/B sky130_fd_sc_hd__buf_2
Xrebuffer438 _7438_/B VGND VGND VPWR VPWR _7568_/A sky130_fd_sc_hd__buf_2
Xrebuffer449 _5061_/Y VGND VGND VPWR VPWR _5824_/A1 sky130_fd_sc_hd__buf_2
X_7445_ _7445_/A _8406_/A VGND VGND VPWR VPWR _7449_/A sky130_fd_sc_hd__nand2_2
XFILLER_107_217 VGND VGND VPWR VPWR sky130_fd_sc_hd__decap_3
X_4657_ _4657_/A VGND VGND VPWR VPWR _9077_/D sky130_fd_sc_hd__buf_1
Xhold820 _4834_/X VGND VGND VPWR VPWR _4835_/A sky130_fd_sc_hd__dlygate4sd3_1
X_7376_ _7377_/A _7377_/B VGND VGND VPWR VPWR _7380_/B sky130_fd_sc_hd__nor2_2
XFILLER_101_9 VGND VGND VPWR VPWR sky130_fd_sc_hd__decap_3
X_4588_ _4588_/A VGND VGND VPWR VPWR _9045_/D sky130_fd_sc_hd__buf_1
Xhold831 _9091_/Q VGND VGND VPWR VPWR hold831/X sky130_fd_sc_hd__dlygate4sd3_1
Xhold842 _4579_/X VGND VGND VPWR VPWR _4580_/A sky130_fd_sc_hd__dlygate4sd3_1
XFILLER_89_602 VGND VGND VPWR VPWR sky130_fd_sc_hd__decap_3
XFILLER_107_12 VGND VGND VPWR VPWR sky130_fd_sc_hd__decap_3
Xhold853 _8883_/X VGND VGND VPWR VPWR _8884_/A sky130_fd_sc_hd__dlygate4sd3_1
X_9115_ _9335_/CLK _9115_/D load_slew399/X VGND VGND VPWR VPWR _9115_/Q sky130_fd_sc_hd__dfrtp_2
XFILLER_122_209 VGND VGND VPWR VPWR sky130_fd_sc_hd__decap_3
X_6327_ _6326_/B _6326_/C _6188_/A VGND VGND VPWR VPWR _6327_/Y sky130_fd_sc_hd__a21boi_2
Xhold864 _9142_/Q VGND VGND VPWR VPWR hold864/X sky130_fd_sc_hd__dlygate4sd3_1
Xhold875 _4700_/X VGND VGND VPWR VPWR _4701_/A sky130_fd_sc_hd__dlygate4sd3_1
XFILLER_107_45 VGND VGND VPWR VPWR sky130_fd_sc_hd__fill_2
Xhold886 _9294_/Q VGND VGND VPWR VPWR hold886/X sky130_fd_sc_hd__dlygate4sd3_1
XFILLER_88_123 VGND VGND VPWR VPWR sky130_fd_sc_hd__decap_3
Xhold897 _8940_/X VGND VGND VPWR VPWR _8941_/A sky130_fd_sc_hd__dlygate4sd3_1
XFILLER_89_657 VGND VGND VPWR VPWR sky130_fd_sc_hd__decap_3
XFILLER_115_294 VGND VGND VPWR VPWR sky130_fd_sc_hd__decap_3
XFILLER_103_445 VGND VGND VPWR VPWR sky130_fd_sc_hd__decap_3
X_9046_ _9142_/CLK _9046_/D load_slew404/X VGND VGND VPWR VPWR _9046_/Q sky130_fd_sc_hd__dfrtp_2
XTAP_TAPCELL_ROW_73_1267 VGND VPWR sky130_fd_sc_hd__tapvpwrvgnd_1
X_6258_ _6378_/A _6378_/B VGND VGND VPWR VPWR _6260_/A sky130_fd_sc_hd__xnor2_2
XFILLER_130_231 VGND VGND VPWR VPWR sky130_fd_sc_hd__decap_3
XFILLER_89_679 VGND VGND VPWR VPWR sky130_fd_sc_hd__decap_3
XFILLER_130_253 VGND VGND VPWR VPWR sky130_fd_sc_hd__decap_3
X_5209_ _5305_/A _5305_/B VGND VGND VPWR VPWR _5210_/B sky130_fd_sc_hd__xnor2_2
XPHY_EDGE_ROW_95_Left_226 VGND VGND VPWR VPWR sky130_fd_sc_hd__decap_3
X_6189_ _6190_/A _6189_/B VGND VGND VPWR VPWR _6189_/Y sky130_fd_sc_hd__nor2_2
XTAP_TAPCELL_ROW_4_333 VGND VPWR sky130_fd_sc_hd__tapvpwrvgnd_1
XFILLER_57_532 VGND VGND VPWR VPWR sky130_fd_sc_hd__decap_3
XFILLER_29_223 VGND VGND VPWR VPWR sky130_fd_sc_hd__fill_1
XFILLER_130_297 VGND VGND VPWR VPWR sky130_fd_sc_hd__decap_3
XFILLER_123_33 VGND VGND VPWR VPWR sky130_fd_sc_hd__decap_3
XFILLER_29_245 VGND VGND VPWR VPWR sky130_fd_sc_hd__decap_3
XFILLER_45_705 VGND VGND VPWR VPWR sky130_fd_sc_hd__decap_3
XFILLER_123_66 VGND VGND VPWR VPWR sky130_fd_sc_hd__decap_3
XFILLER_84_384 VGND VGND VPWR VPWR sky130_fd_sc_hd__fill_1
XFILLER_44_215 VGND VGND VPWR VPWR sky130_fd_sc_hd__decap_3
XFILLER_29_289 VGND VGND VPWR VPWR sky130_fd_sc_hd__decap_3
XFILLER_123_99 VGND VGND VPWR VPWR sky130_fd_sc_hd__decap_3
XFILLER_72_557 VGND VGND VPWR VPWR sky130_fd_sc_hd__decap_3
XFILLER_44_259 VGND VGND VPWR VPWR sky130_fd_sc_hd__decap_3
XFILLER_25_440 VGND VGND VPWR VPWR sky130_fd_sc_hd__decap_3
XFILLER_72_579 VGND VGND VPWR VPWR sky130_fd_sc_hd__decap_3
XFILLER_53_760 VGND VGND VPWR VPWR sky130_fd_sc_hd__fill_1
XFILLER_16_53 VGND VGND VPWR VPWR sky130_fd_sc_hd__decap_3
XFILLER_25_484 VGND VGND VPWR VPWR sky130_fd_sc_hd__decap_3
XFILLER_25_495 VGND VGND VPWR VPWR sky130_fd_sc_hd__decap_3
XFILLER_40_421 VGND VGND VPWR VPWR sky130_fd_sc_hd__fill_1
XFILLER_9_617 VGND VGND VPWR VPWR sky130_fd_sc_hd__decap_3
XFILLER_12_156 VGND VGND VPWR VPWR sky130_fd_sc_hd__decap_3
XTAP_TAPCELL_ROW_51_972 VGND VPWR sky130_fd_sc_hd__tapvpwrvgnd_1
XFILLER_40_487 VGND VGND VPWR VPWR sky130_fd_sc_hd__decap_3
XFILLER_32_41 VGND VGND VPWR VPWR sky130_fd_sc_hd__decap_3
XFILLER_32_74 VGND VGND VPWR VPWR sky130_fd_sc_hd__decap_3
XFILLER_32_85 VGND VGND VPWR VPWR sky130_fd_sc_hd__decap_3
XFILLER_126_504 VGND VGND VPWR VPWR sky130_fd_sc_hd__decap_3
XFILLER_126_548 VGND VGND VPWR VPWR sky130_fd_sc_hd__fill_2
XFILLER_4_377 VGND VGND VPWR VPWR sky130_fd_sc_hd__decap_3
XFILLER_122_721 VGND VGND VPWR VPWR sky130_fd_sc_hd__decap_3
XFILLER_106_283 VGND VGND VPWR VPWR sky130_fd_sc_hd__decap_3
XFILLER_121_220 VGND VGND VPWR VPWR sky130_fd_sc_hd__decap_3
XFILLER_79_145 VGND VGND VPWR VPWR sky130_fd_sc_hd__decap_3
XFILLER_122_754 VGND VGND VPWR VPWR sky130_fd_sc_hd__fill_2
XFILLER_95_605 VGND VGND VPWR VPWR sky130_fd_sc_hd__decap_3
XFILLER_121_253 VGND VGND VPWR VPWR sky130_fd_sc_hd__fill_1
XFILLER_0_561 VGND VGND VPWR VPWR sky130_fd_sc_hd__decap_3
XFILLER_79_178 VGND VGND VPWR VPWR sky130_fd_sc_hd__decap_3
XFILLER_95_638 VGND VGND VPWR VPWR sky130_fd_sc_hd__decap_3
XFILLER_48_521 VGND VGND VPWR VPWR sky130_fd_sc_hd__decap_3
XFILLER_48_554 VGND VGND VPWR VPWR sky130_fd_sc_hd__decap_3
XFILLER_48_587 VGND VGND VPWR VPWR sky130_fd_sc_hd__fill_1
XFILLER_36_727 VGND VGND VPWR VPWR sky130_fd_sc_hd__decap_3
XFILLER_48_598 VGND VGND VPWR VPWR sky130_fd_sc_hd__decap_3
XFILLER_90_321 VGND VGND VPWR VPWR sky130_fd_sc_hd__decap_3
XFILLER_63_546 VGND VGND VPWR VPWR sky130_fd_sc_hd__decap_3
XFILLER_35_237 VGND VGND VPWR VPWR sky130_fd_sc_hd__decap_3
XFILLER_63_579 VGND VGND VPWR VPWR sky130_fd_sc_hd__decap_3
XFILLER_90_365 VGND VGND VPWR VPWR sky130_fd_sc_hd__decap_3
XFILLER_44_760 VGND VGND VPWR VPWR sky130_fd_sc_hd__decap_3
XFILLER_43_281 VGND VGND VPWR VPWR sky130_fd_sc_hd__decap_3
XFILLER_31_476 VGND VGND VPWR VPWR sky130_fd_sc_hd__fill_1
X_5560_ _5560_/A _5559_/Y VGND VGND VPWR VPWR _5561_/B sky130_fd_sc_hd__or2b_2
XFILLER_78_3 VGND VGND VPWR VPWR sky130_fd_sc_hd__decap_3
X_5491_ _5638_/A _5638_/B VGND VGND VPWR VPWR _5497_/A sky130_fd_sc_hd__xor2_4
XFILLER_117_537 VGND VGND VPWR VPWR sky130_fd_sc_hd__decap_3
XFILLER_8_694 VGND VGND VPWR VPWR sky130_fd_sc_hd__decap_3
X_7230_ _7881_/C _7715_/B VGND VGND VPWR VPWR _7520_/B sky130_fd_sc_hd__xnor2_2
XTAP_TAPCELL_ROW_113_1802 VGND VPWR sky130_fd_sc_hd__tapvpwrvgnd_1
XFILLER_104_209 VGND VGND VPWR VPWR sky130_fd_sc_hd__decap_3
XTAP_TAPCELL_ROW_113_1813 VGND VPWR sky130_fd_sc_hd__tapvpwrvgnd_1
X_7161_ _8009_/A _7154_/Y _6891_/A VGND VGND VPWR VPWR _7161_/Y sky130_fd_sc_hd__a21oi_2
XFILLER_125_570 VGND VGND VPWR VPWR sky130_fd_sc_hd__decap_3
X_6112_ _7181_/A _5949_/A _6415_/A VGND VGND VPWR VPWR _6112_/X sky130_fd_sc_hd__mux2_2
X_7092_ _7089_/X _7090_/Y _7077_/X _7078_/Y VGND VGND VPWR VPWR _7103_/C sky130_fd_sc_hd__a211o_4
XFILLER_98_465 VGND VGND VPWR VPWR sky130_fd_sc_hd__decap_3
XFILLER_112_264 VGND VGND VPWR VPWR sky130_fd_sc_hd__fill_2
X_6043_ _5849_/A _5849_/B _5851_/B VGND VGND VPWR VPWR _6043_/X sky130_fd_sc_hd__a21bo_2
XFILLER_112_297 VGND VGND VPWR VPWR sky130_fd_sc_hd__decap_3
XFILLER_66_351 VGND VGND VPWR VPWR sky130_fd_sc_hd__decap_3
XFILLER_27_727 VGND VGND VPWR VPWR sky130_fd_sc_hd__fill_1
XFILLER_94_682 VGND VGND VPWR VPWR sky130_fd_sc_hd__fill_1
XFILLER_94_693 VGND VGND VPWR VPWR sky130_fd_sc_hd__decap_3
XFILLER_81_310 VGND VGND VPWR VPWR sky130_fd_sc_hd__decap_3
X_7994_ _7994_/A1 _7857_/X _7853_/X VGND VGND VPWR VPWR _7994_/X sky130_fd_sc_hd__a21o_2
XFILLER_81_332 VGND VGND VPWR VPWR sky130_fd_sc_hd__decap_3
XFILLER_26_259 VGND VGND VPWR VPWR sky130_fd_sc_hd__decap_3
X_6945_ _9211_/Q _7117_/A _7117_/B VGND VGND VPWR VPWR _6946_/B sky130_fd_sc_hd__and3b_2
XTAP_TAPCELL_ROW_124_1953 VGND VPWR sky130_fd_sc_hd__tapvpwrvgnd_1
XFILLER_81_365 VGND VGND VPWR VPWR sky130_fd_sc_hd__decap_3
XFILLER_54_579 VGND VGND VPWR VPWR sky130_fd_sc_hd__decap_3
XFILLER_53_18 VGND VGND VPWR VPWR sky130_fd_sc_hd__decap_3
XTAP_TAPCELL_ROW_37_777 VGND VPWR sky130_fd_sc_hd__tapvpwrvgnd_1
X_6876_ _7532_/B1 _7877_/A _7867_/A VGND VGND VPWR VPWR _6876_/X sky130_fd_sc_hd__a21o_2
XFILLER_22_443 VGND VGND VPWR VPWR sky130_fd_sc_hd__decap_3
X_5827_ _5703_/A _5703_/B _5826_/X VGND VGND VPWR VPWR _6057_/B sky130_fd_sc_hd__a21o_2
X_8615_ _8690_/A _8615_/B VGND VGND VPWR VPWR _8678_/B sky130_fd_sc_hd__xnor2_2
XFILLER_50_763 VGND VGND VPWR VPWR sky130_fd_sc_hd__decap_3
X_5758_ _5635_/A _5753_/Y _5756_/X _5757_/X VGND VGND VPWR VPWR _5820_/B sky130_fd_sc_hd__o211a_2
X_8546_ wire110/X _8543_/X _8545_/X VGND VGND VPWR VPWR _9225_/D sky130_fd_sc_hd__a21oi_2
X_4709_ _4709_/A VGND VGND VPWR VPWR _9102_/D sky130_fd_sc_hd__buf_1
X_8477_ _9222_/Q _9223_/Q _8447_/X VGND VGND VPWR VPWR _8477_/Y sky130_fd_sc_hd__a21oi_2
X_5689_ _5689_/A _5689_/B _5689_/C VGND VGND VPWR VPWR _5897_/C sky130_fd_sc_hd__nand3_2
XFILLER_108_559 VGND VGND VPWR VPWR sky130_fd_sc_hd__decap_3
X_7428_ _7955_/A _8070_/A _7324_/B _7324_/A VGND VGND VPWR VPWR _7579_/B sky130_fd_sc_hd__a31o_2
XTAP_TAPCELL_ROW_9_403 VGND VPWR sky130_fd_sc_hd__tapvpwrvgnd_1
XFILLER_118_44 VGND VGND VPWR VPWR sky130_fd_sc_hd__decap_3
XFILLER_78_15 VGND VGND VPWR VPWR sky130_fd_sc_hd__decap_3
XFILLER_123_529 VGND VGND VPWR VPWR sky130_fd_sc_hd__decap_3
XFILLER_118_77 VGND VGND VPWR VPWR sky130_fd_sc_hd__decap_3
X_7359_ _7951_/B VGND VGND VPWR VPWR _8248_/B sky130_fd_sc_hd__clkbuf_2
XFILLER_118_88 VGND VGND VPWR VPWR sky130_fd_sc_hd__decap_3
XFILLER_116_592 VGND VGND VPWR VPWR sky130_fd_sc_hd__decap_3
XFILLER_89_465 VGND VGND VPWR VPWR sky130_fd_sc_hd__decap_3
X_9029_ _9345_/CLK _9029_/D load_slew388/X VGND VGND VPWR VPWR _9029_/Q sky130_fd_sc_hd__dfrtp_2
XFILLER_89_498 VGND VGND VPWR VPWR sky130_fd_sc_hd__decap_3
XFILLER_77_649 VGND VGND VPWR VPWR sky130_fd_sc_hd__decap_3
XFILLER_94_25 VGND VGND VPWR VPWR sky130_fd_sc_hd__decap_3
XFILLER_76_159 VGND VGND VPWR VPWR sky130_fd_sc_hd__fill_1
XFILLER_85_660 VGND VGND VPWR VPWR sky130_fd_sc_hd__decap_3
XFILLER_18_716 VGND VGND VPWR VPWR sky130_fd_sc_hd__decap_3
XFILLER_17_204 VGND VGND VPWR VPWR sky130_fd_sc_hd__decap_3
XTAP_TAPCELL_ROW_86_1436 VGND VPWR sky130_fd_sc_hd__tapvpwrvgnd_1
XFILLER_18_749 VGND VGND VPWR VPWR sky130_fd_sc_hd__decap_3
XTAP_TAPCELL_ROW_86_1447 VGND VPWR sky130_fd_sc_hd__tapvpwrvgnd_1
XFILLER_17_237 VGND VGND VPWR VPWR sky130_fd_sc_hd__decap_3
XFILLER_27_85 VGND VGND VPWR VPWR sky130_fd_sc_hd__decap_3
XFILLER_60_505 VGND VGND VPWR VPWR sky130_fd_sc_hd__decap_3
XFILLER_45_579 VGND VGND VPWR VPWR sky130_fd_sc_hd__decap_3
XFILLER_26_760 VGND VGND VPWR VPWR sky130_fd_sc_hd__decap_3
XFILLER_13_432 VGND VGND VPWR VPWR sky130_fd_sc_hd__decap_3
XFILLER_41_752 VGND VGND VPWR VPWR sky130_fd_sc_hd__decap_3
XFILLER_40_240 VGND VGND VPWR VPWR sky130_fd_sc_hd__decap_3
XFILLER_13_465 VGND VGND VPWR VPWR sky130_fd_sc_hd__decap_3
XFILLER_9_414 VGND VGND VPWR VPWR sky130_fd_sc_hd__decap_3
XFILLER_40_262 VGND VGND VPWR VPWR sky130_fd_sc_hd__decap_3
XFILLER_43_84 VGND VGND VPWR VPWR sky130_fd_sc_hd__fill_1
XFILLER_9_469 VGND VGND VPWR VPWR sky130_fd_sc_hd__decap_3
XFILLER_126_301 VGND VGND VPWR VPWR sky130_fd_sc_hd__decap_3
XFILLER_64_9 VGND VGND VPWR VPWR sky130_fd_sc_hd__fill_2
XTAP_TAPCELL_ROW_97_1587 VGND VPWR sky130_fd_sc_hd__tapvpwrvgnd_1
XFILLER_107_570 VGND VGND VPWR VPWR sky130_fd_sc_hd__decap_3
XFILLER_4_12 VGND VGND VPWR VPWR sky130_fd_sc_hd__decap_3
XFILLER_5_697 VGND VGND VPWR VPWR sky130_fd_sc_hd__decap_3
XFILLER_4_56 VGND VGND VPWR VPWR sky130_fd_sc_hd__fill_2
XFILLER_68_605 VGND VGND VPWR VPWR sky130_fd_sc_hd__decap_3
XFILLER_122_551 VGND VGND VPWR VPWR sky130_fd_sc_hd__decap_3
XFILLER_95_402 VGND VGND VPWR VPWR sky130_fd_sc_hd__decap_3
XFILLER_122_573 VGND VGND VPWR VPWR sky130_fd_sc_hd__decap_3
XFILLER_122_584 VGND VGND VPWR VPWR sky130_fd_sc_hd__decap_3
XFILLER_122_595 VGND VGND VPWR VPWR sky130_fd_sc_hd__decap_3
XFILLER_110_746 VGND VGND VPWR VPWR sky130_fd_sc_hd__fill_2
XFILLER_0_380 VGND VGND VPWR VPWR sky130_fd_sc_hd__fill_1
XFILLER_110_757 VGND VGND VPWR VPWR sky130_fd_sc_hd__fill_1
XFILLER_83_608 VGND VGND VPWR VPWR sky130_fd_sc_hd__fill_2
XFILLER_48_362 VGND VGND VPWR VPWR sky130_fd_sc_hd__fill_2
XFILLER_36_502 VGND VGND VPWR VPWR sky130_fd_sc_hd__decap_3
XFILLER_91_630 VGND VGND VPWR VPWR sky130_fd_sc_hd__decap_3
XFILLER_63_343 VGND VGND VPWR VPWR sky130_fd_sc_hd__decap_3
X_4991_ _6232_/C _6231_/B _4991_/C VGND VGND VPWR VPWR _5879_/C sky130_fd_sc_hd__and3b_4
XFILLER_23_207 VGND VGND VPWR VPWR sky130_fd_sc_hd__decap_3
XFILLER_17_771 VGND VGND VPWR VPWR sky130_fd_sc_hd__decap_3
X_6730_ _6730_/A _6730_/B _6730_/C VGND VGND VPWR VPWR _6732_/D sky130_fd_sc_hd__and3_2
XTAP_TAPCELL_ROW_34_736 VGND VPWR sky130_fd_sc_hd__tapvpwrvgnd_1
XTAP_TAPCELL_ROW_34_747 VGND VPWR sky130_fd_sc_hd__tapvpwrvgnd_1
X_6661_ _6661_/A _6661_/B VGND VGND VPWR VPWR _6661_/Y sky130_fd_sc_hd__nand2_2
XFILLER_32_774 VGND VGND VPWR VPWR sky130_fd_sc_hd__decap_3
XFILLER_31_251 VGND VGND VPWR VPWR sky130_fd_sc_hd__fill_2
XFILLER_31_262 VGND VGND VPWR VPWR sky130_fd_sc_hd__decap_3
X_5612_ _5612_/A _5612_/B VGND VGND VPWR VPWR _5612_/X sky130_fd_sc_hd__and2_2
X_8400_ _8353_/A _8397_/Y _8399_/Y VGND VGND VPWR VPWR _8400_/X sky130_fd_sc_hd__a21o_2
XTAP_TAPCELL_ROW_14_471 VGND VPWR sky130_fd_sc_hd__tapvpwrvgnd_1
XFILLER_31_284 VGND VGND VPWR VPWR sky130_fd_sc_hd__fill_1
X_6592_ _7313_/A _7313_/B _6588_/A _7329_/C _6211_/B VGND VGND VPWR VPWR _6592_/X
+ sky130_fd_sc_hd__a221o_2
XFILLER_31_295 VGND VGND VPWR VPWR sky130_fd_sc_hd__decap_3
X_8331_ _8329_/Y _8243_/B _8330_/Y _8244_/A VGND VGND VPWR VPWR _8421_/B sky130_fd_sc_hd__a22o_2
X_5543_ _5936_/A _5543_/B VGND VGND VPWR VPWR _5544_/B sky130_fd_sc_hd__xnor2_2
XFILLER_129_161 VGND VGND VPWR VPWR sky130_fd_sc_hd__decap_3
XFILLER_129_172 VGND VGND VPWR VPWR sky130_fd_sc_hd__decap_3
XFILLER_117_334 VGND VGND VPWR VPWR sky130_fd_sc_hd__fill_2
X_8262_ _8261_/Y _8218_/B _8350_/B VGND VGND VPWR VPWR _8263_/B sky130_fd_sc_hd__a21o_2
X_5474_ _9245_/Q _5627_/B VGND VGND VPWR VPWR _5474_/Y sky130_fd_sc_hd__nor2_2
XFILLER_105_529 VGND VGND VPWR VPWR sky130_fd_sc_hd__fill_2
X_7213_ _6859_/A _7211_/X _7212_/X _6857_/B VGND VGND VPWR VPWR _7259_/A sky130_fd_sc_hd__a22o_2
XTAP_TAPCELL_ROW_57_1048 VGND VPWR sky130_fd_sc_hd__tapvpwrvgnd_1
X_8193_ _9217_/Q _8271_/A _8268_/S _8344_/A VGND VGND VPWR VPWR _8193_/X sky130_fd_sc_hd__or4_2
X_7144_ _7274_/B _7139_/Y _7141_/Y VGND VGND VPWR VPWR _7145_/B sky130_fd_sc_hd__a21oi_2
XFILLER_59_605 VGND VGND VPWR VPWR sky130_fd_sc_hd__decap_3
Xfanout415 fanout415/A VGND VGND VPWR VPWR wire417/A sky130_fd_sc_hd__clkdlybuf4s25_1
XTAP_TAPCELL_ROW_70_1226 VGND VPWR sky130_fd_sc_hd__tapvpwrvgnd_1
XFILLER_48_18 VGND VGND VPWR VPWR sky130_fd_sc_hd__decap_3
XFILLER_48_29 VGND VGND VPWR VPWR sky130_fd_sc_hd__decap_3
XFILLER_86_424 VGND VGND VPWR VPWR sky130_fd_sc_hd__decap_3
XFILLER_101_735 VGND VGND VPWR VPWR sky130_fd_sc_hd__decap_3
X_7075_ _7301_/A _7300_/A _7300_/B VGND VGND VPWR VPWR _7077_/B sky130_fd_sc_hd__nand3_2
XFILLER_100_234 VGND VGND VPWR VPWR sky130_fd_sc_hd__decap_3
X_6026_ _6221_/B _6221_/A VGND VGND VPWR VPWR _6158_/A sky130_fd_sc_hd__xor2_2
XFILLER_74_619 VGND VGND VPWR VPWR sky130_fd_sc_hd__decap_3
XFILLER_73_129 VGND VGND VPWR VPWR sky130_fd_sc_hd__decap_3
XFILLER_39_384 VGND VGND VPWR VPWR sky130_fd_sc_hd__decap_3
XFILLER_27_535 VGND VGND VPWR VPWR sky130_fd_sc_hd__decap_3
XFILLER_82_641 VGND VGND VPWR VPWR sky130_fd_sc_hd__decap_3
XPHY_EDGE_ROW_126_Right_126 VGND VGND VPWR VPWR sky130_fd_sc_hd__decap_3
XFILLER_54_343 VGND VGND VPWR VPWR sky130_fd_sc_hd__decap_3
XFILLER_82_663 VGND VGND VPWR VPWR sky130_fd_sc_hd__decap_3
XFILLER_54_365 VGND VGND VPWR VPWR sky130_fd_sc_hd__decap_3
X_7977_ _7977_/A _7977_/B VGND VGND VPWR VPWR _7978_/B sky130_fd_sc_hd__xnor2_2
XFILLER_42_516 VGND VGND VPWR VPWR sky130_fd_sc_hd__decap_3
XFILLER_14_207 VGND VGND VPWR VPWR sky130_fd_sc_hd__decap_3
XFILLER_120_12 VGND VGND VPWR VPWR sky130_fd_sc_hd__decap_3
XTAP_TAPCELL_ROW_68_1199 VGND VPWR sky130_fd_sc_hd__tapvpwrvgnd_1
X_6928_ _6699_/A _6926_/Y _6927_/X VGND VGND VPWR VPWR _6950_/A sky130_fd_sc_hd__o21ai_2
XFILLER_23_741 VGND VGND VPWR VPWR sky130_fd_sc_hd__decap_3
XFILLER_120_56 VGND VGND VPWR VPWR sky130_fd_sc_hd__decap_3
XFILLER_80_27 VGND VGND VPWR VPWR sky130_fd_sc_hd__fill_1
XFILLER_23_774 VGND VGND VPWR VPWR sky130_fd_sc_hd__decap_3
X_6859_ _6859_/A _8009_/A VGND VGND VPWR VPWR _7256_/A sky130_fd_sc_hd__nor2_2
XTAP_TAPCELL_ROW_81_1377 VGND VPWR sky130_fd_sc_hd__tapvpwrvgnd_1
XFILLER_22_273 VGND VGND VPWR VPWR sky130_fd_sc_hd__decap_3
XFILLER_10_413 VGND VGND VPWR VPWR sky130_fd_sc_hd__decap_3
XFILLER_13_21 VGND VGND VPWR VPWR sky130_fd_sc_hd__decap_3
XFILLER_10_424 VGND VGND VPWR VPWR sky130_fd_sc_hd__fill_1
XFILLER_129_21 VGND VGND VPWR VPWR sky130_fd_sc_hd__decap_3
XFILLER_108_301 VGND VGND VPWR VPWR sky130_fd_sc_hd__decap_3
XFILLER_6_417 VGND VGND VPWR VPWR sky130_fd_sc_hd__decap_3
X_8529_ _8446_/A _8521_/X _8522_/X _8528_/X VGND VGND VPWR VPWR _8549_/A sky130_fd_sc_hd__o22a_2
XFILLER_6_439 VGND VGND VPWR VPWR sky130_fd_sc_hd__decap_3
XFILLER_129_54 VGND VGND VPWR VPWR sky130_fd_sc_hd__fill_2
XFILLER_129_87 VGND VGND VPWR VPWR sky130_fd_sc_hd__decap_3
XFILLER_2_601 VGND VGND VPWR VPWR sky130_fd_sc_hd__decap_3
XFILLER_123_304 VGND VGND VPWR VPWR sky130_fd_sc_hd__fill_1
XFILLER_1_100 VGND VGND VPWR VPWR sky130_fd_sc_hd__decap_3
XFILLER_123_337 VGND VGND VPWR VPWR sky130_fd_sc_hd__decap_3
XFILLER_8_3 VGND VGND VPWR VPWR sky130_fd_sc_hd__decap_3
XFILLER_2_634 VGND VGND VPWR VPWR sky130_fd_sc_hd__decap_3
XFILLER_2_645 VGND VGND VPWR VPWR sky130_fd_sc_hd__decap_3
XFILLER_1_122 VGND VGND VPWR VPWR sky130_fd_sc_hd__decap_3
XFILLER_104_562 VGND VGND VPWR VPWR sky130_fd_sc_hd__decap_3
XFILLER_89_262 VGND VGND VPWR VPWR sky130_fd_sc_hd__decap_3
XFILLER_2_678 VGND VGND VPWR VPWR sky130_fd_sc_hd__decap_3
XFILLER_89_284 VGND VGND VPWR VPWR sky130_fd_sc_hd__decap_3
XFILLER_77_435 VGND VGND VPWR VPWR sky130_fd_sc_hd__fill_2
XFILLER_92_405 VGND VGND VPWR VPWR sky130_fd_sc_hd__decap_3
XFILLER_18_502 VGND VGND VPWR VPWR sky130_fd_sc_hd__fill_2
XFILLER_92_427 VGND VGND VPWR VPWR sky130_fd_sc_hd__fill_2
XFILLER_58_671 VGND VGND VPWR VPWR sky130_fd_sc_hd__decap_3
XFILLER_38_73 VGND VGND VPWR VPWR sky130_fd_sc_hd__decap_3
XFILLER_73_630 VGND VGND VPWR VPWR sky130_fd_sc_hd__decap_3
XFILLER_45_321 VGND VGND VPWR VPWR sky130_fd_sc_hd__decap_3
Xhold1180 _9063_/Q VGND VGND VPWR VPWR _4660_/A1 sky130_fd_sc_hd__dlygate4sd3_1
Xhold1191 _9328_/Q VGND VGND VPWR VPWR _9007_/A1 sky130_fd_sc_hd__dlygate4sd3_1
XFILLER_73_663 VGND VGND VPWR VPWR sky130_fd_sc_hd__decap_3
XFILLER_33_505 VGND VGND VPWR VPWR sky130_fd_sc_hd__decap_3
XFILLER_73_696 VGND VGND VPWR VPWR sky130_fd_sc_hd__decap_3
XFILLER_45_387 VGND VGND VPWR VPWR sky130_fd_sc_hd__decap_3
XFILLER_54_83 VGND VGND VPWR VPWR sky130_fd_sc_hd__fill_1
XFILLER_60_357 VGND VGND VPWR VPWR sky130_fd_sc_hd__decap_3
XFILLER_14_752 VGND VGND VPWR VPWR sky130_fd_sc_hd__decap_3
XFILLER_60_368 VGND VGND VPWR VPWR sky130_fd_sc_hd__fill_2
XFILLER_14_763 VGND VGND VPWR VPWR sky130_fd_sc_hd__decap_3
XTAP_TAPCELL_ROW_31_706 VGND VPWR sky130_fd_sc_hd__tapvpwrvgnd_1
XFILLER_9_222 VGND VGND VPWR VPWR sky130_fd_sc_hd__fill_2
XFILLER_41_582 VGND VGND VPWR VPWR sky130_fd_sc_hd__decap_3
XTAP_TAPCELL_ROW_99_1616 VGND VPWR sky130_fd_sc_hd__tapvpwrvgnd_1
XFILLER_13_284 VGND VGND VPWR VPWR sky130_fd_sc_hd__fill_2
XTAP_TAPCELL_ROW_11_430 VGND VPWR sky130_fd_sc_hd__tapvpwrvgnd_1
XFILLER_118_109 VGND VGND VPWR VPWR sky130_fd_sc_hd__decap_3
XFILLER_127_610 VGND VGND VPWR VPWR sky130_fd_sc_hd__decap_3
Xclkload14 _9313_/CLK VGND VGND VPWR VPWR clkload14/X sky130_fd_sc_hd__clkbuf_8
XFILLER_127_632 VGND VGND VPWR VPWR sky130_fd_sc_hd__decap_3
Xclkload25 _9209_/CLK VGND VGND VPWR VPWR clkload25/Y sky130_fd_sc_hd__clkinv_4
XFILLER_127_665 VGND VGND VPWR VPWR sky130_fd_sc_hd__decap_3
XFILLER_127_676 VGND VGND VPWR VPWR sky130_fd_sc_hd__decap_3
XFILLER_126_153 VGND VGND VPWR VPWR sky130_fd_sc_hd__decap_3
XFILLER_114_315 VGND VGND VPWR VPWR sky130_fd_sc_hd__fill_1
XFILLER_126_186 VGND VGND VPWR VPWR sky130_fd_sc_hd__decap_3
XFILLER_5_494 VGND VGND VPWR VPWR sky130_fd_sc_hd__decap_3
XFILLER_126_197 VGND VGND VPWR VPWR sky130_fd_sc_hd__decap_3
XFILLER_114_348 VGND VGND VPWR VPWR sky130_fd_sc_hd__decap_3
XFILLER_114_359 VGND VGND VPWR VPWR sky130_fd_sc_hd__decap_3
X_5190_ _9338_/Q _5002_/X _5185_/X _5188_/X _5189_/X VGND VGND VPWR VPWR _5429_/C
+ sky130_fd_sc_hd__a2111o_2
XFILLER_68_424 VGND VGND VPWR VPWR sky130_fd_sc_hd__fill_1
XFILLER_96_755 VGND VGND VPWR VPWR sky130_fd_sc_hd__fill_1
XFILLER_68_446 VGND VGND VPWR VPWR sky130_fd_sc_hd__decap_3
XFILLER_110_543 VGND VGND VPWR VPWR sky130_fd_sc_hd__decap_3
XTAP_TAPCELL_ROW_39_806 VGND VPWR sky130_fd_sc_hd__tapvpwrvgnd_1
XFILLER_83_416 VGND VGND VPWR VPWR sky130_fd_sc_hd__fill_1
XFILLER_49_660 VGND VGND VPWR VPWR sky130_fd_sc_hd__fill_2
XFILLER_49_682 VGND VGND VPWR VPWR sky130_fd_sc_hd__decap_3
X_7900_ _7900_/A VGND VGND VPWR VPWR _7900_/Y sky130_fd_sc_hd__inv_2
XFILLER_110_598 VGND VGND VPWR VPWR sky130_fd_sc_hd__decap_3
XFILLER_83_449 VGND VGND VPWR VPWR sky130_fd_sc_hd__decap_3
X_8880_ _8880_/A VGND VGND VPWR VPWR _9283_/D sky130_fd_sc_hd__buf_1
XTAP_TAPCELL_ROW_108_1734 VGND VPWR sky130_fd_sc_hd__tapvpwrvgnd_1
XFILLER_76_490 VGND VGND VPWR VPWR sky130_fd_sc_hd__decap_3
XTAP_TAPCELL_ROW_108_1745 VGND VPWR sky130_fd_sc_hd__tapvpwrvgnd_1
XFILLER_48_192 VGND VGND VPWR VPWR sky130_fd_sc_hd__decap_3
XTAP_TAPCELL_ROW_19_541 VGND VPWR sky130_fd_sc_hd__tapvpwrvgnd_1
X_7831_ _7924_/A _7836_/C VGND VGND VPWR VPWR _7831_/X sky130_fd_sc_hd__or2_2
XFILLER_36_365 VGND VGND VPWR VPWR sky130_fd_sc_hd__decap_3
XFILLER_91_482 VGND VGND VPWR VPWR sky130_fd_sc_hd__decap_3
XTAP_TAPCELL_ROW_121_1912 VGND VPWR sky130_fd_sc_hd__tapvpwrvgnd_1
XFILLER_24_549 VGND VGND VPWR VPWR sky130_fd_sc_hd__decap_3
X_4974_ _4974_/A _4974_/B _5743_/B _4974_/D VGND VGND VPWR VPWR _5146_/A sky130_fd_sc_hd__and4_2
X_7762_ _7763_/A _8155_/A VGND VGND VPWR VPWR _7762_/Y sky130_fd_sc_hd__nor2_2
XFILLER_51_335 VGND VGND VPWR VPWR sky130_fd_sc_hd__fill_1
XFILLER_51_346 VGND VGND VPWR VPWR sky130_fd_sc_hd__decap_3
X_6713_ _6730_/A _6730_/C _6730_/B VGND VGND VPWR VPWR _7016_/B sky130_fd_sc_hd__a21o_2
X_7693_ _7705_/B _7693_/B VGND VGND VPWR VPWR _7744_/B sky130_fd_sc_hd__xnor2_2
XFILLER_20_722 VGND VGND VPWR VPWR sky130_fd_sc_hd__decap_3
X_6644_ _6642_/X _6643_/Y _6644_/S VGND VGND VPWR VPWR _6656_/B sky130_fd_sc_hd__mux2_2
Xclkload8 clkload8/A VGND VGND VPWR VPWR clkload8/Y sky130_fd_sc_hd__inv_6
XFILLER_20_755 VGND VGND VPWR VPWR sky130_fd_sc_hd__fill_1
XFILLER_20_766 VGND VGND VPWR VPWR sky130_fd_sc_hd__decap_3
XFILLER_118_610 VGND VGND VPWR VPWR sky130_fd_sc_hd__decap_3
X_6575_ _6575_/A _6575_/B VGND VGND VPWR VPWR _6695_/A sky130_fd_sc_hd__or2_4
XFILLER_118_621 VGND VGND VPWR VPWR sky130_fd_sc_hd__fill_1
X_5526_ _5338_/A _5525_/X _5337_/B VGND VGND VPWR VPWR _5528_/A sky130_fd_sc_hd__a21oi_2
X_8314_ _8406_/B _8314_/B VGND VGND VPWR VPWR _8320_/A sky130_fd_sc_hd__xnor2_2
XFILLER_118_654 VGND VGND VPWR VPWR sky130_fd_sc_hd__decap_3
X_9294_ _9296_/CLK _9294_/D fanout379/A VGND VGND VPWR VPWR _9294_/Q sky130_fd_sc_hd__dfrtp_2
XTAP_TAPCELL_ROW_119_1885 VGND VPWR sky130_fd_sc_hd__tapvpwrvgnd_1
XFILLER_105_315 VGND VGND VPWR VPWR sky130_fd_sc_hd__decap_3
X_8245_ _8245_/A _8245_/B VGND VGND VPWR VPWR _8245_/Y sky130_fd_sc_hd__xnor2_2
XFILLER_117_175 VGND VGND VPWR VPWR sky130_fd_sc_hd__decap_3
X_5457_ _5457_/A _5457_/B VGND VGND VPWR VPWR _5457_/X sky130_fd_sc_hd__and2_2
XFILLER_105_348 VGND VGND VPWR VPWR sky130_fd_sc_hd__decap_3
XFILLER_59_28 VGND VGND VPWR VPWR sky130_fd_sc_hd__decap_3
X_8176_ _8240_/B _8176_/B VGND VGND VPWR VPWR _8177_/B sky130_fd_sc_hd__nor2_2
X_5388_ _5388_/A1 _5483_/A2 _5483_/A1 _5387_/Y VGND VGND VPWR VPWR _5388_/Y sky130_fd_sc_hd__a31oi_4
XFILLER_87_711 VGND VGND VPWR VPWR sky130_fd_sc_hd__decap_3
XFILLER_120_318 VGND VGND VPWR VPWR sky130_fd_sc_hd__fill_1
XFILLER_115_12 VGND VGND VPWR VPWR sky130_fd_sc_hd__decap_3
X_7127_ _7375_/A _7375_/B _7127_/C VGND VGND VPWR VPWR _7127_/Y sky130_fd_sc_hd__nand3_2
XFILLER_120_329 VGND VGND VPWR VPWR sky130_fd_sc_hd__fill_1
XFILLER_113_370 VGND VGND VPWR VPWR sky130_fd_sc_hd__decap_3
XFILLER_87_755 VGND VGND VPWR VPWR sky130_fd_sc_hd__decap_3
XFILLER_115_45 VGND VGND VPWR VPWR sky130_fd_sc_hd__decap_3
Xfanout267 _7794_/A VGND VGND VPWR VPWR _6206_/A sky130_fd_sc_hd__buf_8
XFILLER_59_457 VGND VGND VPWR VPWR sky130_fd_sc_hd__fill_2
Xfanout278 _7549_/A VGND VGND VPWR VPWR _8034_/A sky130_fd_sc_hd__clkdlybuf4s25_1
XFILLER_75_16 VGND VGND VPWR VPWR sky130_fd_sc_hd__decap_3
XFILLER_47_608 VGND VGND VPWR VPWR sky130_fd_sc_hd__decap_3
X_7058_ _6967_/A _7058_/B _7058_/C VGND VGND VPWR VPWR _7058_/X sky130_fd_sc_hd__and3b_2
XFILLER_115_78 VGND VGND VPWR VPWR sky130_fd_sc_hd__decap_3
XFILLER_46_107 VGND VGND VPWR VPWR sky130_fd_sc_hd__decap_3
XFILLER_46_118 VGND VGND VPWR VPWR sky130_fd_sc_hd__decap_3
X_6009_ _6166_/A _7071_/A VGND VGND VPWR VPWR _6011_/A sky130_fd_sc_hd__nand2_2
XFILLER_74_449 VGND VGND VPWR VPWR sky130_fd_sc_hd__decap_3
XFILLER_67_490 VGND VGND VPWR VPWR sky130_fd_sc_hd__decap_3
XFILLER_55_630 VGND VGND VPWR VPWR sky130_fd_sc_hd__decap_3
XFILLER_27_343 VGND VGND VPWR VPWR sky130_fd_sc_hd__decap_3
XTAP_TAPCELL_ROW_83_1406 VGND VPWR sky130_fd_sc_hd__tapvpwrvgnd_1
XFILLER_15_505 VGND VGND VPWR VPWR sky130_fd_sc_hd__fill_2
XFILLER_55_696 VGND VGND VPWR VPWR sky130_fd_sc_hd__decap_3
XFILLER_82_493 VGND VGND VPWR VPWR sky130_fd_sc_hd__decap_3
XFILLER_70_633 VGND VGND VPWR VPWR sky130_fd_sc_hd__decap_3
XFILLER_15_549 VGND VGND VPWR VPWR sky130_fd_sc_hd__decap_3
XFILLER_70_677 VGND VGND VPWR VPWR sky130_fd_sc_hd__decap_3
XFILLER_42_368 VGND VGND VPWR VPWR sky130_fd_sc_hd__decap_3
XFILLER_70_699 VGND VGND VPWR VPWR sky130_fd_sc_hd__fill_1
XFILLER_24_53 VGND VGND VPWR VPWR sky130_fd_sc_hd__decap_3
XFILLER_11_711 VGND VGND VPWR VPWR sky130_fd_sc_hd__decap_3
XFILLER_23_582 VGND VGND VPWR VPWR sky130_fd_sc_hd__decap_3
XFILLER_11_744 VGND VGND VPWR VPWR sky130_fd_sc_hd__decap_3
XFILLER_7_704 VGND VGND VPWR VPWR sky130_fd_sc_hd__decap_3
XFILLER_10_243 VGND VGND VPWR VPWR sky130_fd_sc_hd__decap_3
XFILLER_6_203 VGND VGND VPWR VPWR sky130_fd_sc_hd__decap_3
XFILLER_10_265 VGND VGND VPWR VPWR sky130_fd_sc_hd__decap_3
XFILLER_7_759 VGND VGND VPWR VPWR sky130_fd_sc_hd__decap_3
XFILLER_109_643 VGND VGND VPWR VPWR sky130_fd_sc_hd__decap_3
XFILLER_6_247 VGND VGND VPWR VPWR sky130_fd_sc_hd__decap_3
XFILLER_109_665 VGND VGND VPWR VPWR sky130_fd_sc_hd__decap_3
XFILLER_109_676 VGND VGND VPWR VPWR sky130_fd_sc_hd__fill_1
XTAP_TAPCELL_ROW_94_1546 VGND VPWR sky130_fd_sc_hd__tapvpwrvgnd_1
XFILLER_40_85 VGND VGND VPWR VPWR sky130_fd_sc_hd__decap_3
XTAP_TAPCELL_ROW_94_1557 VGND VPWR sky130_fd_sc_hd__tapvpwrvgnd_1
XFILLER_108_197 VGND VGND VPWR VPWR sky130_fd_sc_hd__fill_1
XFILLER_123_134 VGND VGND VPWR VPWR sky130_fd_sc_hd__decap_3
XFILLER_97_508 VGND VGND VPWR VPWR sky130_fd_sc_hd__decap_3
XFILLER_123_167 VGND VGND VPWR VPWR sky130_fd_sc_hd__fill_1
XFILLER_123_178 VGND VGND VPWR VPWR sky130_fd_sc_hd__decap_3
XFILLER_111_329 VGND VGND VPWR VPWR sky130_fd_sc_hd__decap_3
XFILLER_78_733 VGND VGND VPWR VPWR sky130_fd_sc_hd__decap_3
XFILLER_2_497 VGND VGND VPWR VPWR sky130_fd_sc_hd__decap_3
XFILLER_78_755 VGND VGND VPWR VPWR sky130_fd_sc_hd__fill_1
XFILLER_49_72 VGND VGND VPWR VPWR sky130_fd_sc_hd__decap_3
XFILLER_27_9 VGND VGND VPWR VPWR sky130_fd_sc_hd__fill_1
XFILLER_38_608 VGND VGND VPWR VPWR sky130_fd_sc_hd__decap_3
XFILLER_1_24 VGND VGND VPWR VPWR sky130_fd_sc_hd__decap_3
XFILLER_92_224 VGND VGND VPWR VPWR sky130_fd_sc_hd__decap_3
XFILLER_1_57 VGND VGND VPWR VPWR sky130_fd_sc_hd__decap_3
XFILLER_46_641 VGND VGND VPWR VPWR sky130_fd_sc_hd__decap_3
XFILLER_1_79 VGND VGND VPWR VPWR sky130_fd_sc_hd__decap_3
XFILLER_92_268 VGND VGND VPWR VPWR sky130_fd_sc_hd__decap_3
XFILLER_80_408 VGND VGND VPWR VPWR sky130_fd_sc_hd__decap_3
XFILLER_45_151 VGND VGND VPWR VPWR sky130_fd_sc_hd__decap_3
XFILLER_45_162 VGND VGND VPWR VPWR sky130_fd_sc_hd__decap_3
XFILLER_33_302 VGND VGND VPWR VPWR sky130_fd_sc_hd__decap_3
XTAP_TAPCELL_ROW_16_500 VGND VPWR sky130_fd_sc_hd__tapvpwrvgnd_1
XTAP_TAPCELL_ROW_44_875 VGND VPWR sky130_fd_sc_hd__tapvpwrvgnd_1
XFILLER_60_165 VGND VGND VPWR VPWR sky130_fd_sc_hd__decap_3
XFILLER_14_560 VGND VGND VPWR VPWR sky130_fd_sc_hd__decap_3
XTAP_TAPCELL_ROW_103_1675 VGND VPWR sky130_fd_sc_hd__tapvpwrvgnd_1
XFILLER_14_571 VGND VGND VPWR VPWR sky130_fd_sc_hd__fill_2
X_4690_ _4690_/A VGND VGND VPWR VPWR _9093_/D sky130_fd_sc_hd__buf_1
XFILLER_119_429 VGND VGND VPWR VPWR sky130_fd_sc_hd__decap_3
X_6360_ _9208_/Q _6248_/A _6353_/Y _6359_/X _6942_/A VGND VGND VPWR VPWR _6540_/B
+ sky130_fd_sc_hd__a32o_2
XFILLER_60_3 VGND VGND VPWR VPWR sky130_fd_sc_hd__decap_3
XFILLER_115_613 VGND VGND VPWR VPWR sky130_fd_sc_hd__decap_3
X_5311_ _5311_/A _5310_/Y VGND VGND VPWR VPWR _5312_/B sky130_fd_sc_hd__or2b_2
X_6291_ _6291_/A _6291_/B VGND VGND VPWR VPWR _6297_/B sky130_fd_sc_hd__nand2_2
XTAP_TAPCELL_ROW_54_1007 VGND VPWR sky130_fd_sc_hd__tapvpwrvgnd_1
XFILLER_114_134 VGND VGND VPWR VPWR sky130_fd_sc_hd__decap_3
X_8030_ _7670_/A _8028_/Y _8029_/X VGND VGND VPWR VPWR _8031_/B sky130_fd_sc_hd__a21o_2
X_5242_ _9199_/Q _6765_/A _5344_/A VGND VGND VPWR VPWR _5410_/B sky130_fd_sc_hd__and3_2
XFILLER_88_519 VGND VGND VPWR VPWR sky130_fd_sc_hd__decap_3
XFILLER_69_700 VGND VGND VPWR VPWR sky130_fd_sc_hd__fill_2
XFILLER_114_156 VGND VGND VPWR VPWR sky130_fd_sc_hd__fill_1
XFILLER_114_178 VGND VGND VPWR VPWR sky130_fd_sc_hd__decap_3
XFILLER_102_329 VGND VGND VPWR VPWR sky130_fd_sc_hd__fill_2
XFILLER_130_638 VGND VGND VPWR VPWR sky130_fd_sc_hd__decap_3
X_5173_ _5147_/A _5148_/A _5172_/X VGND VGND VPWR VPWR _5247_/A sky130_fd_sc_hd__a21oi_2
XFILLER_96_530 VGND VGND VPWR VPWR sky130_fd_sc_hd__fill_2
XFILLER_69_755 VGND VGND VPWR VPWR sky130_fd_sc_hd__decap_3
XFILLER_110_362 VGND VGND VPWR VPWR sky130_fd_sc_hd__fill_2
XFILLER_56_427 VGND VGND VPWR VPWR sky130_fd_sc_hd__decap_3
Xinput1 rst_n VGND VGND VPWR VPWR input1/X sky130_fd_sc_hd__buf_2
X_8932_ _9308_/Q _8932_/A1 _8946_/S VGND VGND VPWR VPWR _8932_/X sky130_fd_sc_hd__mux2_2
XFILLER_49_490 VGND VGND VPWR VPWR sky130_fd_sc_hd__fill_2
XFILLER_83_279 VGND VGND VPWR VPWR sky130_fd_sc_hd__fill_1
XFILLER_71_419 VGND VGND VPWR VPWR sky130_fd_sc_hd__decap_3
X_8863_ _8863_/A VGND VGND VPWR VPWR _9275_/D sky130_fd_sc_hd__buf_1
XFILLER_37_685 VGND VGND VPWR VPWR sky130_fd_sc_hd__decap_3
XFILLER_36_162 VGND VGND VPWR VPWR sky130_fd_sc_hd__fill_2
XFILLER_24_324 VGND VGND VPWR VPWR sky130_fd_sc_hd__decap_3
X_7814_ _7622_/A _7622_/B _7813_/X VGND VGND VPWR VPWR _7825_/A sky130_fd_sc_hd__o21a_2
X_8794_ _8794_/A VGND VGND VPWR VPWR _9242_/D sky130_fd_sc_hd__buf_1
XTAP_TAPCELL_ROW_65_1158 VGND VPWR sky130_fd_sc_hd__tapvpwrvgnd_1
XFILLER_24_357 VGND VGND VPWR VPWR sky130_fd_sc_hd__decap_3
XFILLER_24_368 VGND VGND VPWR VPWR sky130_fd_sc_hd__decap_3
XFILLER_52_688 VGND VGND VPWR VPWR sky130_fd_sc_hd__decap_3
XFILLER_51_154 VGND VGND VPWR VPWR sky130_fd_sc_hd__decap_3
XFILLER_101_69 VGND VGND VPWR VPWR sky130_fd_sc_hd__fill_1
X_4957_ _6232_/C _6231_/B _4924_/B VGND VGND VPWR VPWR _5875_/C sky130_fd_sc_hd__nor3b_4
X_7745_ _7694_/A _7742_/Y _7856_/B VGND VGND VPWR VPWR _7745_/X sky130_fd_sc_hd__o21a_2
XFILLER_61_18 VGND VGND VPWR VPWR sky130_fd_sc_hd__decap_3
XFILLER_32_390 VGND VGND VPWR VPWR sky130_fd_sc_hd__decap_3
X_4888_ _4876_/X _4887_/Y _4878_/X hold799/X VGND VGND VPWR VPWR _4888_/X sky130_fd_sc_hd__a2bb2o_2
X_7676_ _7170_/S _7676_/B _7676_/C VGND VGND VPWR VPWR _7676_/X sky130_fd_sc_hd__and3b_2
X_6558_ _6692_/B _6558_/B VGND VGND VPWR VPWR _6669_/A sky130_fd_sc_hd__xnor2_2
X_9346_ _9346_/CLK _9346_/D fanout403/X VGND VGND VPWR VPWR _9346_/Q sky130_fd_sc_hd__dfrtp_2
XFILLER_4_707 VGND VGND VPWR VPWR sky130_fd_sc_hd__decap_3
XFILLER_3_217 VGND VGND VPWR VPWR sky130_fd_sc_hd__decap_3
X_5509_ _6076_/A _5507_/A _5221_/Y _5508_/X _5664_/A VGND VGND VPWR VPWR _5510_/B
+ sky130_fd_sc_hd__a32o_2
XFILLER_3_228 VGND VGND VPWR VPWR sky130_fd_sc_hd__decap_3
XFILLER_118_495 VGND VGND VPWR VPWR sky130_fd_sc_hd__decap_3
X_6489_ _5084_/B _6434_/Y _7178_/B _5949_/A _6096_/Y VGND VGND VPWR VPWR _6490_/B
+ sky130_fd_sc_hd__a221o_2
X_9277_ _9339_/CLK _9277_/D fanout383/X VGND VGND VPWR VPWR _9277_/Q sky130_fd_sc_hd__dfrtp_2
XFILLER_10_44 VGND VGND VPWR VPWR sky130_fd_sc_hd__decap_3
XFILLER_79_508 VGND VGND VPWR VPWR sky130_fd_sc_hd__decap_3
X_8228_ _8229_/B _8227_/Y _8233_/B2 VGND VGND VPWR VPWR _8228_/X sky130_fd_sc_hd__a21o_2
XFILLER_105_167 VGND VGND VPWR VPWR sky130_fd_sc_hd__fill_1
XFILLER_126_44 VGND VGND VPWR VPWR sky130_fd_sc_hd__decap_3
XFILLER_86_15 VGND VGND VPWR VPWR sky130_fd_sc_hd__decap_3
XFILLER_121_638 VGND VGND VPWR VPWR sky130_fd_sc_hd__fill_2
XFILLER_10_99 VGND VGND VPWR VPWR sky130_fd_sc_hd__decap_3
XFILLER_126_77 VGND VGND VPWR VPWR sky130_fd_sc_hd__decap_3
XFILLER_120_115 VGND VGND VPWR VPWR sky130_fd_sc_hd__decap_3
XFILLER_121_649 VGND VGND VPWR VPWR sky130_fd_sc_hd__fill_2
X_8159_ _8312_/A _8322_/A VGND VGND VPWR VPWR _8163_/A sky130_fd_sc_hd__nand2_2
XFILLER_126_88 VGND VGND VPWR VPWR sky130_fd_sc_hd__decap_3
XFILLER_87_552 VGND VGND VPWR VPWR sky130_fd_sc_hd__decap_3
XFILLER_120_159 VGND VGND VPWR VPWR sky130_fd_sc_hd__decap_3
XFILLER_47_405 VGND VGND VPWR VPWR sky130_fd_sc_hd__decap_3
XFILLER_87_585 VGND VGND VPWR VPWR sky130_fd_sc_hd__decap_3
XFILLER_19_53 VGND VGND VPWR VPWR sky130_fd_sc_hd__decap_3
XFILLER_87_596 VGND VGND VPWR VPWR sky130_fd_sc_hd__decap_3
XFILLER_19_64 VGND VGND VPWR VPWR sky130_fd_sc_hd__decap_3
XFILLER_47_449 VGND VGND VPWR VPWR sky130_fd_sc_hd__fill_2
XFILLER_28_630 VGND VGND VPWR VPWR sky130_fd_sc_hd__fill_2
XFILLER_19_86 VGND VGND VPWR VPWR sky130_fd_sc_hd__decap_3
Xclkbuf_leaf_39_clk clkload0/A VGND VGND VPWR VPWR clkload9/A sky130_fd_sc_hd__clkbuf_8
XFILLER_55_471 VGND VGND VPWR VPWR sky130_fd_sc_hd__decap_3
XFILLER_28_696 VGND VGND VPWR VPWR sky130_fd_sc_hd__decap_3
XFILLER_82_290 VGND VGND VPWR VPWR sky130_fd_sc_hd__fill_2
XFILLER_70_430 VGND VGND VPWR VPWR sky130_fd_sc_hd__decap_3
XFILLER_43_644 VGND VGND VPWR VPWR sky130_fd_sc_hd__decap_3
XFILLER_42_132 VGND VGND VPWR VPWR sky130_fd_sc_hd__decap_3
XFILLER_15_346 VGND VGND VPWR VPWR sky130_fd_sc_hd__decap_3
XPHY_EDGE_ROW_106_Left_237 VGND VGND VPWR VPWR sky130_fd_sc_hd__decap_3
XFILLER_43_688 VGND VGND VPWR VPWR sky130_fd_sc_hd__decap_3
XFILLER_42_165 VGND VGND VPWR VPWR sky130_fd_sc_hd__decap_3
XTAP_TAPCELL_ROW_41_834 VGND VPWR sky130_fd_sc_hd__tapvpwrvgnd_1
XFILLER_70_496 VGND VGND VPWR VPWR sky130_fd_sc_hd__fill_1
XFILLER_30_338 VGND VGND VPWR VPWR sky130_fd_sc_hd__decap_3
XFILLER_23_390 VGND VGND VPWR VPWR sky130_fd_sc_hd__fill_2
XFILLER_129_727 VGND VGND VPWR VPWR sky130_fd_sc_hd__fill_1
XFILLER_129_738 VGND VGND VPWR VPWR sky130_fd_sc_hd__decap_3
XFILLER_128_215 VGND VGND VPWR VPWR sky130_fd_sc_hd__decap_3
XFILLER_51_84 VGND VGND VPWR VPWR sky130_fd_sc_hd__fill_1
XFILLER_7_556 VGND VGND VPWR VPWR sky130_fd_sc_hd__decap_3
Xmax_cap209 _5267_/A VGND VGND VPWR VPWR _5182_/B2 sky130_fd_sc_hd__buf_1
XFILLER_109_473 VGND VGND VPWR VPWR sky130_fd_sc_hd__decap_3
XFILLER_124_432 VGND VGND VPWR VPWR sky130_fd_sc_hd__decap_3
XPHY_EDGE_ROW_115_Left_246 VGND VGND VPWR VPWR sky130_fd_sc_hd__decap_3
XFILLER_97_305 VGND VGND VPWR VPWR sky130_fd_sc_hd__fill_1
XFILLER_3_762 VGND VGND VPWR VPWR sky130_fd_sc_hd__decap_3
Xload_slew404 fanout403/X VGND VGND VPWR VPWR load_slew404/X sky130_fd_sc_hd__buf_4
XFILLER_124_487 VGND VGND VPWR VPWR sky130_fd_sc_hd__decap_3
XFILLER_78_541 VGND VGND VPWR VPWR sky130_fd_sc_hd__fill_2
XFILLER_111_137 VGND VGND VPWR VPWR sky130_fd_sc_hd__fill_2
XFILLER_25_6 VGND VGND VPWR VPWR sky130_fd_sc_hd__fill_2
XFILLER_93_500 VGND VGND VPWR VPWR sky130_fd_sc_hd__decap_3
XFILLER_78_574 VGND VGND VPWR VPWR sky130_fd_sc_hd__fill_2
XFILLER_120_660 VGND VGND VPWR VPWR sky130_fd_sc_hd__fill_1
XFILLER_65_202 VGND VGND VPWR VPWR sky130_fd_sc_hd__decap_3
XFILLER_38_427 VGND VGND VPWR VPWR sky130_fd_sc_hd__decap_3
XFILLER_38_438 VGND VGND VPWR VPWR sky130_fd_sc_hd__decap_3
XTAP_TAPCELL_ROW_49_945 VGND VPWR sky130_fd_sc_hd__tapvpwrvgnd_1
XFILLER_66_769 VGND VGND VPWR VPWR sky130_fd_sc_hd__decap_3
XFILLER_53_419 VGND VGND VPWR VPWR sky130_fd_sc_hd__decap_3
XTAP_TAPCELL_ROW_105_1704 VGND VPWR sky130_fd_sc_hd__tapvpwrvgnd_1
XFILLER_46_460 VGND VGND VPWR VPWR sky130_fd_sc_hd__decap_3
XPHY_EDGE_ROW_124_Left_255 VGND VGND VPWR VPWR sky130_fd_sc_hd__decap_3
XFILLER_34_633 VGND VGND VPWR VPWR sky130_fd_sc_hd__decap_3
XFILLER_18_184 VGND VGND VPWR VPWR sky130_fd_sc_hd__fill_1
X_5860_ _5860_/A _5860_/B VGND VGND VPWR VPWR _6143_/A sky130_fd_sc_hd__xnor2_4
XFILLER_61_452 VGND VGND VPWR VPWR sky130_fd_sc_hd__decap_3
XFILLER_33_143 VGND VGND VPWR VPWR sky130_fd_sc_hd__fill_1
X_4811_ _9151_/Q hold835/X _4819_/S VGND VGND VPWR VPWR _4811_/X sky130_fd_sc_hd__mux2_2
XFILLER_34_688 VGND VGND VPWR VPWR sky130_fd_sc_hd__decap_3
XFILLER_33_165 VGND VGND VPWR VPWR sky130_fd_sc_hd__decap_3
X_5791_ _5791_/A _5791_/B VGND VGND VPWR VPWR _5922_/A sky130_fd_sc_hd__xnor2_4
XFILLER_21_316 VGND VGND VPWR VPWR sky130_fd_sc_hd__decap_3
X_4742_ _9118_/Q hold868/X _4756_/S VGND VGND VPWR VPWR _4742_/X sky130_fd_sc_hd__mux2_2
X_7530_ _8011_/A _7530_/B VGND VGND VPWR VPWR _8028_/A sky130_fd_sc_hd__xnor2_2
XFILLER_14_390 VGND VGND VPWR VPWR sky130_fd_sc_hd__decap_3
Xrebuffer609 _8211_/A VGND VGND VPWR VPWR _8687_/B1 sky130_fd_sc_hd__buf_6
X_7461_ _7626_/C _7626_/D _7438_/Y _7461_/C1 VGND VGND VPWR VPWR _7636_/C sky130_fd_sc_hd__o211ai_2
X_4673_ _4673_/A VGND VGND VPWR VPWR _9085_/D sky130_fd_sc_hd__buf_1
XTAP_TAPCELL_ROW_60_1088 VGND VPWR sky130_fd_sc_hd__tapvpwrvgnd_1
X_6412_ _6412_/A _6412_/B VGND VGND VPWR VPWR _6413_/A sky130_fd_sc_hd__xnor2_2
X_9200_ clkload8/A _9200_/D fanout407/A VGND VGND VPWR VPWR _9200_/Q sky130_fd_sc_hd__dfrtp_2
X_7392_ _7392_/A _7392_/B VGND VGND VPWR VPWR _7564_/C sky130_fd_sc_hd__nor2_2
XFILLER_128_760 VGND VGND VPWR VPWR sky130_fd_sc_hd__decap_3
X_6343_ _6341_/X _6342_/Y _6758_/C VGND VGND VPWR VPWR _6343_/X sky130_fd_sc_hd__o21a_2
X_9131_ _9335_/CLK _9131_/D load_slew399/X VGND VGND VPWR VPWR _9131_/Q sky130_fd_sc_hd__dfrtp_2
XTAP_TAPCELL_ROW_116_1844 VGND VPWR sky130_fd_sc_hd__tapvpwrvgnd_1
XFILLER_115_410 VGND VGND VPWR VPWR sky130_fd_sc_hd__decap_3
XFILLER_127_281 VGND VGND VPWR VPWR sky130_fd_sc_hd__decap_3
XFILLER_115_432 VGND VGND VPWR VPWR sky130_fd_sc_hd__decap_3
XFILLER_103_605 VGND VGND VPWR VPWR sky130_fd_sc_hd__fill_2
X_9062_ _9142_/CLK _9062_/D load_slew404/X VGND VGND VPWR VPWR _9062_/Q sky130_fd_sc_hd__dfrtp_2
X_6274_ _6279_/A _6963_/D _7071_/A _7573_/B VGND VGND VPWR VPWR _6274_/X sky130_fd_sc_hd__o211a_2
XFILLER_102_104 VGND VGND VPWR VPWR sky130_fd_sc_hd__decap_3
XFILLER_103_649 VGND VGND VPWR VPWR sky130_fd_sc_hd__decap_3
X_5225_ hold987/X _5224_/Y _5530_/S VGND VGND VPWR VPWR _5225_/X sky130_fd_sc_hd__mux2_2
X_8013_ _8013_/A _8013_/B VGND VGND VPWR VPWR _8014_/B sky130_fd_sc_hd__xnor2_2
XFILLER_102_126 VGND VGND VPWR VPWR sky130_fd_sc_hd__decap_3
XFILLER_130_457 VGND VGND VPWR VPWR sky130_fd_sc_hd__fill_1
XFILLER_69_552 VGND VGND VPWR VPWR sky130_fd_sc_hd__fill_1
X_5156_ _9197_/Q _5043_/B _5018_/Y _5155_/Y _4984_/Y VGND VGND VPWR VPWR _5157_/B
+ sky130_fd_sc_hd__o32a_2
XFILLER_57_714 VGND VGND VPWR VPWR sky130_fd_sc_hd__decap_3
XFILLER_84_500 VGND VGND VPWR VPWR sky130_fd_sc_hd__decap_3
XFILLER_56_29 VGND VGND VPWR VPWR sky130_fd_sc_hd__decap_3
XFILLER_29_427 VGND VGND VPWR VPWR sky130_fd_sc_hd__decap_3
XFILLER_84_533 VGND VGND VPWR VPWR sky130_fd_sc_hd__decap_3
XFILLER_110_170 VGND VGND VPWR VPWR sky130_fd_sc_hd__decap_3
XFILLER_57_758 VGND VGND VPWR VPWR sky130_fd_sc_hd__fill_1
XFILLER_29_449 VGND VGND VPWR VPWR sky130_fd_sc_hd__decap_3
X_5087_ _5667_/S _5087_/B VGND VGND VPWR VPWR _5088_/B sky130_fd_sc_hd__nand2_2
XFILLER_56_246 VGND VGND VPWR VPWR sky130_fd_sc_hd__decap_3
X_8915_ _9300_/Q hold962/X _8925_/S VGND VGND VPWR VPWR _8915_/X sky130_fd_sc_hd__mux2_2
XFILLER_112_24 VGND VGND VPWR VPWR sky130_fd_sc_hd__decap_3
XFILLER_25_611 VGND VGND VPWR VPWR sky130_fd_sc_hd__decap_3
XFILLER_112_35 VGND VGND VPWR VPWR sky130_fd_sc_hd__decap_3
XTAP_TAPCELL_ROW_127_1995 VGND VPWR sky130_fd_sc_hd__tapvpwrvgnd_1
XFILLER_24_110 VGND VGND VPWR VPWR sky130_fd_sc_hd__decap_3
X_8846_ _8846_/A0 _9251_/Q _8862_/S VGND VGND VPWR VPWR _8846_/X sky130_fd_sc_hd__mux2_2
XFILLER_24_132 VGND VGND VPWR VPWR sky130_fd_sc_hd__fill_2
XFILLER_80_772 VGND VGND VPWR VPWR sky130_fd_sc_hd__decap_3
X_8777_ _8777_/A _8777_/B VGND VGND VPWR VPWR _8778_/B sky130_fd_sc_hd__nand2_2
X_5989_ _9297_/Q _9029_/Q _5989_/S VGND VGND VPWR VPWR _5990_/C sky130_fd_sc_hd__mux2_2
XFILLER_52_496 VGND VGND VPWR VPWR sky130_fd_sc_hd__decap_3
X_7728_ _7728_/A _7728_/B _8011_/B VGND VGND VPWR VPWR _7728_/X sky130_fd_sc_hd__or3_2
XFILLER_8_309 VGND VGND VPWR VPWR sky130_fd_sc_hd__fill_1
XFILLER_20_360 VGND VGND VPWR VPWR sky130_fd_sc_hd__decap_3
X_7659_ _7659_/A _7659_/B VGND VGND VPWR VPWR _7659_/X sky130_fd_sc_hd__or2_2
XFILLER_21_21 VGND VGND VPWR VPWR sky130_fd_sc_hd__decap_3
XFILLER_126_719 VGND VGND VPWR VPWR sky130_fd_sc_hd__decap_3
XTAP_TAPCELL_ROW_78_1338 VGND VPWR sky130_fd_sc_hd__tapvpwrvgnd_1
XFILLER_21_43 VGND VGND VPWR VPWR sky130_fd_sc_hd__decap_3
XFILLER_119_771 VGND VGND VPWR VPWR sky130_fd_sc_hd__decap_3
X_9329_ _9345_/CLK _9329_/D load_slew388/X VGND VGND VPWR VPWR _9329_/Q sky130_fd_sc_hd__dfrtp_2
XFILLER_118_292 VGND VGND VPWR VPWR sky130_fd_sc_hd__decap_3
XFILLER_108_3 VGND VGND VPWR VPWR sky130_fd_sc_hd__decap_3
XTAP_TAPCELL_ROW_91_1505 VGND VPWR sky130_fd_sc_hd__tapvpwrvgnd_1
XTAP_TAPCELL_ROW_91_1516 VGND VPWR sky130_fd_sc_hd__tapvpwrvgnd_1
XFILLER_106_454 VGND VGND VPWR VPWR sky130_fd_sc_hd__decap_3
XFILLER_0_710 VGND VGND VPWR VPWR sky130_fd_sc_hd__decap_3
XFILLER_121_413 VGND VGND VPWR VPWR sky130_fd_sc_hd__decap_3
XFILLER_121_424 VGND VGND VPWR VPWR sky130_fd_sc_hd__decap_3
XFILLER_0_732 VGND VGND VPWR VPWR sky130_fd_sc_hd__decap_3
XFILLER_121_457 VGND VGND VPWR VPWR sky130_fd_sc_hd__decap_3
XTAP_TAPCELL_ROW_7_375 VGND VPWR sky130_fd_sc_hd__tapvpwrvgnd_1
XFILLER_102_660 VGND VGND VPWR VPWR sky130_fd_sc_hd__fill_2
XFILLER_87_360 VGND VGND VPWR VPWR sky130_fd_sc_hd__fill_1
XFILLER_75_500 VGND VGND VPWR VPWR sky130_fd_sc_hd__decap_3
XFILLER_75_511 VGND VGND VPWR VPWR sky130_fd_sc_hd__decap_3
XFILLER_102_693 VGND VGND VPWR VPWR sky130_fd_sc_hd__decap_3
XFILLER_48_747 VGND VGND VPWR VPWR sky130_fd_sc_hd__fill_2
XFILLER_75_555 VGND VGND VPWR VPWR sky130_fd_sc_hd__decap_3
XTAP_TAPCELL_ROW_89_1478 VGND VPWR sky130_fd_sc_hd__tapvpwrvgnd_1
XTAP_TAPCELL_ROW_46_904 VGND VPWR sky130_fd_sc_hd__tapvpwrvgnd_1
XFILLER_63_717 VGND VGND VPWR VPWR sky130_fd_sc_hd__decap_3
XFILLER_35_408 VGND VGND VPWR VPWR sky130_fd_sc_hd__decap_3
XFILLER_46_51 VGND VGND VPWR VPWR sky130_fd_sc_hd__decap_3
XTAP_TAPCELL_ROW_89_1489 VGND VPWR sky130_fd_sc_hd__tapvpwrvgnd_1
XFILLER_47_279 VGND VGND VPWR VPWR sky130_fd_sc_hd__fill_1
XFILLER_90_525 VGND VGND VPWR VPWR sky130_fd_sc_hd__decap_3
Xmax_cap52 _8657_/B VGND VGND VPWR VPWR _8758_/A sky130_fd_sc_hd__buf_2
XFILLER_90_547 VGND VGND VPWR VPWR sky130_fd_sc_hd__decap_3
Xmax_cap63 _5306_/X VGND VGND VPWR VPWR _5307_/B sky130_fd_sc_hd__buf_2
XFILLER_43_430 VGND VGND VPWR VPWR sky130_fd_sc_hd__decap_3
Xmax_cap85 _7591_/A VGND VGND VPWR VPWR _5344_/A sky130_fd_sc_hd__buf_2
Xmax_cap96 _8231_/B VGND VGND VPWR VPWR _6253_/B sky130_fd_sc_hd__buf_4
XFILLER_43_452 VGND VGND VPWR VPWR sky130_fd_sc_hd__decap_3
XFILLER_15_154 VGND VGND VPWR VPWR sky130_fd_sc_hd__fill_1
XFILLER_15_165 VGND VGND VPWR VPWR sky130_fd_sc_hd__decap_3
XFILLER_94_9 VGND VGND VPWR VPWR sky130_fd_sc_hd__decap_3
XFILLER_15_187 VGND VGND VPWR VPWR sky130_fd_sc_hd__decap_3
XFILLER_70_293 VGND VGND VPWR VPWR sky130_fd_sc_hd__fill_2
XTAP_TAPCELL_ROW_100_1634 VGND VPWR sky130_fd_sc_hd__tapvpwrvgnd_1
XFILLER_7_12 VGND VGND VPWR VPWR sky130_fd_sc_hd__decap_3
XFILLER_7_45 VGND VGND VPWR VPWR sky130_fd_sc_hd__decap_3
XFILLER_129_579 VGND VGND VPWR VPWR sky130_fd_sc_hd__decap_3
XFILLER_116_207 VGND VGND VPWR VPWR sky130_fd_sc_hd__decap_3
XFILLER_125_741 VGND VGND VPWR VPWR sky130_fd_sc_hd__decap_3
XFILLER_125_774 VGND VGND VPWR VPWR sky130_fd_sc_hd__decap_3
XFILLER_98_614 VGND VGND VPWR VPWR sky130_fd_sc_hd__decap_3
XFILLER_124_251 VGND VGND VPWR VPWR sky130_fd_sc_hd__fill_1
XFILLER_124_262 VGND VGND VPWR VPWR sky130_fd_sc_hd__decap_3
XFILLER_97_113 VGND VGND VPWR VPWR sky130_fd_sc_hd__decap_3
XFILLER_112_413 VGND VGND VPWR VPWR sky130_fd_sc_hd__decap_3
XFILLER_3_592 VGND VGND VPWR VPWR sky130_fd_sc_hd__decap_3
XFILLER_112_446 VGND VGND VPWR VPWR sky130_fd_sc_hd__fill_1
Xload_slew245 _7472_/A VGND VGND VPWR VPWR _6239_/A sky130_fd_sc_hd__buf_4
X_5010_ _6976_/A VGND VGND VPWR VPWR _5010_/X sky130_fd_sc_hd__buf_6
Xload_slew256 _8174_/A VGND VGND VPWR VPWR _5739_/S sky130_fd_sc_hd__clkbuf_4
XTAP_TAPCELL_ROW_111_1774 VGND VPWR sky130_fd_sc_hd__tapvpwrvgnd_1
XFILLER_87_80 VGND VGND VPWR VPWR sky130_fd_sc_hd__decap_3
XFILLER_39_703 VGND VGND VPWR VPWR sky130_fd_sc_hd__decap_3
Xhold1009 _9341_/Q VGND VGND VPWR VPWR _9001_/A0 sky130_fd_sc_hd__dlygate4sd3_1
XTAP_TAPCELL_ROW_111_1785 VGND VPWR sky130_fd_sc_hd__tapvpwrvgnd_1
XFILLER_23_3 VGND VGND VPWR VPWR sky130_fd_sc_hd__decap_3
Xload_slew289 _8011_/A VGND VGND VPWR VPWR _7661_/A sky130_fd_sc_hd__buf_2
XFILLER_78_371 VGND VGND VPWR VPWR sky130_fd_sc_hd__decap_3
XFILLER_39_736 VGND VGND VPWR VPWR sky130_fd_sc_hd__decap_3
XFILLER_66_533 VGND VGND VPWR VPWR sky130_fd_sc_hd__decap_3
XFILLER_39_769 VGND VGND VPWR VPWR sky130_fd_sc_hd__decap_3
XFILLER_38_246 VGND VGND VPWR VPWR sky130_fd_sc_hd__decap_3
XFILLER_66_566 VGND VGND VPWR VPWR sky130_fd_sc_hd__decap_3
XFILLER_26_419 VGND VGND VPWR VPWR sky130_fd_sc_hd__fill_1
X_6961_ _6961_/A _6961_/B VGND VGND VPWR VPWR _6969_/A sky130_fd_sc_hd__xnor2_2
XFILLER_19_482 VGND VGND VPWR VPWR sky130_fd_sc_hd__decap_3
X_8700_ _9229_/Q _8700_/B VGND VGND VPWR VPWR _8700_/Y sky130_fd_sc_hd__nand2_2
XFILLER_53_238 VGND VGND VPWR VPWR sky130_fd_sc_hd__fill_2
X_5912_ _5912_/A _5912_/B VGND VGND VPWR VPWR _5913_/B sky130_fd_sc_hd__nand2_2
XFILLER_34_430 VGND VGND VPWR VPWR sky130_fd_sc_hd__fill_2
X_6892_ _6892_/A _6892_/B VGND VGND VPWR VPWR _6893_/B sky130_fd_sc_hd__xor2_2
XTAP_TAPCELL_ROW_24_609 VGND VPWR sky130_fd_sc_hd__tapvpwrvgnd_1
XFILLER_34_463 VGND VGND VPWR VPWR sky130_fd_sc_hd__decap_3
X_8631_ _8644_/B _8631_/B VGND VGND VPWR VPWR _8639_/A sky130_fd_sc_hd__xor2_2
XFILLER_34_474 VGND VGND VPWR VPWR sky130_fd_sc_hd__fill_2
X_5843_ _5843_/A _5843_/B VGND VGND VPWR VPWR wire62/A sky130_fd_sc_hd__xnor2_2
XTAP_TAPCELL_ROW_62_1117 VGND VPWR sky130_fd_sc_hd__tapvpwrvgnd_1
XFILLER_61_260 VGND VGND VPWR VPWR sky130_fd_sc_hd__decap_3
XFILLER_22_625 VGND VGND VPWR VPWR sky130_fd_sc_hd__decap_3
XFILLER_21_113 VGND VGND VPWR VPWR sky130_fd_sc_hd__decap_3
X_8562_ _8562_/A _8562_/B VGND VGND VPWR VPWR _8562_/X sky130_fd_sc_hd__or2_2
XFILLER_22_669 VGND VGND VPWR VPWR sky130_fd_sc_hd__decap_3
X_5774_ _5773_/B _5773_/C _5774_/B1 VGND VGND VPWR VPWR _5774_/X sky130_fd_sc_hd__a21o_2
X_7513_ _7513_/A _7513_/B VGND VGND VPWR VPWR _7556_/A sky130_fd_sc_hd__or2_2
X_4725_ _9110_/Q _4725_/A1 _4735_/S VGND VGND VPWR VPWR _4725_/X sky130_fd_sc_hd__mux2_2
X_8493_ _8493_/A _8493_/B VGND VGND VPWR VPWR _8514_/B sky130_fd_sc_hd__xnor2_2
Xrebuffer428 _4952_/Y VGND VGND VPWR VPWR _4953_/A sky130_fd_sc_hd__buf_6
Xrebuffer439 _6326_/C VGND VGND VPWR VPWR _6188_/C sky130_fd_sc_hd__buf_2
X_4656_ _9077_/Q hold956/X _4672_/S VGND VGND VPWR VPWR _4656_/X sky130_fd_sc_hd__mux2_2
X_7444_ _7443_/A _7443_/B _7332_/B _7332_/A VGND VGND VPWR VPWR _7444_/X sky130_fd_sc_hd__a2bb2o_2
Xhold810 _9190_/Q VGND VGND VPWR VPWR hold810/X sky130_fd_sc_hd__dlygate4sd3_1
X_4587_ _4621_/A1 _9029_/Q _4587_/S VGND VGND VPWR VPWR _4587_/X sky130_fd_sc_hd__mux2_2
X_7375_ _7375_/A _7375_/B VGND VGND VPWR VPWR _7496_/A sky130_fd_sc_hd__and2_2
Xhold832 _4719_/X VGND VGND VPWR VPWR _4720_/A sky130_fd_sc_hd__dlygate4sd3_1
XFILLER_116_752 VGND VGND VPWR VPWR sky130_fd_sc_hd__decap_3
Xhold843 _9134_/Q VGND VGND VPWR VPWR hold843/X sky130_fd_sc_hd__dlygate4sd3_1
XFILLER_116_763 VGND VGND VPWR VPWR sky130_fd_sc_hd__decap_3
X_9114_ _9334_/CLK _9114_/D fanout400/X VGND VGND VPWR VPWR _9114_/Q sky130_fd_sc_hd__dfrtp_2
X_6326_ _6188_/A _6326_/B _6326_/C VGND VGND VPWR VPWR _6326_/Y sky130_fd_sc_hd__nand3b_2
Xhold854 _9263_/Q VGND VGND VPWR VPWR hold854/X sky130_fd_sc_hd__dlygate4sd3_1
XFILLER_107_24 VGND VGND VPWR VPWR sky130_fd_sc_hd__decap_3
Xhold865 _9040_/Q VGND VGND VPWR VPWR hold865/X sky130_fd_sc_hd__dlygate4sd3_1
XFILLER_1_518 VGND VGND VPWR VPWR sky130_fd_sc_hd__decap_3
Xhold876 _9059_/Q VGND VGND VPWR VPWR hold876/X sky130_fd_sc_hd__dlygate4sd3_1
XFILLER_89_636 VGND VGND VPWR VPWR sky130_fd_sc_hd__decap_3
Xhold887 _8936_/X VGND VGND VPWR VPWR _8937_/A sky130_fd_sc_hd__dlygate4sd3_1
XFILLER_107_57 VGND VGND VPWR VPWR sky130_fd_sc_hd__fill_2
Xhold898 _9159_/Q VGND VGND VPWR VPWR hold898/X sky130_fd_sc_hd__dlygate4sd3_1
X_6257_ _8271_/B _6255_/X _6256_/X VGND VGND VPWR VPWR _6378_/B sky130_fd_sc_hd__a21oi_2
X_9045_ _9345_/CLK _9045_/D load_slew388/X VGND VGND VPWR VPWR _9045_/Q sky130_fd_sc_hd__dfrtp_2
XTAP_TAPCELL_ROW_73_1268 VGND VPWR sky130_fd_sc_hd__tapvpwrvgnd_1
XFILLER_130_221 VGND VGND VPWR VPWR sky130_fd_sc_hd__decap_3
XFILLER_107_68 VGND VGND VPWR VPWR sky130_fd_sc_hd__fill_2
XFILLER_130_243 VGND VGND VPWR VPWR sky130_fd_sc_hd__decap_3
XFILLER_88_157 VGND VGND VPWR VPWR sky130_fd_sc_hd__decap_3
X_5208_ _5208_/A _5208_/B VGND VGND VPWR VPWR _5305_/B sky130_fd_sc_hd__xnor2_2
XFILLER_57_500 VGND VGND VPWR VPWR sky130_fd_sc_hd__decap_3
XFILLER_130_265 VGND VGND VPWR VPWR sky130_fd_sc_hd__decap_3
X_6188_ _6188_/A _6326_/B _6188_/C VGND VGND VPWR VPWR _6193_/C sky130_fd_sc_hd__nand3_2
XFILLER_57_511 VGND VGND VPWR VPWR sky130_fd_sc_hd__decap_3
XTAP_TAPCELL_ROW_4_334 VGND VPWR sky130_fd_sc_hd__tapvpwrvgnd_1
XFILLER_97_691 VGND VGND VPWR VPWR sky130_fd_sc_hd__decap_3
XFILLER_69_382 VGND VGND VPWR VPWR sky130_fd_sc_hd__fill_2
XFILLER_123_12 VGND VGND VPWR VPWR sky130_fd_sc_hd__decap_3
X_5139_ _5137_/X _5138_/X _5343_/A VGND VGND VPWR VPWR _5147_/A sky130_fd_sc_hd__a21o_2
XFILLER_84_330 VGND VGND VPWR VPWR sky130_fd_sc_hd__decap_3
XFILLER_123_45 VGND VGND VPWR VPWR sky130_fd_sc_hd__decap_3
XFILLER_45_717 VGND VGND VPWR VPWR sky130_fd_sc_hd__decap_3
XFILLER_17_408 VGND VGND VPWR VPWR sky130_fd_sc_hd__decap_3
XFILLER_83_27 VGND VGND VPWR VPWR sky130_fd_sc_hd__decap_3
XFILLER_123_78 VGND VGND VPWR VPWR sky130_fd_sc_hd__decap_3
XFILLER_44_227 VGND VGND VPWR VPWR sky130_fd_sc_hd__decap_3
XFILLER_72_547 VGND VGND VPWR VPWR sky130_fd_sc_hd__fill_2
XFILLER_16_21 VGND VGND VPWR VPWR sky130_fd_sc_hd__decap_3
XFILLER_72_569 VGND VGND VPWR VPWR sky130_fd_sc_hd__decap_3
XFILLER_16_32 VGND VGND VPWR VPWR sky130_fd_sc_hd__decap_3
XFILLER_16_65 VGND VGND VPWR VPWR sky130_fd_sc_hd__decap_3
X_8829_ hold900/X _8829_/A1 _8841_/S VGND VGND VPWR VPWR _8830_/A sky130_fd_sc_hd__mux2_2
XFILLER_13_625 VGND VGND VPWR VPWR sky130_fd_sc_hd__fill_1
XFILLER_40_466 VGND VGND VPWR VPWR sky130_fd_sc_hd__fill_2
XTAP_TAPCELL_ROW_51_973 VGND VPWR sky130_fd_sc_hd__tapvpwrvgnd_1
XFILLER_40_477 VGND VGND VPWR VPWR sky130_fd_sc_hd__fill_2
XFILLER_12_179 VGND VGND VPWR VPWR sky130_fd_sc_hd__decap_3
XFILLER_32_53 VGND VGND VPWR VPWR sky130_fd_sc_hd__decap_3
XFILLER_21_691 VGND VGND VPWR VPWR sky130_fd_sc_hd__decap_3
XFILLER_126_527 VGND VGND VPWR VPWR sky130_fd_sc_hd__decap_3
XFILLER_4_312 VGND VGND VPWR VPWR sky130_fd_sc_hd__decap_3
XFILLER_107_741 VGND VGND VPWR VPWR sky130_fd_sc_hd__decap_3
XFILLER_106_240 VGND VGND VPWR VPWR sky130_fd_sc_hd__fill_2
XFILLER_79_102 VGND VGND VPWR VPWR sky130_fd_sc_hd__fill_1
XFILLER_4_389 VGND VGND VPWR VPWR sky130_fd_sc_hd__decap_3
XFILLER_79_113 VGND VGND VPWR VPWR sky130_fd_sc_hd__decap_3
XFILLER_122_733 VGND VGND VPWR VPWR sky130_fd_sc_hd__decap_3
XFILLER_106_295 VGND VGND VPWR VPWR sky130_fd_sc_hd__fill_2
XFILLER_122_766 VGND VGND VPWR VPWR sky130_fd_sc_hd__decap_3
XFILLER_0_551 VGND VGND VPWR VPWR sky130_fd_sc_hd__decap_3
XFILLER_95_617 VGND VGND VPWR VPWR sky130_fd_sc_hd__decap_3
XFILLER_67_319 VGND VGND VPWR VPWR sky130_fd_sc_hd__decap_3
XFILLER_121_265 VGND VGND VPWR VPWR sky130_fd_sc_hd__decap_3
XFILLER_0_573 VGND VGND VPWR VPWR sky130_fd_sc_hd__decap_3
XFILLER_94_127 VGND VGND VPWR VPWR sky130_fd_sc_hd__fill_2
XFILLER_88_691 VGND VGND VPWR VPWR sky130_fd_sc_hd__decap_3
XFILLER_0_595 VGND VGND VPWR VPWR sky130_fd_sc_hd__decap_3
XFILLER_48_533 VGND VGND VPWR VPWR sky130_fd_sc_hd__decap_3
XFILLER_87_190 VGND VGND VPWR VPWR sky130_fd_sc_hd__decap_3
XFILLER_75_330 VGND VGND VPWR VPWR sky130_fd_sc_hd__decap_3
XFILLER_57_72 VGND VGND VPWR VPWR sky130_fd_sc_hd__decap_3
XFILLER_36_706 VGND VGND VPWR VPWR sky130_fd_sc_hd__decap_3
XFILLER_63_503 VGND VGND VPWR VPWR sky130_fd_sc_hd__fill_1
XFILLER_35_249 VGND VGND VPWR VPWR sky130_fd_sc_hd__decap_3
XFILLER_63_569 VGND VGND VPWR VPWR sky130_fd_sc_hd__decap_3
XFILLER_73_60 VGND VGND VPWR VPWR sky130_fd_sc_hd__fill_1
XFILLER_31_411 VGND VGND VPWR VPWR sky130_fd_sc_hd__decap_3
XFILLER_31_433 VGND VGND VPWR VPWR sky130_fd_sc_hd__decap_3
XFILLER_31_444 VGND VGND VPWR VPWR sky130_fd_sc_hd__decap_3
XFILLER_8_662 VGND VGND VPWR VPWR sky130_fd_sc_hd__decap_3
X_5490_ _5490_/A _5490_/B VGND VGND VPWR VPWR _5638_/B sky130_fd_sc_hd__xnor2_4
XFILLER_7_183 VGND VGND VPWR VPWR sky130_fd_sc_hd__fill_2
XPHY_EDGE_ROW_9_Right_9 VGND VGND VPWR VPWR sky130_fd_sc_hd__decap_3
XTAP_TAPCELL_ROW_113_1803 VGND VPWR sky130_fd_sc_hd__tapvpwrvgnd_1
X_7160_ _7157_/Y _7158_/Y _7159_/Y _7702_/A _7885_/B VGND VGND VPWR VPWR _7163_/A
+ sky130_fd_sc_hd__o221a_2
XFILLER_98_400 VGND VGND VPWR VPWR sky130_fd_sc_hd__fill_1
X_6111_ _6113_/A _6434_/B VGND VGND VPWR VPWR _6111_/X sky130_fd_sc_hd__xor2_4
XFILLER_98_433 VGND VGND VPWR VPWR sky130_fd_sc_hd__fill_1
XFILLER_113_744 VGND VGND VPWR VPWR sky130_fd_sc_hd__fill_1
X_7091_ _7349_/A1 _7078_/Y _7089_/X _7090_/Y VGND VGND VPWR VPWR _7103_/B sky130_fd_sc_hd__o211ai_2
XFILLER_112_221 VGND VGND VPWR VPWR sky130_fd_sc_hd__fill_2
XPHY_EDGE_ROW_107_Right_107 VGND VGND VPWR VPWR sky130_fd_sc_hd__decap_3
XFILLER_98_477 VGND VGND VPWR VPWR sky130_fd_sc_hd__decap_3
X_6042_ _6042_/A _6042_/B VGND VGND VPWR VPWR _6186_/A sky130_fd_sc_hd__xnor2_4
XFILLER_86_628 VGND VGND VPWR VPWR sky130_fd_sc_hd__decap_3
XFILLER_58_319 VGND VGND VPWR VPWR sky130_fd_sc_hd__decap_3
XFILLER_98_499 VGND VGND VPWR VPWR sky130_fd_sc_hd__decap_3
XFILLER_79_680 VGND VGND VPWR VPWR sky130_fd_sc_hd__decap_3
XFILLER_39_511 VGND VGND VPWR VPWR sky130_fd_sc_hd__fill_1
XFILLER_100_427 VGND VGND VPWR VPWR sky130_fd_sc_hd__decap_3
XFILLER_112_287 VGND VGND VPWR VPWR sky130_fd_sc_hd__fill_2
XFILLER_39_522 VGND VGND VPWR VPWR sky130_fd_sc_hd__decap_3
XFILLER_100_449 VGND VGND VPWR VPWR sky130_fd_sc_hd__decap_3
XFILLER_39_533 VGND VGND VPWR VPWR sky130_fd_sc_hd__decap_3
XFILLER_39_555 VGND VGND VPWR VPWR sky130_fd_sc_hd__fill_1
XFILLER_94_661 VGND VGND VPWR VPWR sky130_fd_sc_hd__decap_3
XFILLER_66_363 VGND VGND VPWR VPWR sky130_fd_sc_hd__fill_1
XFILLER_81_300 VGND VGND VPWR VPWR sky130_fd_sc_hd__decap_3
XFILLER_66_374 VGND VGND VPWR VPWR sky130_fd_sc_hd__decap_3
XFILLER_54_514 VGND VGND VPWR VPWR sky130_fd_sc_hd__fill_2
X_7993_ _7993_/A VGND VGND VPWR VPWR _9218_/D sky130_fd_sc_hd__buf_1
XFILLER_54_547 VGND VGND VPWR VPWR sky130_fd_sc_hd__decap_3
XFILLER_26_238 VGND VGND VPWR VPWR sky130_fd_sc_hd__decap_3
X_6944_ _6944_/A _6944_/B VGND VGND VPWR VPWR _7117_/B sky130_fd_sc_hd__nor2_2
XFILLER_19_290 VGND VGND VPWR VPWR sky130_fd_sc_hd__decap_3
XTAP_TAPCELL_ROW_124_1954 VGND VPWR sky130_fd_sc_hd__tapvpwrvgnd_1
XTAP_TAPCELL_ROW_37_778 VGND VPWR sky130_fd_sc_hd__tapvpwrvgnd_1
XFILLER_41_208 VGND VGND VPWR VPWR sky130_fd_sc_hd__decap_3
XFILLER_81_399 VGND VGND VPWR VPWR sky130_fd_sc_hd__decap_3
X_6875_ _7522_/A _7520_/A _6874_/X VGND VGND VPWR VPWR _7196_/B sky130_fd_sc_hd__o21ai_2
XFILLER_50_720 VGND VGND VPWR VPWR sky130_fd_sc_hd__decap_3
XFILLER_22_411 VGND VGND VPWR VPWR sky130_fd_sc_hd__decap_3
X_8614_ _8654_/S _8612_/X _8613_/X VGND VGND VPWR VPWR _8615_/B sky130_fd_sc_hd__a21o_2
X_5826_ _5703_/A _5703_/B _5863_/A VGND VGND VPWR VPWR _5826_/X sky130_fd_sc_hd__o21ba_2
XFILLER_22_455 VGND VGND VPWR VPWR sky130_fd_sc_hd__decap_3
XFILLER_22_477 VGND VGND VPWR VPWR sky130_fd_sc_hd__decap_3
XFILLER_10_628 VGND VGND VPWR VPWR sky130_fd_sc_hd__decap_3
X_8545_ wire313/X _8560_/A _7561_/A _8774_/C1 VGND VGND VPWR VPWR _8545_/X sky130_fd_sc_hd__o211a_2
X_5757_ _9203_/Q _6765_/A _5631_/B _5635_/A VGND VGND VPWR VPWR _5757_/X sky130_fd_sc_hd__a31o_2
X_4708_ hold868/X _4708_/A1 _4714_/S VGND VGND VPWR VPWR _4709_/A sky130_fd_sc_hd__mux2_2
X_8476_ _8566_/A VGND VGND VPWR VPWR _8476_/X sky130_fd_sc_hd__clkbuf_1
X_5688_ _5968_/S hold846/X _5685_/X _5687_/Y VGND VGND VPWR VPWR _5688_/X sky130_fd_sc_hd__a31o_2
XFILLER_118_12 VGND VGND VPWR VPWR sky130_fd_sc_hd__decap_3
X_7427_ _7955_/A _8070_/A _7324_/B VGND VGND VPWR VPWR _7579_/A sky130_fd_sc_hd__a21o_2
X_4639_ _4639_/A VGND VGND VPWR VPWR _9069_/D sky130_fd_sc_hd__buf_1
XTAP_TAPCELL_ROW_9_404 VGND VPWR sky130_fd_sc_hd__tapvpwrvgnd_1
XFILLER_123_508 VGND VGND VPWR VPWR sky130_fd_sc_hd__decap_3
XFILLER_118_56 VGND VGND VPWR VPWR sky130_fd_sc_hd__decap_3
X_7358_ _7358_/A1 _7356_/Y _7357_/Y VGND VGND VPWR VPWR _7370_/A sky130_fd_sc_hd__o21ai_2
XFILLER_1_304 VGND VGND VPWR VPWR sky130_fd_sc_hd__decap_3
XFILLER_116_571 VGND VGND VPWR VPWR sky130_fd_sc_hd__decap_3
XFILLER_78_38 VGND VGND VPWR VPWR sky130_fd_sc_hd__decap_3
XFILLER_89_422 VGND VGND VPWR VPWR sky130_fd_sc_hd__decap_3
XFILLER_103_210 VGND VGND VPWR VPWR sky130_fd_sc_hd__decap_3
X_6309_ _6575_/A _6309_/B VGND VGND VPWR VPWR _6583_/B sky130_fd_sc_hd__xnor2_2
XFILLER_89_444 VGND VGND VPWR VPWR sky130_fd_sc_hd__decap_3
XFILLER_1_337 VGND VGND VPWR VPWR sky130_fd_sc_hd__decap_3
X_7289_ _8137_/A _8411_/A VGND VGND VPWR VPWR _7293_/A sky130_fd_sc_hd__nand2_2
XFILLER_89_477 VGND VGND VPWR VPWR sky130_fd_sc_hd__decap_3
XFILLER_103_265 VGND VGND VPWR VPWR sky130_fd_sc_hd__decap_3
X_9028_ _9344_/CLK _9028_/D load_slew380/X VGND VGND VPWR VPWR _9028_/Q sky130_fd_sc_hd__dfrtp_2
XFILLER_49_319 VGND VGND VPWR VPWR sky130_fd_sc_hd__decap_3
XFILLER_94_15 VGND VGND VPWR VPWR sky130_fd_sc_hd__fill_1
XFILLER_91_108 VGND VGND VPWR VPWR sky130_fd_sc_hd__decap_3
XFILLER_57_363 VGND VGND VPWR VPWR sky130_fd_sc_hd__decap_3
XFILLER_27_20 VGND VGND VPWR VPWR sky130_fd_sc_hd__decap_3
XFILLER_91_119 VGND VGND VPWR VPWR sky130_fd_sc_hd__decap_3
XFILLER_85_683 VGND VGND VPWR VPWR sky130_fd_sc_hd__decap_3
XFILLER_45_514 VGND VGND VPWR VPWR sky130_fd_sc_hd__fill_2
XFILLER_18_728 VGND VGND VPWR VPWR sky130_fd_sc_hd__decap_3
XFILLER_17_216 VGND VGND VPWR VPWR sky130_fd_sc_hd__decap_3
XTAP_TAPCELL_ROW_86_1437 VGND VPWR sky130_fd_sc_hd__tapvpwrvgnd_1
XFILLER_84_182 VGND VGND VPWR VPWR sky130_fd_sc_hd__fill_1
XFILLER_57_396 VGND VGND VPWR VPWR sky130_fd_sc_hd__decap_3
XFILLER_27_53 VGND VGND VPWR VPWR sky130_fd_sc_hd__decap_3
XTAP_TAPCELL_ROW_86_1448 VGND VPWR sky130_fd_sc_hd__tapvpwrvgnd_1
XFILLER_27_64 VGND VGND VPWR VPWR sky130_fd_sc_hd__decap_3
XFILLER_17_249 VGND VGND VPWR VPWR sky130_fd_sc_hd__decap_3
XFILLER_26_750 VGND VGND VPWR VPWR sky130_fd_sc_hd__decap_3
XFILLER_32_208 VGND VGND VPWR VPWR sky130_fd_sc_hd__decap_3
XFILLER_26_772 VGND VGND VPWR VPWR sky130_fd_sc_hd__decap_3
XFILLER_60_528 VGND VGND VPWR VPWR sky130_fd_sc_hd__decap_3
XFILLER_43_41 VGND VGND VPWR VPWR sky130_fd_sc_hd__decap_3
XFILLER_43_63 VGND VGND VPWR VPWR sky130_fd_sc_hd__decap_3
XFILLER_41_775 VGND VGND VPWR VPWR sky130_fd_sc_hd__fill_2
XFILLER_13_477 VGND VGND VPWR VPWR sky130_fd_sc_hd__decap_3
XFILLER_9_437 VGND VGND VPWR VPWR sky130_fd_sc_hd__fill_2
XFILLER_13_499 VGND VGND VPWR VPWR sky130_fd_sc_hd__decap_3
XFILLER_5_610 VGND VGND VPWR VPWR sky130_fd_sc_hd__decap_3
XFILLER_126_335 VGND VGND VPWR VPWR sky130_fd_sc_hd__decap_3
XTAP_TAPCELL_ROW_97_1588 VGND VPWR sky130_fd_sc_hd__tapvpwrvgnd_1
XFILLER_57_9 VGND VGND VPWR VPWR sky130_fd_sc_hd__decap_3
XFILLER_126_368 VGND VGND VPWR VPWR sky130_fd_sc_hd__decap_3
XFILLER_114_508 VGND VGND VPWR VPWR sky130_fd_sc_hd__decap_3
XFILLER_5_665 VGND VGND VPWR VPWR sky130_fd_sc_hd__decap_3
XFILLER_5_676 VGND VGND VPWR VPWR sky130_fd_sc_hd__decap_3
XFILLER_4_24 VGND VGND VPWR VPWR sky130_fd_sc_hd__decap_3
XFILLER_107_582 VGND VGND VPWR VPWR sky130_fd_sc_hd__decap_3
XFILLER_4_35 VGND VGND VPWR VPWR sky130_fd_sc_hd__decap_3
XFILLER_4_186 VGND VGND VPWR VPWR sky130_fd_sc_hd__fill_1
XFILLER_4_197 VGND VGND VPWR VPWR sky130_fd_sc_hd__decap_3
XTAP_TAPCELL_ROW_128_2010 VGND VPWR sky130_fd_sc_hd__tapvpwrvgnd_1
XFILLER_110_725 VGND VGND VPWR VPWR sky130_fd_sc_hd__decap_3
XFILLER_68_82 VGND VGND VPWR VPWR sky130_fd_sc_hd__fill_2
XFILLER_67_116 VGND VGND VPWR VPWR sky130_fd_sc_hd__decap_3
XFILLER_95_447 VGND VGND VPWR VPWR sky130_fd_sc_hd__fill_1
XFILLER_110_769 VGND VGND VPWR VPWR sky130_fd_sc_hd__fill_2
XFILLER_76_661 VGND VGND VPWR VPWR sky130_fd_sc_hd__decap_3
XFILLER_82_108 VGND VGND VPWR VPWR sky130_fd_sc_hd__decap_3
XFILLER_36_514 VGND VGND VPWR VPWR sky130_fd_sc_hd__decap_3
XFILLER_63_322 VGND VGND VPWR VPWR sky130_fd_sc_hd__decap_3
XFILLER_36_536 VGND VGND VPWR VPWR sky130_fd_sc_hd__decap_3
XFILLER_84_81 VGND VGND VPWR VPWR sky130_fd_sc_hd__decap_3
XFILLER_90_141 VGND VGND VPWR VPWR sky130_fd_sc_hd__fill_1
XFILLER_36_569 VGND VGND VPWR VPWR sky130_fd_sc_hd__decap_3
XFILLER_17_750 VGND VGND VPWR VPWR sky130_fd_sc_hd__decap_3
X_4990_ _6206_/B _5464_/A1 _4986_/X _4989_/X _5990_/A VGND VGND VPWR VPWR _5103_/A
+ sky130_fd_sc_hd__a32o_2
XFILLER_90_152 VGND VGND VPWR VPWR sky130_fd_sc_hd__decap_3
XFILLER_51_517 VGND VGND VPWR VPWR sky130_fd_sc_hd__decap_3
XFILLER_63_399 VGND VGND VPWR VPWR sky130_fd_sc_hd__decap_3
XTAP_TAPCELL_ROW_34_737 VGND VPWR sky130_fd_sc_hd__tapvpwrvgnd_1
XFILLER_16_271 VGND VGND VPWR VPWR sky130_fd_sc_hd__fill_2
XFILLER_16_293 VGND VGND VPWR VPWR sky130_fd_sc_hd__decap_3
XFILLER_90_3 VGND VGND VPWR VPWR sky130_fd_sc_hd__decap_3
X_6660_ _6661_/A _6661_/B VGND VGND VPWR VPWR _6660_/Y sky130_fd_sc_hd__nor2_2
X_5611_ _9326_/Q _9122_/Q _5611_/S VGND VGND VPWR VPWR _5612_/B sky130_fd_sc_hd__mux2_2
XFILLER_31_274 VGND VGND VPWR VPWR sky130_fd_sc_hd__decap_3
XTAP_TAPCELL_ROW_14_472 VGND VPWR sky130_fd_sc_hd__tapvpwrvgnd_1
X_6591_ _6591_/A _6708_/A _6708_/B VGND VGND VPWR VPWR _6705_/C sky130_fd_sc_hd__or3b_4
XFILLER_129_140 VGND VGND VPWR VPWR sky130_fd_sc_hd__decap_3
X_8330_ _8410_/S _8176_/B _8329_/A VGND VGND VPWR VPWR _8330_/Y sky130_fd_sc_hd__o21ai_2
X_5542_ _5934_/A _5540_/X _5674_/B _5514_/Y VGND VGND VPWR VPWR _5543_/B sky130_fd_sc_hd__o2bb2a_2
XFILLER_129_184 VGND VGND VPWR VPWR sky130_fd_sc_hd__decap_3
X_5473_ _5473_/A _5473_/B _5473_/C _5473_/D VGND VGND VPWR VPWR _5473_/Y sky130_fd_sc_hd__nor4_4
X_8261_ _8350_/A VGND VGND VPWR VPWR _8261_/Y sky130_fd_sc_hd__inv_2
XFILLER_117_346 VGND VGND VPWR VPWR sky130_fd_sc_hd__fill_2
XFILLER_105_508 VGND VGND VPWR VPWR sky130_fd_sc_hd__decap_3
X_7212_ _7212_/A _7212_/B VGND VGND VPWR VPWR _7212_/X sky130_fd_sc_hd__or2_2
XTAP_TAPCELL_ROW_57_1049 VGND VPWR sky130_fd_sc_hd__tapvpwrvgnd_1
X_8192_ _8109_/A _8192_/A2 _8191_/X VGND VGND VPWR VPWR _8283_/A sky130_fd_sc_hd__o21a_2
X_7143_ _7274_/B _7141_/Y _7142_/X VGND VGND VPWR VPWR _7143_/X sky130_fd_sc_hd__a21o_2
XFILLER_98_230 VGND VGND VPWR VPWR sky130_fd_sc_hd__fill_1
Xfanout405 fanout405/A VGND VGND VPWR VPWR wire406/A sky130_fd_sc_hd__clkdlybuf4s25_1
XFILLER_113_541 VGND VGND VPWR VPWR sky130_fd_sc_hd__fill_2
XFILLER_59_617 VGND VGND VPWR VPWR sky130_fd_sc_hd__decap_3
XTAP_TAPCELL_ROW_70_1227 VGND VPWR sky130_fd_sc_hd__tapvpwrvgnd_1
XFILLER_113_574 VGND VGND VPWR VPWR sky130_fd_sc_hd__decap_3
XFILLER_101_725 VGND VGND VPWR VPWR sky130_fd_sc_hd__decap_3
X_7074_ _7073_/A _7073_/B _6975_/A VGND VGND VPWR VPWR _7300_/B sky130_fd_sc_hd__a21o_2
XFILLER_58_116 VGND VGND VPWR VPWR sky130_fd_sc_hd__decap_3
XFILLER_86_436 VGND VGND VPWR VPWR sky130_fd_sc_hd__decap_3
XFILLER_113_596 VGND VGND VPWR VPWR sky130_fd_sc_hd__decap_3
XFILLER_101_747 VGND VGND VPWR VPWR sky130_fd_sc_hd__decap_3
X_6025_ _5843_/A _5842_/B _6024_/X VGND VGND VPWR VPWR _6221_/A sky130_fd_sc_hd__a21o_2
XFILLER_39_330 VGND VGND VPWR VPWR sky130_fd_sc_hd__decap_3
XFILLER_100_246 VGND VGND VPWR VPWR sky130_fd_sc_hd__decap_3
XFILLER_86_469 VGND VGND VPWR VPWR sky130_fd_sc_hd__decap_3
XFILLER_100_279 VGND VGND VPWR VPWR sky130_fd_sc_hd__decap_3
XFILLER_104_47 VGND VGND VPWR VPWR sky130_fd_sc_hd__decap_3
XFILLER_27_503 VGND VGND VPWR VPWR sky130_fd_sc_hd__fill_1
XFILLER_54_300 VGND VGND VPWR VPWR sky130_fd_sc_hd__decap_3
XFILLER_67_694 VGND VGND VPWR VPWR sky130_fd_sc_hd__decap_3
XFILLER_94_480 VGND VGND VPWR VPWR sky130_fd_sc_hd__decap_3
XFILLER_66_182 VGND VGND VPWR VPWR sky130_fd_sc_hd__decap_3
XFILLER_39_396 VGND VGND VPWR VPWR sky130_fd_sc_hd__decap_3
XFILLER_66_193 VGND VGND VPWR VPWR sky130_fd_sc_hd__decap_3
XFILLER_27_547 VGND VGND VPWR VPWR sky130_fd_sc_hd__decap_3
XFILLER_15_709 VGND VGND VPWR VPWR sky130_fd_sc_hd__decap_3
X_7976_ _8080_/B _7976_/B VGND VGND VPWR VPWR _7977_/B sky130_fd_sc_hd__xnor2_2
XFILLER_82_686 VGND VGND VPWR VPWR sky130_fd_sc_hd__decap_3
XFILLER_42_528 VGND VGND VPWR VPWR sky130_fd_sc_hd__decap_3
X_6927_ _6699_/A _6926_/Y _6697_/C VGND VGND VPWR VPWR _6927_/X sky130_fd_sc_hd__a21bo_2
XFILLER_54_399 VGND VGND VPWR VPWR sky130_fd_sc_hd__decap_3
XFILLER_120_24 VGND VGND VPWR VPWR sky130_fd_sc_hd__decap_3
XFILLER_120_35 VGND VGND VPWR VPWR sky130_fd_sc_hd__decap_3
XFILLER_35_591 VGND VGND VPWR VPWR sky130_fd_sc_hd__decap_3
XFILLER_23_753 VGND VGND VPWR VPWR sky130_fd_sc_hd__decap_3
XFILLER_22_230 VGND VGND VPWR VPWR sky130_fd_sc_hd__decap_3
XFILLER_120_68 VGND VGND VPWR VPWR sky130_fd_sc_hd__decap_3
X_6858_ _8034_/A VGND VGND VPWR VPWR _8009_/A sky130_fd_sc_hd__inv_2
XFILLER_50_561 VGND VGND VPWR VPWR sky130_fd_sc_hd__decap_3
XTAP_TAPCELL_ROW_81_1378 VGND VPWR sky130_fd_sc_hd__tapvpwrvgnd_1
XFILLER_50_572 VGND VGND VPWR VPWR sky130_fd_sc_hd__decap_3
X_5809_ _5809_/A _5809_/B VGND VGND VPWR VPWR _5811_/B sky130_fd_sc_hd__xnor2_2
XFILLER_22_285 VGND VGND VPWR VPWR sky130_fd_sc_hd__decap_3
XFILLER_13_33 VGND VGND VPWR VPWR sky130_fd_sc_hd__decap_3
X_6789_ _6788_/A _6485_/A _6856_/A VGND VGND VPWR VPWR _6789_/X sky130_fd_sc_hd__o21a_2
XFILLER_10_458 VGND VGND VPWR VPWR sky130_fd_sc_hd__decap_3
X_8528_ _8523_/Y _8562_/B _8525_/Y _8527_/X VGND VGND VPWR VPWR _8528_/X sky130_fd_sc_hd__a31o_2
XFILLER_129_33 VGND VGND VPWR VPWR sky130_fd_sc_hd__decap_3
XFILLER_10_469 VGND VGND VPWR VPWR sky130_fd_sc_hd__decap_3
XFILLER_89_15 VGND VGND VPWR VPWR sky130_fd_sc_hd__decap_3
XFILLER_129_66 VGND VGND VPWR VPWR sky130_fd_sc_hd__decap_3
X_8459_ _8459_/A _8459_/B _8459_/C VGND VGND VPWR VPWR _8459_/Y sky130_fd_sc_hd__nand3_2
XFILLER_129_99 VGND VGND VPWR VPWR sky130_fd_sc_hd__decap_3
XFILLER_108_368 VGND VGND VPWR VPWR sky130_fd_sc_hd__fill_2
XFILLER_108_379 VGND VGND VPWR VPWR sky130_fd_sc_hd__decap_3
XFILLER_2_613 VGND VGND VPWR VPWR sky130_fd_sc_hd__decap_3
XFILLER_123_349 VGND VGND VPWR VPWR sky130_fd_sc_hd__decap_3
XFILLER_2_657 VGND VGND VPWR VPWR sky130_fd_sc_hd__decap_3
XFILLER_104_552 VGND VGND VPWR VPWR sky130_fd_sc_hd__fill_2
XFILLER_49_105 VGND VGND VPWR VPWR sky130_fd_sc_hd__decap_3
XFILLER_49_116 VGND VGND VPWR VPWR sky130_fd_sc_hd__decap_3
XFILLER_77_458 VGND VGND VPWR VPWR sky130_fd_sc_hd__decap_3
XFILLER_49_149 VGND VGND VPWR VPWR sky130_fd_sc_hd__fill_1
XFILLER_58_683 VGND VGND VPWR VPWR sky130_fd_sc_hd__decap_3
XFILLER_38_85 VGND VGND VPWR VPWR sky130_fd_sc_hd__fill_1
Xhold1170 _8825_/X VGND VGND VPWR VPWR _8826_/A sky130_fd_sc_hd__dlygate4sd3_1
XFILLER_85_480 VGND VGND VPWR VPWR sky130_fd_sc_hd__decap_3
Xhold1181 _4660_/X VGND VGND VPWR VPWR _4661_/A sky130_fd_sc_hd__dlygate4sd3_1
XFILLER_73_642 VGND VGND VPWR VPWR sky130_fd_sc_hd__decap_3
Xhold1192 _9239_/Q VGND VGND VPWR VPWR _8820_/A1 sky130_fd_sc_hd__dlygate4sd3_1
XFILLER_33_517 VGND VGND VPWR VPWR sky130_fd_sc_hd__decap_3
XFILLER_14_731 VGND VGND VPWR VPWR sky130_fd_sc_hd__decap_3
XFILLER_13_230 VGND VGND VPWR VPWR sky130_fd_sc_hd__decap_3
XFILLER_41_550 VGND VGND VPWR VPWR sky130_fd_sc_hd__decap_3
XFILLER_41_561 VGND VGND VPWR VPWR sky130_fd_sc_hd__fill_2
XFILLER_14_775 VGND VGND VPWR VPWR sky130_fd_sc_hd__fill_2
XFILLER_9_201 VGND VGND VPWR VPWR sky130_fd_sc_hd__decap_3
XFILLER_13_263 VGND VGND VPWR VPWR sky130_fd_sc_hd__decap_3
XTAP_TAPCELL_ROW_99_1617 VGND VPWR sky130_fd_sc_hd__tapvpwrvgnd_1
XFILLER_9_234 VGND VGND VPWR VPWR sky130_fd_sc_hd__fill_1
XFILLER_9_245 VGND VGND VPWR VPWR sky130_fd_sc_hd__decap_3
XTAP_TAPCELL_ROW_11_431 VGND VPWR sky130_fd_sc_hd__tapvpwrvgnd_1
XFILLER_9_267 VGND VGND VPWR VPWR sky130_fd_sc_hd__decap_3
Xclkload15 _9345_/CLK VGND VGND VPWR VPWR clkload15/Y sky130_fd_sc_hd__clkinv_2
Xclkload26 _9204_/CLK VGND VGND VPWR VPWR clkload26/Y sky130_fd_sc_hd__inv_6
XFILLER_127_644 VGND VGND VPWR VPWR sky130_fd_sc_hd__decap_3
XFILLER_126_121 VGND VGND VPWR VPWR sky130_fd_sc_hd__decap_3
XFILLER_5_440 VGND VGND VPWR VPWR sky130_fd_sc_hd__decap_3
XFILLER_55_6 VGND VGND VPWR VPWR sky130_fd_sc_hd__decap_3
XFILLER_127_688 VGND VGND VPWR VPWR sky130_fd_sc_hd__decap_3
XFILLER_126_165 VGND VGND VPWR VPWR sky130_fd_sc_hd__decap_3
XFILLER_114_327 VGND VGND VPWR VPWR sky130_fd_sc_hd__decap_3
XFILLER_96_701 VGND VGND VPWR VPWR sky130_fd_sc_hd__decap_3
XFILLER_96_723 VGND VGND VPWR VPWR sky130_fd_sc_hd__decap_3
XFILLER_122_360 VGND VGND VPWR VPWR sky130_fd_sc_hd__decap_3
XFILLER_122_371 VGND VGND VPWR VPWR sky130_fd_sc_hd__decap_3
XFILLER_122_382 VGND VGND VPWR VPWR sky130_fd_sc_hd__decap_3
XFILLER_68_458 VGND VGND VPWR VPWR sky130_fd_sc_hd__decap_3
XTAP_TAPCELL_ROW_39_807 VGND VPWR sky130_fd_sc_hd__tapvpwrvgnd_1
XFILLER_95_277 VGND VGND VPWR VPWR sky130_fd_sc_hd__decap_3
XFILLER_64_631 VGND VGND VPWR VPWR sky130_fd_sc_hd__fill_1
XTAP_TAPCELL_ROW_108_1735 VGND VPWR sky130_fd_sc_hd__tapvpwrvgnd_1
XTAP_TAPCELL_ROW_108_1746 VGND VPWR sky130_fd_sc_hd__tapvpwrvgnd_1
XFILLER_36_333 VGND VGND VPWR VPWR sky130_fd_sc_hd__decap_3
X_7830_ _9215_/Q _7924_/A VGND VGND VPWR VPWR _7830_/Y sky130_fd_sc_hd__nand2_2
XTAP_TAPCELL_ROW_19_542 VGND VPWR sky130_fd_sc_hd__tapvpwrvgnd_1
XFILLER_24_506 VGND VGND VPWR VPWR sky130_fd_sc_hd__decap_3
XFILLER_91_461 VGND VGND VPWR VPWR sky130_fd_sc_hd__fill_2
XFILLER_64_697 VGND VGND VPWR VPWR sky130_fd_sc_hd__decap_3
XFILLER_51_314 VGND VGND VPWR VPWR sky130_fd_sc_hd__decap_3
X_7761_ _8155_/A _7619_/A _7931_/B VGND VGND VPWR VPWR _7761_/X sky130_fd_sc_hd__a21o_2
XTAP_TAPCELL_ROW_121_1913 VGND VPWR sky130_fd_sc_hd__tapvpwrvgnd_1
XFILLER_63_185 VGND VGND VPWR VPWR sky130_fd_sc_hd__decap_3
XFILLER_36_399 VGND VGND VPWR VPWR sky130_fd_sc_hd__decap_3
X_4973_ _4973_/A VGND VGND VPWR VPWR _9196_/D sky130_fd_sc_hd__buf_1
X_6712_ _5275_/A _7071_/D _6710_/X _6711_/X VGND VGND VPWR VPWR _6730_/B sky130_fd_sc_hd__a31o_4
XFILLER_51_358 VGND VGND VPWR VPWR sky130_fd_sc_hd__decap_3
X_7692_ _7692_/A _7692_/B VGND VGND VPWR VPWR _7693_/B sky130_fd_sc_hd__xnor2_2
XFILLER_20_701 VGND VGND VPWR VPWR sky130_fd_sc_hd__decap_3
X_6643_ _6643_/A _6643_/B VGND VGND VPWR VPWR _6643_/Y sky130_fd_sc_hd__nand2_2
XFILLER_20_734 VGND VGND VPWR VPWR sky130_fd_sc_hd__decap_3
Xclkload9 clkload9/A VGND VGND VPWR VPWR clkload9/Y sky130_fd_sc_hd__inv_4
X_6574_ _6695_/C _6695_/D VGND VGND VPWR VPWR _6582_/A sky130_fd_sc_hd__nand2_2
X_8313_ _8313_/A _8313_/B VGND VGND VPWR VPWR _8314_/B sky130_fd_sc_hd__nand2_2
X_5525_ _5525_/A _5525_/B VGND VGND VPWR VPWR _5525_/X sky130_fd_sc_hd__or2_2
X_9293_ _9293_/CLK _9293_/D fanout383/X VGND VGND VPWR VPWR _9293_/Q sky130_fd_sc_hd__dfrtp_2
XFILLER_118_666 VGND VGND VPWR VPWR sky130_fd_sc_hd__decap_3
XTAP_TAPCELL_ROW_119_1886 VGND VPWR sky130_fd_sc_hd__tapvpwrvgnd_1
XFILLER_118_688 VGND VGND VPWR VPWR sky130_fd_sc_hd__decap_3
X_8244_ _8244_/A _8321_/A VGND VGND VPWR VPWR _8245_/B sky130_fd_sc_hd__xnor2_2
X_5456_ _9073_/Q _5456_/B VGND VGND VPWR VPWR _5830_/A sky130_fd_sc_hd__nand2_2
X_8175_ _8175_/A _8175_/B VGND VGND VPWR VPWR _8176_/B sky130_fd_sc_hd__nor2_2
X_5387_ _9244_/Q _5387_/B VGND VGND VPWR VPWR _5387_/Y sky130_fd_sc_hd__nor2_4
X_7126_ _7377_/A _7126_/B VGND VGND VPWR VPWR _7127_/C sky130_fd_sc_hd__xnor2_2
XFILLER_99_583 VGND VGND VPWR VPWR sky130_fd_sc_hd__decap_3
XFILLER_59_414 VGND VGND VPWR VPWR sky130_fd_sc_hd__decap_3
Xfanout235 _8175_/A VGND VGND VPWR VPWR _5588_/A sky130_fd_sc_hd__clkdlybuf4s25_1
XFILLER_99_594 VGND VGND VPWR VPWR sky130_fd_sc_hd__decap_3
XFILLER_115_24 VGND VGND VPWR VPWR sky130_fd_sc_hd__decap_3
XFILLER_101_522 VGND VGND VPWR VPWR sky130_fd_sc_hd__decap_3
Xfanout246 _9236_/Q VGND VGND VPWR VPWR _5050_/A sky130_fd_sc_hd__buf_4
XFILLER_113_393 VGND VGND VPWR VPWR sky130_fd_sc_hd__decap_3
Xfanout268 _9233_/Q VGND VGND VPWR VPWR _7794_/A sky130_fd_sc_hd__clkbuf_4
XFILLER_115_57 VGND VGND VPWR VPWR sky130_fd_sc_hd__decap_3
XFILLER_101_555 VGND VGND VPWR VPWR sky130_fd_sc_hd__decap_3
X_7057_ _7056_/A _7056_/B _6990_/Y VGND VGND VPWR VPWR _7357_/C sky130_fd_sc_hd__a21o_4
XFILLER_59_469 VGND VGND VPWR VPWR sky130_fd_sc_hd__decap_3
XFILLER_86_266 VGND VGND VPWR VPWR sky130_fd_sc_hd__decap_3
XFILLER_74_417 VGND VGND VPWR VPWR sky130_fd_sc_hd__decap_3
X_6008_ _6149_/A _6008_/B VGND VGND VPWR VPWR _6052_/A sky130_fd_sc_hd__nor2_2
XFILLER_27_300 VGND VGND VPWR VPWR sky130_fd_sc_hd__decap_3
XFILLER_55_620 VGND VGND VPWR VPWR sky130_fd_sc_hd__fill_2
XFILLER_27_322 VGND VGND VPWR VPWR sky130_fd_sc_hd__decap_3
XPHY_EDGE_ROW_19_Left_150 VGND VGND VPWR VPWR sky130_fd_sc_hd__decap_3
XFILLER_55_642 VGND VGND VPWR VPWR sky130_fd_sc_hd__fill_2
XFILLER_55_653 VGND VGND VPWR VPWR sky130_fd_sc_hd__decap_3
XTAP_TAPCELL_ROW_83_1407 VGND VPWR sky130_fd_sc_hd__tapvpwrvgnd_1
XFILLER_82_461 VGND VGND VPWR VPWR sky130_fd_sc_hd__fill_1
XFILLER_54_163 VGND VGND VPWR VPWR sky130_fd_sc_hd__decap_3
XFILLER_42_303 VGND VGND VPWR VPWR sky130_fd_sc_hd__decap_3
XFILLER_15_528 VGND VGND VPWR VPWR sky130_fd_sc_hd__fill_2
X_7959_ _8070_/A _7960_/C wire88/A _8170_/A VGND VGND VPWR VPWR _7959_/X sky130_fd_sc_hd__a22o_2
XFILLER_91_49 VGND VGND VPWR VPWR sky130_fd_sc_hd__decap_3
XFILLER_24_21 VGND VGND VPWR VPWR sky130_fd_sc_hd__decap_3
XFILLER_70_689 VGND VGND VPWR VPWR sky130_fd_sc_hd__decap_3
XFILLER_23_561 VGND VGND VPWR VPWR sky130_fd_sc_hd__decap_3
XFILLER_24_65 VGND VGND VPWR VPWR sky130_fd_sc_hd__fill_1
XFILLER_11_723 VGND VGND VPWR VPWR sky130_fd_sc_hd__decap_3
XFILLER_50_380 VGND VGND VPWR VPWR sky130_fd_sc_hd__decap_3
XFILLER_11_756 VGND VGND VPWR VPWR sky130_fd_sc_hd__decap_3
XFILLER_7_716 VGND VGND VPWR VPWR sky130_fd_sc_hd__decap_3
XFILLER_7_738 VGND VGND VPWR VPWR sky130_fd_sc_hd__decap_3
XFILLER_6_215 VGND VGND VPWR VPWR sky130_fd_sc_hd__decap_3
XFILLER_109_688 VGND VGND VPWR VPWR sky130_fd_sc_hd__decap_3
XTAP_TAPCELL_ROW_94_1547 VGND VPWR sky130_fd_sc_hd__tapvpwrvgnd_1
XFILLER_40_97 VGND VGND VPWR VPWR sky130_fd_sc_hd__decap_3
XFILLER_124_625 VGND VGND VPWR VPWR sky130_fd_sc_hd__fill_2
XFILLER_123_102 VGND VGND VPWR VPWR sky130_fd_sc_hd__decap_3
XFILLER_108_187 VGND VGND VPWR VPWR sky130_fd_sc_hd__fill_1
XFILLER_123_113 VGND VGND VPWR VPWR sky130_fd_sc_hd__decap_3
XFILLER_123_146 VGND VGND VPWR VPWR sky130_fd_sc_hd__decap_3
XFILLER_78_701 VGND VGND VPWR VPWR sky130_fd_sc_hd__decap_3
XFILLER_78_712 VGND VGND VPWR VPWR sky130_fd_sc_hd__decap_3
XFILLER_49_84 VGND VGND VPWR VPWR sky130_fd_sc_hd__decap_3
XFILLER_93_715 VGND VGND VPWR VPWR sky130_fd_sc_hd__decap_3
XFILLER_37_108 VGND VGND VPWR VPWR sky130_fd_sc_hd__decap_3
XFILLER_37_119 VGND VGND VPWR VPWR sky130_fd_sc_hd__decap_3
XFILLER_1_36 VGND VGND VPWR VPWR sky130_fd_sc_hd__decap_3
XFILLER_46_620 VGND VGND VPWR VPWR sky130_fd_sc_hd__decap_3
XFILLER_1_69 VGND VGND VPWR VPWR sky130_fd_sc_hd__fill_2
XFILLER_46_664 VGND VGND VPWR VPWR sky130_fd_sc_hd__decap_3
XFILLER_18_355 VGND VGND VPWR VPWR sky130_fd_sc_hd__fill_1
XFILLER_73_461 VGND VGND VPWR VPWR sky130_fd_sc_hd__decap_3
XFILLER_65_94 VGND VGND VPWR VPWR sky130_fd_sc_hd__fill_2
XFILLER_18_377 VGND VGND VPWR VPWR sky130_fd_sc_hd__decap_3
XTAP_TAPCELL_ROW_16_501 VGND VPWR sky130_fd_sc_hd__tapvpwrvgnd_1
XFILLER_46_697 VGND VGND VPWR VPWR sky130_fd_sc_hd__decap_3
XFILLER_33_314 VGND VGND VPWR VPWR sky130_fd_sc_hd__decap_3
XFILLER_33_325 VGND VGND VPWR VPWR sky130_fd_sc_hd__decap_3
XFILLER_61_645 VGND VGND VPWR VPWR sky130_fd_sc_hd__decap_3
XFILLER_33_358 VGND VGND VPWR VPWR sky130_fd_sc_hd__decap_3
XFILLER_60_144 VGND VGND VPWR VPWR sky130_fd_sc_hd__decap_3
XTAP_TAPCELL_ROW_44_876 VGND VPWR sky130_fd_sc_hd__tapvpwrvgnd_1
XTAP_TAPCELL_ROW_103_1676 VGND VPWR sky130_fd_sc_hd__tapvpwrvgnd_1
XFILLER_81_60 VGND VGND VPWR VPWR sky130_fd_sc_hd__fill_2
XFILLER_41_391 VGND VGND VPWR VPWR sky130_fd_sc_hd__fill_1
XFILLER_119_408 VGND VGND VPWR VPWR sky130_fd_sc_hd__decap_3
XFILLER_6_760 VGND VGND VPWR VPWR sky130_fd_sc_hd__decap_3
X_5310_ _5310_/A _5310_/B VGND VGND VPWR VPWR _5310_/Y sky130_fd_sc_hd__nand2_2
X_6290_ _6290_/A _6290_/B VGND VGND VPWR VPWR _6291_/B sky130_fd_sc_hd__nand2_2
XFILLER_53_3 VGND VGND VPWR VPWR sky130_fd_sc_hd__decap_3
XFILLER_115_625 VGND VGND VPWR VPWR sky130_fd_sc_hd__decap_3
XFILLER_127_496 VGND VGND VPWR VPWR sky130_fd_sc_hd__fill_2
XFILLER_5_281 VGND VGND VPWR VPWR sky130_fd_sc_hd__decap_3
XTAP_TAPCELL_ROW_54_1008 VGND VPWR sky130_fd_sc_hd__tapvpwrvgnd_1
X_5241_ _8271_/B _5241_/B VGND VGND VPWR VPWR _5241_/Y sky130_fd_sc_hd__nand2_2
XFILLER_115_669 VGND VGND VPWR VPWR sky130_fd_sc_hd__decap_3
XFILLER_130_617 VGND VGND VPWR VPWR sky130_fd_sc_hd__decap_3
X_5172_ _5147_/A _5148_/A _5147_/B VGND VGND VPWR VPWR _5172_/X sky130_fd_sc_hd__o21ba_2
XFILLER_68_211 VGND VGND VPWR VPWR sky130_fd_sc_hd__fill_2
XFILLER_68_222 VGND VGND VPWR VPWR sky130_fd_sc_hd__decap_3
XFILLER_123_691 VGND VGND VPWR VPWR sky130_fd_sc_hd__decap_3
XFILLER_110_330 VGND VGND VPWR VPWR sky130_fd_sc_hd__decap_3
XFILLER_96_553 VGND VGND VPWR VPWR sky130_fd_sc_hd__decap_3
XFILLER_84_704 VGND VGND VPWR VPWR sky130_fd_sc_hd__fill_2
XFILLER_96_586 VGND VGND VPWR VPWR sky130_fd_sc_hd__fill_2
XFILLER_96_597 VGND VGND VPWR VPWR sky130_fd_sc_hd__decap_3
XFILLER_110_374 VGND VGND VPWR VPWR sky130_fd_sc_hd__decap_3
X_8931_ _8931_/A VGND VGND VPWR VPWR _9307_/D sky130_fd_sc_hd__buf_1
Xinput2 sample_in[0] VGND VGND VPWR VPWR input2/X sky130_fd_sc_hd__dlymetal6s2s_1
XFILLER_37_620 VGND VGND VPWR VPWR sky130_fd_sc_hd__fill_1
XFILLER_37_631 VGND VGND VPWR VPWR sky130_fd_sc_hd__decap_3
XFILLER_36_130 VGND VGND VPWR VPWR sky130_fd_sc_hd__fill_2
X_8862_ _9275_/Q hold900/X _8862_/S VGND VGND VPWR VPWR _8862_/X sky130_fd_sc_hd__mux2_2
XFILLER_37_664 VGND VGND VPWR VPWR sky130_fd_sc_hd__decap_3
XFILLER_64_461 VGND VGND VPWR VPWR sky130_fd_sc_hd__decap_3
XFILLER_52_612 VGND VGND VPWR VPWR sky130_fd_sc_hd__fill_2
X_7813_ _7622_/A _7622_/B _7623_/A VGND VGND VPWR VPWR _7813_/X sky130_fd_sc_hd__a21o_2
XFILLER_51_111 VGND VGND VPWR VPWR sky130_fd_sc_hd__fill_1
XFILLER_101_15 VGND VGND VPWR VPWR sky130_fd_sc_hd__decap_3
X_8793_ _9242_/Q _5953_/A _8799_/S VGND VGND VPWR VPWR _8793_/X sky130_fd_sc_hd__mux2_2
XFILLER_52_645 VGND VGND VPWR VPWR sky130_fd_sc_hd__fill_2
XTAP_TAPCELL_ROW_65_1159 VGND VPWR sky130_fd_sc_hd__tapvpwrvgnd_1
X_7744_ _7744_/A _7744_/B VGND VGND VPWR VPWR _7856_/B sky130_fd_sc_hd__nand2_2
X_4956_ _9254_/Q _4956_/B _5990_/A VGND VGND VPWR VPWR _4956_/X sky130_fd_sc_hd__and3_2
XFILLER_51_188 VGND VGND VPWR VPWR sky130_fd_sc_hd__fill_1
X_7675_ _5097_/X _6116_/B _7186_/X VGND VGND VPWR VPWR _7676_/B sky130_fd_sc_hd__a21o_2
XFILLER_32_380 VGND VGND VPWR VPWR sky130_fd_sc_hd__fill_1
X_4887_ _9215_/Q _4899_/B VGND VGND VPWR VPWR _4887_/Y sky130_fd_sc_hd__nor2_2
XFILLER_20_531 VGND VGND VPWR VPWR sky130_fd_sc_hd__fill_1
X_6626_ _6626_/A _6626_/B VGND VGND VPWR VPWR _8410_/S sky130_fd_sc_hd__and2_2
XFILLER_124_9 VGND VGND VPWR VPWR sky130_fd_sc_hd__decap_3
XFILLER_20_586 VGND VGND VPWR VPWR sky130_fd_sc_hd__fill_2
XFILLER_118_430 VGND VGND VPWR VPWR sky130_fd_sc_hd__decap_3
X_9345_ _9345_/CLK _9345_/D load_slew388/X VGND VGND VPWR VPWR _9345_/Q sky130_fd_sc_hd__dfrtp_2
X_6557_ _6557_/A _6557_/B VGND VGND VPWR VPWR _6558_/B sky130_fd_sc_hd__xor2_2
XFILLER_4_719 VGND VGND VPWR VPWR sky130_fd_sc_hd__decap_3
XFILLER_106_625 VGND VGND VPWR VPWR sky130_fd_sc_hd__decap_3
X_5508_ _5507_/A _5507_/Y _5957_/A VGND VGND VPWR VPWR _5508_/X sky130_fd_sc_hd__mux2_2
XFILLER_10_12 VGND VGND VPWR VPWR sky130_fd_sc_hd__decap_3
X_9276_ _9338_/CLK _9276_/D load_slew368/X VGND VGND VPWR VPWR _9276_/Q sky130_fd_sc_hd__dfrtp_2
XFILLER_105_113 VGND VGND VPWR VPWR sky130_fd_sc_hd__decap_3
X_6488_ _6096_/A _6096_/B _6434_/Y VGND VGND VPWR VPWR _7178_/B sky130_fd_sc_hd__a21oi_2
XFILLER_126_12 VGND VGND VPWR VPWR sky130_fd_sc_hd__decap_3
XFILLER_105_146 VGND VGND VPWR VPWR sky130_fd_sc_hd__decap_3
X_8227_ _8231_/A _8315_/A VGND VGND VPWR VPWR _8227_/Y sky130_fd_sc_hd__nand2_2
X_5439_ _8137_/A _5357_/X _5439_/S VGND VGND VPWR VPWR _5440_/B sky130_fd_sc_hd__mux2_2
XFILLER_121_617 VGND VGND VPWR VPWR sky130_fd_sc_hd__decap_3
XFILLER_126_56 VGND VGND VPWR VPWR sky130_fd_sc_hd__decap_3
X_8158_ _8152_/X _8157_/X _8421_/A VGND VGND VPWR VPWR _8180_/A sky130_fd_sc_hd__o21a_2
XFILLER_86_27 VGND VGND VPWR VPWR sky130_fd_sc_hd__fill_1
XFILLER_114_680 VGND VGND VPWR VPWR sky130_fd_sc_hd__decap_3
XFILLER_87_531 VGND VGND VPWR VPWR sky130_fd_sc_hd__decap_3
XFILLER_120_127 VGND VGND VPWR VPWR sky130_fd_sc_hd__decap_3
XFILLER_101_330 VGND VGND VPWR VPWR sky130_fd_sc_hd__decap_3
X_7109_ _7108_/A _7019_/A _6985_/B _6985_/A VGND VGND VPWR VPWR _7375_/B sky130_fd_sc_hd__o211ai_4
XFILLER_19_21 VGND VGND VPWR VPWR sky130_fd_sc_hd__decap_3
XFILLER_87_564 VGND VGND VPWR VPWR sky130_fd_sc_hd__decap_3
XFILLER_75_704 VGND VGND VPWR VPWR sky130_fd_sc_hd__decap_3
X_8089_ _8127_/A _8215_/B VGND VGND VPWR VPWR _8090_/B sky130_fd_sc_hd__xnor2_2
XFILLER_47_417 VGND VGND VPWR VPWR sky130_fd_sc_hd__decap_3
XFILLER_19_119 VGND VGND VPWR VPWR sky130_fd_sc_hd__decap_3
XFILLER_75_748 VGND VGND VPWR VPWR sky130_fd_sc_hd__fill_1
XFILLER_19_98 VGND VGND VPWR VPWR sky130_fd_sc_hd__decap_3
XFILLER_90_707 VGND VGND VPWR VPWR sky130_fd_sc_hd__fill_1
XFILLER_28_653 VGND VGND VPWR VPWR sky130_fd_sc_hd__fill_2
XFILLER_62_409 VGND VGND VPWR VPWR sky130_fd_sc_hd__decap_3
XFILLER_55_461 VGND VGND VPWR VPWR sky130_fd_sc_hd__decap_3
XFILLER_43_601 VGND VGND VPWR VPWR sky130_fd_sc_hd__fill_2
XFILLER_42_100 VGND VGND VPWR VPWR sky130_fd_sc_hd__decap_3
XFILLER_43_656 VGND VGND VPWR VPWR sky130_fd_sc_hd__decap_3
XFILLER_70_475 VGND VGND VPWR VPWR sky130_fd_sc_hd__fill_1
XFILLER_35_97 VGND VGND VPWR VPWR sky130_fd_sc_hd__decap_3
XFILLER_42_177 VGND VGND VPWR VPWR sky130_fd_sc_hd__decap_3
XFILLER_30_317 VGND VGND VPWR VPWR sky130_fd_sc_hd__decap_3
XTAP_TAPCELL_ROW_41_835 VGND VPWR sky130_fd_sc_hd__tapvpwrvgnd_1
XFILLER_129_706 VGND VGND VPWR VPWR sky130_fd_sc_hd__decap_3
XFILLER_51_52 VGND VGND VPWR VPWR sky130_fd_sc_hd__decap_3
XFILLER_11_564 VGND VGND VPWR VPWR sky130_fd_sc_hd__decap_3
XFILLER_128_227 VGND VGND VPWR VPWR sky130_fd_sc_hd__decap_3
XTAP_TAPCELL_ROW_21_570 VGND VPWR sky130_fd_sc_hd__tapvpwrvgnd_1
XFILLER_109_441 VGND VGND VPWR VPWR sky130_fd_sc_hd__decap_3
XFILLER_109_452 VGND VGND VPWR VPWR sky130_fd_sc_hd__decap_3
XFILLER_3_741 VGND VGND VPWR VPWR sky130_fd_sc_hd__decap_3
XFILLER_124_455 VGND VGND VPWR VPWR sky130_fd_sc_hd__decap_3
XFILLER_112_617 VGND VGND VPWR VPWR sky130_fd_sc_hd__decap_3
XFILLER_3_774 VGND VGND VPWR VPWR sky130_fd_sc_hd__decap_3
XFILLER_2_251 VGND VGND VPWR VPWR sky130_fd_sc_hd__fill_1
Xload_slew416 wire417/X VGND VGND VPWR VPWR load_slew416/X sky130_fd_sc_hd__clkbuf_4
XFILLER_111_116 VGND VGND VPWR VPWR sky130_fd_sc_hd__decap_3
XFILLER_105_691 VGND VGND VPWR VPWR sky130_fd_sc_hd__decap_3
XFILLER_111_127 VGND VGND VPWR VPWR sky130_fd_sc_hd__fill_1
XFILLER_78_531 VGND VGND VPWR VPWR sky130_fd_sc_hd__fill_1
XFILLER_66_704 VGND VGND VPWR VPWR sky130_fd_sc_hd__decap_3
XFILLER_38_417 VGND VGND VPWR VPWR sky130_fd_sc_hd__decap_3
XFILLER_93_523 VGND VGND VPWR VPWR sky130_fd_sc_hd__fill_1
XFILLER_66_737 VGND VGND VPWR VPWR sky130_fd_sc_hd__decap_3
XFILLER_76_71 VGND VGND VPWR VPWR sky130_fd_sc_hd__decap_3
XFILLER_18_6 VGND VGND VPWR VPWR sky130_fd_sc_hd__decap_3
XFILLER_120_694 VGND VGND VPWR VPWR sky130_fd_sc_hd__decap_3
XTAP_TAPCELL_ROW_49_946 VGND VPWR sky130_fd_sc_hd__tapvpwrvgnd_1
XFILLER_19_620 VGND VGND VPWR VPWR sky130_fd_sc_hd__decap_3
XFILLER_65_236 VGND VGND VPWR VPWR sky130_fd_sc_hd__decap_3
XFILLER_93_556 VGND VGND VPWR VPWR sky130_fd_sc_hd__decap_3
XFILLER_19_642 VGND VGND VPWR VPWR sky130_fd_sc_hd__decap_3
XFILLER_93_567 VGND VGND VPWR VPWR sky130_fd_sc_hd__decap_3
XFILLER_81_707 VGND VGND VPWR VPWR sky130_fd_sc_hd__decap_3
XFILLER_81_729 VGND VGND VPWR VPWR sky130_fd_sc_hd__decap_3
XFILLER_18_141 VGND VGND VPWR VPWR sky130_fd_sc_hd__decap_3
XTAP_TAPCELL_ROW_105_1705 VGND VPWR sky130_fd_sc_hd__tapvpwrvgnd_1
XFILLER_80_206 VGND VGND VPWR VPWR sky130_fd_sc_hd__fill_1
XFILLER_34_612 VGND VGND VPWR VPWR sky130_fd_sc_hd__decap_3
XTAP_TAPCELL_ROW_29_670 VGND VPWR sky130_fd_sc_hd__tapvpwrvgnd_1
XFILLER_46_483 VGND VGND VPWR VPWR sky130_fd_sc_hd__decap_3
XFILLER_34_645 VGND VGND VPWR VPWR sky130_fd_sc_hd__decap_3
XFILLER_33_122 VGND VGND VPWR VPWR sky130_fd_sc_hd__decap_3
XFILLER_34_667 VGND VGND VPWR VPWR sky130_fd_sc_hd__decap_3
X_4810_ _4810_/A VGND VGND VPWR VPWR _9150_/D sky130_fd_sc_hd__buf_1
XFILLER_61_464 VGND VGND VPWR VPWR sky130_fd_sc_hd__decap_3
X_5790_ _5790_/A _6873_/A _6425_/S VGND VGND VPWR VPWR _5791_/A sky130_fd_sc_hd__and3_2
X_4741_ _4741_/A VGND VGND VPWR VPWR _9117_/D sky130_fd_sc_hd__buf_1
XFILLER_14_380 VGND VGND VPWR VPWR sky130_fd_sc_hd__fill_2
X_7460_ _7438_/Y _7439_/X _7626_/C _7626_/D VGND VGND VPWR VPWR _7636_/B sky130_fd_sc_hd__a211o_4
X_4672_ _9085_/Q _4672_/A1 _4672_/S VGND VGND VPWR VPWR _4672_/X sky130_fd_sc_hd__mux2_2
XTAP_TAPCELL_ROW_60_1089 VGND VPWR sky130_fd_sc_hd__tapvpwrvgnd_1
X_6411_ _6467_/B _6411_/B VGND VGND VPWR VPWR _6412_/B sky130_fd_sc_hd__xnor2_2
X_7391_ _7392_/A _7392_/B VGND VGND VPWR VPWR _7393_/A sky130_fd_sc_hd__and2_2
XFILLER_128_772 VGND VGND VPWR VPWR sky130_fd_sc_hd__decap_3
X_9130_ _9334_/CLK _9130_/D fanout400/X VGND VGND VPWR VPWR _9130_/Q sky130_fd_sc_hd__dfrtp_2
X_6342_ _6342_/A _6342_/B _9315_/Q VGND VGND VPWR VPWR _6342_/Y sky130_fd_sc_hd__nor3b_2
XTAP_TAPCELL_ROW_116_1845 VGND VPWR sky130_fd_sc_hd__tapvpwrvgnd_1
XFILLER_115_444 VGND VGND VPWR VPWR sky130_fd_sc_hd__decap_3
X_9061_ _9345_/CLK _9061_/D fanout387/X VGND VGND VPWR VPWR _9061_/Q sky130_fd_sc_hd__dfrtp_2
XFILLER_115_455 VGND VGND VPWR VPWR sky130_fd_sc_hd__decap_3
X_6273_ _6522_/A _6519_/C _6519_/B VGND VGND VPWR VPWR _6385_/C sky130_fd_sc_hd__a21oi_2
XFILLER_103_617 VGND VGND VPWR VPWR sky130_fd_sc_hd__decap_3
X_8012_ _7656_/A _7880_/Y _8011_/X VGND VGND VPWR VPWR _8013_/B sky130_fd_sc_hd__o21a_2
XFILLER_102_116 VGND VGND VPWR VPWR sky130_fd_sc_hd__decap_3
X_5224_ _7676_/C _5224_/B VGND VGND VPWR VPWR _5224_/Y sky130_fd_sc_hd__xnor2_2
XFILLER_69_520 VGND VGND VPWR VPWR sky130_fd_sc_hd__decap_3
XFILLER_102_138 VGND VGND VPWR VPWR sky130_fd_sc_hd__fill_2
X_5155_ _9197_/Q _5043_/B _7114_/B VGND VGND VPWR VPWR _5155_/Y sky130_fd_sc_hd__a21oi_2
XFILLER_111_650 VGND VGND VPWR VPWR sky130_fd_sc_hd__fill_1
XFILLER_96_361 VGND VGND VPWR VPWR sky130_fd_sc_hd__decap_3
XFILLER_69_575 VGND VGND VPWR VPWR sky130_fd_sc_hd__decap_3
XFILLER_84_512 VGND VGND VPWR VPWR sky130_fd_sc_hd__decap_3
X_5086_ _5086_/A VGND VGND VPWR VPWR _5087_/B sky130_fd_sc_hd__clkbuf_1
XFILLER_56_225 VGND VGND VPWR VPWR sky130_fd_sc_hd__decap_3
XFILLER_110_182 VGND VGND VPWR VPWR sky130_fd_sc_hd__decap_3
XFILLER_84_556 VGND VGND VPWR VPWR sky130_fd_sc_hd__decap_3
X_8914_ _8914_/A VGND VGND VPWR VPWR _9299_/D sky130_fd_sc_hd__buf_1
XFILLER_84_589 VGND VGND VPWR VPWR sky130_fd_sc_hd__decap_3
XFILLER_71_206 VGND VGND VPWR VPWR sky130_fd_sc_hd__decap_3
XFILLER_71_228 VGND VGND VPWR VPWR sky130_fd_sc_hd__decap_3
XFILLER_112_47 VGND VGND VPWR VPWR sky130_fd_sc_hd__decap_3
X_8845_ _8845_/A VGND VGND VPWR VPWR _9266_/D sky130_fd_sc_hd__buf_1
XTAP_TAPCELL_ROW_127_1996 VGND VPWR sky130_fd_sc_hd__tapvpwrvgnd_1
XFILLER_80_751 VGND VGND VPWR VPWR sky130_fd_sc_hd__decap_3
XFILLER_24_144 VGND VGND VPWR VPWR sky130_fd_sc_hd__decap_3
XFILLER_52_464 VGND VGND VPWR VPWR sky130_fd_sc_hd__decap_3
X_8776_ _8780_/B _5718_/A _4544_/S VGND VGND VPWR VPWR _9233_/D sky130_fd_sc_hd__a21o_2
XFILLER_25_689 VGND VGND VPWR VPWR sky130_fd_sc_hd__decap_3
X_5988_ _9045_/Q _9109_/Q _5989_/S VGND VGND VPWR VPWR _5988_/X sky130_fd_sc_hd__mux2_2
XFILLER_24_177 VGND VGND VPWR VPWR sky130_fd_sc_hd__decap_3
XFILLER_40_637 VGND VGND VPWR VPWR sky130_fd_sc_hd__fill_1
X_7727_ _7157_/Y _7682_/A _7728_/A VGND VGND VPWR VPWR _7727_/X sky130_fd_sc_hd__a21o_2
X_4939_ _5990_/A _4935_/X _4936_/X _5612_/A _4938_/X VGND VGND VPWR VPWR _4940_/D
+ sky130_fd_sc_hd__a32o_2
X_7658_ _7518_/C _7549_/B _7857_/B VGND VGND VPWR VPWR _7658_/X sky130_fd_sc_hd__a21o_2
XFILLER_20_372 VGND VGND VPWR VPWR sky130_fd_sc_hd__fill_1
XFILLER_122_6 VGND VGND VPWR VPWR sky130_fd_sc_hd__decap_3
X_6609_ _9144_/Q _5126_/X _6606_/X _6607_/X _6608_/X VGND VGND VPWR VPWR _6612_/B
+ sky130_fd_sc_hd__a2111o_2
XFILLER_119_750 VGND VGND VPWR VPWR sky130_fd_sc_hd__decap_3
XTAP_TAPCELL_ROW_78_1328 VGND VPWR sky130_fd_sc_hd__tapvpwrvgnd_1
X_7589_ _7586_/X _7588_/X _7408_/A VGND VGND VPWR VPWR _7589_/X sky130_fd_sc_hd__a21o_2
XTAP_TAPCELL_ROW_78_1339 VGND VPWR sky130_fd_sc_hd__tapvpwrvgnd_1
XFILLER_125_208 VGND VGND VPWR VPWR sky130_fd_sc_hd__decap_3
XFILLER_4_516 VGND VGND VPWR VPWR sky130_fd_sc_hd__decap_3
X_9328_ _9344_/CLK _9328_/D load_slew380/X VGND VGND VPWR VPWR _9328_/Q sky130_fd_sc_hd__dfrtp_2
XFILLER_21_66 VGND VGND VPWR VPWR sky130_fd_sc_hd__fill_2
XFILLER_106_433 VGND VGND VPWR VPWR sky130_fd_sc_hd__decap_3
XTAP_TAPCELL_ROW_91_1506 VGND VPWR sky130_fd_sc_hd__tapvpwrvgnd_1
X_9259_ clkload3/A _9259_/D fanout369/X VGND VGND VPWR VPWR _9259_/Q sky130_fd_sc_hd__dfrtp_2
XFILLER_106_466 VGND VGND VPWR VPWR sky130_fd_sc_hd__fill_2
XFILLER_106_477 VGND VGND VPWR VPWR sky130_fd_sc_hd__decap_3
XFILLER_0_722 VGND VGND VPWR VPWR sky130_fd_sc_hd__decap_3
XFILLER_0_744 VGND VGND VPWR VPWR sky130_fd_sc_hd__decap_3
XFILLER_121_469 VGND VGND VPWR VPWR sky130_fd_sc_hd__decap_3
XFILLER_0_766 VGND VGND VPWR VPWR sky130_fd_sc_hd__decap_3
XTAP_TAPCELL_ROW_7_376 VGND VPWR sky130_fd_sc_hd__tapvpwrvgnd_1
XFILLER_94_309 VGND VGND VPWR VPWR sky130_fd_sc_hd__decap_3
XFILLER_47_203 VGND VGND VPWR VPWR sky130_fd_sc_hd__decap_3
XFILLER_87_383 VGND VGND VPWR VPWR sky130_fd_sc_hd__decap_3
XFILLER_75_534 VGND VGND VPWR VPWR sky130_fd_sc_hd__decap_3
XFILLER_47_225 VGND VGND VPWR VPWR sky130_fd_sc_hd__decap_3
XFILLER_75_567 VGND VGND VPWR VPWR sky130_fd_sc_hd__fill_2
XTAP_TAPCELL_ROW_89_1479 VGND VPWR sky130_fd_sc_hd__tapvpwrvgnd_1
XTAP_TAPCELL_ROW_46_905 VGND VPWR sky130_fd_sc_hd__tapvpwrvgnd_1
XFILLER_90_504 VGND VGND VPWR VPWR sky130_fd_sc_hd__decap_3
XFILLER_75_578 VGND VGND VPWR VPWR sky130_fd_sc_hd__decap_3
XFILLER_63_729 VGND VGND VPWR VPWR sky130_fd_sc_hd__decap_3
XFILLER_16_601 VGND VGND VPWR VPWR sky130_fd_sc_hd__decap_3
Xmax_cap42 _7652_/Y VGND VGND VPWR VPWR _7748_/S sky130_fd_sc_hd__buf_6
Xmax_cap53 _8571_/B VGND VGND VPWR VPWR _8649_/B sky130_fd_sc_hd__clkbuf_2
XFILLER_28_483 VGND VGND VPWR VPWR sky130_fd_sc_hd__fill_1
Xmax_cap64 _8476_/X VGND VGND VPWR VPWR _8755_/B sky130_fd_sc_hd__buf_2
XFILLER_90_559 VGND VGND VPWR VPWR sky130_fd_sc_hd__decap_3
XFILLER_16_645 VGND VGND VPWR VPWR sky130_fd_sc_hd__decap_3
Xmax_cap75 _6159_/B VGND VGND VPWR VPWR _6157_/B sky130_fd_sc_hd__buf_6
XFILLER_55_291 VGND VGND VPWR VPWR sky130_fd_sc_hd__decap_3
Xmax_cap86 _8216_/A VGND VGND VPWR VPWR _8313_/B sky130_fd_sc_hd__buf_4
XFILLER_43_442 VGND VGND VPWR VPWR sky130_fd_sc_hd__decap_3
Xmax_cap97 _6209_/X VGND VGND VPWR VPWR _6366_/A sky130_fd_sc_hd__buf_2
XFILLER_71_773 VGND VGND VPWR VPWR sky130_fd_sc_hd__decap_3
XFILLER_43_464 VGND VGND VPWR VPWR sky130_fd_sc_hd__decap_3
XFILLER_31_604 VGND VGND VPWR VPWR sky130_fd_sc_hd__decap_3
XFILLER_30_125 VGND VGND VPWR VPWR sky130_fd_sc_hd__decap_3
XFILLER_31_659 VGND VGND VPWR VPWR sky130_fd_sc_hd__decap_3
XTAP_TAPCELL_ROW_100_1635 VGND VPWR sky130_fd_sc_hd__tapvpwrvgnd_1
XFILLER_129_503 VGND VGND VPWR VPWR sky130_fd_sc_hd__fill_1
XFILLER_7_24 VGND VGND VPWR VPWR sky130_fd_sc_hd__decap_3
XFILLER_129_547 VGND VGND VPWR VPWR sky130_fd_sc_hd__decap_3
Xwire230 wire230/A VGND VGND VPWR VPWR result_out[13] sky130_fd_sc_hd__buf_4
XFILLER_117_709 VGND VGND VPWR VPWR sky130_fd_sc_hd__decap_3
XFILLER_7_343 VGND VGND VPWR VPWR sky130_fd_sc_hd__decap_3
XFILLER_7_57 VGND VGND VPWR VPWR sky130_fd_sc_hd__decap_3
XFILLER_7_354 VGND VGND VPWR VPWR sky130_fd_sc_hd__fill_1
XFILLER_125_753 VGND VGND VPWR VPWR sky130_fd_sc_hd__decap_3
XFILLER_98_626 VGND VGND VPWR VPWR sky130_fd_sc_hd__decap_3
XFILLER_98_648 VGND VGND VPWR VPWR sky130_fd_sc_hd__decap_3
XFILLER_97_125 VGND VGND VPWR VPWR sky130_fd_sc_hd__fill_1
XFILLER_97_147 VGND VGND VPWR VPWR sky130_fd_sc_hd__decap_3
Xload_slew257 _8174_/A VGND VGND VPWR VPWR _8778_/A sky130_fd_sc_hd__buf_2
XTAP_TAPCELL_ROW_111_1775 VGND VPWR sky130_fd_sc_hd__tapvpwrvgnd_1
XFILLER_97_169 VGND VGND VPWR VPWR sky130_fd_sc_hd__decap_3
XTAP_TAPCELL_ROW_111_1786 VGND VPWR sky130_fd_sc_hd__tapvpwrvgnd_1
XFILLER_78_361 VGND VGND VPWR VPWR sky130_fd_sc_hd__decap_3
Xload_slew279 _8034_/A VGND VGND VPWR VPWR _7702_/A sky130_fd_sc_hd__clkbuf_4
XFILLER_38_225 VGND VGND VPWR VPWR sky130_fd_sc_hd__decap_3
XFILLER_120_480 VGND VGND VPWR VPWR sky130_fd_sc_hd__fill_1
XFILLER_16_3 VGND VGND VPWR VPWR sky130_fd_sc_hd__decap_3
XFILLER_93_342 VGND VGND VPWR VPWR sky130_fd_sc_hd__fill_1
X_6960_ _6960_/A _6960_/B VGND VGND VPWR VPWR _6961_/B sky130_fd_sc_hd__nor2_2
XFILLER_66_589 VGND VGND VPWR VPWR sky130_fd_sc_hd__decap_3
XFILLER_54_729 VGND VGND VPWR VPWR sky130_fd_sc_hd__decap_3
XFILLER_19_461 VGND VGND VPWR VPWR sky130_fd_sc_hd__decap_3
XFILLER_93_386 VGND VGND VPWR VPWR sky130_fd_sc_hd__decap_3
XFILLER_81_537 VGND VGND VPWR VPWR sky130_fd_sc_hd__decap_3
XFILLER_53_228 VGND VGND VPWR VPWR sky130_fd_sc_hd__fill_1
X_5911_ _5911_/A _5911_/B _5911_/C VGND VGND VPWR VPWR _5912_/B sky130_fd_sc_hd__or3_4
X_6891_ _6891_/A _6891_/B VGND VGND VPWR VPWR _6892_/B sky130_fd_sc_hd__xnor2_2
XFILLER_81_559 VGND VGND VPWR VPWR sky130_fd_sc_hd__fill_1
XFILLER_46_291 VGND VGND VPWR VPWR sky130_fd_sc_hd__decap_3
XFILLER_34_442 VGND VGND VPWR VPWR sky130_fd_sc_hd__decap_3
X_8630_ _8649_/B _8623_/Y _8624_/X _8681_/A _8629_/X VGND VGND VPWR VPWR _8631_/B
+ sky130_fd_sc_hd__a221o_2
X_5842_ _5842_/A _5842_/B VGND VGND VPWR VPWR _5843_/B sky130_fd_sc_hd__xor2_2
XTAP_TAPCELL_ROW_62_1118 VGND VPWR sky130_fd_sc_hd__tapvpwrvgnd_1
XFILLER_34_486 VGND VGND VPWR VPWR sky130_fd_sc_hd__decap_3
XFILLER_21_103 VGND VGND VPWR VPWR sky130_fd_sc_hd__decap_3
XFILLER_34_497 VGND VGND VPWR VPWR sky130_fd_sc_hd__decap_3
XFILLER_22_637 VGND VGND VPWR VPWR sky130_fd_sc_hd__decap_3
XFILLER_22_648 VGND VGND VPWR VPWR sky130_fd_sc_hd__fill_1
X_8561_ _8562_/A _8557_/B wire61/X _9225_/Q VGND VGND VPWR VPWR _8561_/X sky130_fd_sc_hd__a211o_2
XFILLER_21_125 VGND VGND VPWR VPWR sky130_fd_sc_hd__decap_3
X_5773_ _5773_/A _5773_/B _5773_/C VGND VGND VPWR VPWR _5773_/X sky130_fd_sc_hd__and3_4
X_7512_ _7508_/A _7262_/X _7509_/X _7264_/X _7511_/X VGND VGND VPWR VPWR _7512_/Y
+ sky130_fd_sc_hd__o221ai_4
X_4724_ _4724_/A VGND VGND VPWR VPWR _9109_/D sky130_fd_sc_hd__buf_1
XFILLER_21_169 VGND VGND VPWR VPWR sky130_fd_sc_hd__decap_3
X_8492_ _8562_/A _8492_/B VGND VGND VPWR VPWR _8493_/B sky130_fd_sc_hd__xnor2_2
Xrebuffer429 _5473_/D VGND VGND VPWR VPWR _5386_/D sky130_fd_sc_hd__buf_6
XFILLER_30_692 VGND VGND VPWR VPWR sky130_fd_sc_hd__decap_3
X_7443_ _7443_/A _7443_/B VGND VGND VPWR VPWR _7443_/Y sky130_fd_sc_hd__nand2_2
X_4655_ _4655_/A VGND VGND VPWR VPWR _9076_/D sky130_fd_sc_hd__buf_1
Xhold800 _4888_/X VGND VGND VPWR VPWR _9184_/D sky130_fd_sc_hd__dlygate4sd3_1
XFILLER_116_720 VGND VGND VPWR VPWR sky130_fd_sc_hd__decap_3
X_7374_ _7374_/A _7374_/B VGND VGND VPWR VPWR _7385_/A sky130_fd_sc_hd__or2_2
Xhold811 _4900_/X VGND VGND VPWR VPWR _9190_/D sky130_fd_sc_hd__dlygate4sd3_1
X_4586_ _4586_/A VGND VGND VPWR VPWR _9044_/D sky130_fd_sc_hd__buf_1
Xhold822 _5335_/Y VGND VGND VPWR VPWR _5337_/A sky130_fd_sc_hd__dlygate4sd3_1
Xhold833 _9303_/Q VGND VGND VPWR VPWR hold833/X sky130_fd_sc_hd__dlygate4sd3_1
X_9113_ _9228_/CLK _9113_/D wire406/A VGND VGND VPWR VPWR _9113_/Q sky130_fd_sc_hd__dfrtp_2
X_6325_ _6325_/A _6325_/B _6325_/C _6325_/D VGND VGND VPWR VPWR _6363_/B sky130_fd_sc_hd__nand4_2
Xhold844 _4809_/X VGND VGND VPWR VPWR _4810_/A sky130_fd_sc_hd__dlygate4sd3_1
Xhold855 _8871_/X VGND VGND VPWR VPWR _8872_/A sky130_fd_sc_hd__dlygate4sd3_1
Xhold866 _4611_/X VGND VGND VPWR VPWR _4612_/A sky130_fd_sc_hd__dlygate4sd3_1
XFILLER_107_36 VGND VGND VPWR VPWR sky130_fd_sc_hd__decap_3
Xhold877 _4650_/X VGND VGND VPWR VPWR _4651_/A sky130_fd_sc_hd__dlygate4sd3_1
XFILLER_130_200 VGND VGND VPWR VPWR sky130_fd_sc_hd__decap_3
Xhold888 _9038_/Q VGND VGND VPWR VPWR hold888/X sky130_fd_sc_hd__dlygate4sd3_1
X_9044_ _9345_/CLK _9044_/D load_slew380/X VGND VGND VPWR VPWR _9044_/Q sky130_fd_sc_hd__dfrtp_2
XFILLER_89_648 VGND VGND VPWR VPWR sky130_fd_sc_hd__decap_3
XFILLER_103_436 VGND VGND VPWR VPWR sky130_fd_sc_hd__decap_3
X_6256_ _7480_/C _6253_/B _6256_/B1 _9207_/Q VGND VGND VPWR VPWR _6256_/X sky130_fd_sc_hd__o211a_2
Xhold899 _4861_/X VGND VGND VPWR VPWR _4862_/A sky130_fd_sc_hd__dlygate4sd3_1
XTAP_TAPCELL_ROW_73_1269 VGND VPWR sky130_fd_sc_hd__tapvpwrvgnd_1
XFILLER_103_458 VGND VGND VPWR VPWR sky130_fd_sc_hd__decap_3
X_5207_ _5255_/A _5255_/B VGND VGND VPWR VPWR _5208_/B sky130_fd_sc_hd__xnor2_2
X_6187_ _6326_/C _6326_/B _6188_/A VGND VGND VPWR VPWR _6193_/B sky130_fd_sc_hd__a21o_4
XFILLER_130_277 VGND VGND VPWR VPWR sky130_fd_sc_hd__decap_3
XTAP_TAPCELL_ROW_4_335 VGND VPWR sky130_fd_sc_hd__tapvpwrvgnd_1
XFILLER_57_523 VGND VGND VPWR VPWR sky130_fd_sc_hd__decap_3
X_5138_ _6976_/C VGND VGND VPWR VPWR _5138_/X sky130_fd_sc_hd__clkbuf_4
XFILLER_123_24 VGND VGND VPWR VPWR sky130_fd_sc_hd__decap_3
XFILLER_111_480 VGND VGND VPWR VPWR sky130_fd_sc_hd__decap_3
XFILLER_29_236 VGND VGND VPWR VPWR sky130_fd_sc_hd__decap_3
XFILLER_123_57 VGND VGND VPWR VPWR sky130_fd_sc_hd__decap_3
XFILLER_72_504 VGND VGND VPWR VPWR sky130_fd_sc_hd__fill_1
X_5069_ _9084_/Q _4955_/B _5068_/X _5464_/A1 VGND VGND VPWR VPWR _5069_/X sky130_fd_sc_hd__a22o_2
XFILLER_72_515 VGND VGND VPWR VPWR sky130_fd_sc_hd__decap_3
XFILLER_45_729 VGND VGND VPWR VPWR sky130_fd_sc_hd__decap_3
XFILLER_44_206 VGND VGND VPWR VPWR sky130_fd_sc_hd__decap_3
XFILLER_25_431 VGND VGND VPWR VPWR sky130_fd_sc_hd__decap_3
XFILLER_16_44 VGND VGND VPWR VPWR sky130_fd_sc_hd__decap_3
XFILLER_53_773 VGND VGND VPWR VPWR sky130_fd_sc_hd__decap_3
X_8828_ _8828_/A VGND VGND VPWR VPWR _9258_/D sky130_fd_sc_hd__buf_1
XFILLER_25_475 VGND VGND VPWR VPWR sky130_fd_sc_hd__decap_3
XFILLER_80_570 VGND VGND VPWR VPWR sky130_fd_sc_hd__decap_3
XFILLER_52_261 VGND VGND VPWR VPWR sky130_fd_sc_hd__fill_2
XFILLER_16_77 VGND VGND VPWR VPWR sky130_fd_sc_hd__decap_3
XFILLER_40_412 VGND VGND VPWR VPWR sky130_fd_sc_hd__decap_3
XFILLER_16_88 VGND VGND VPWR VPWR sky130_fd_sc_hd__decap_3
X_8759_ _8741_/A _8728_/S _8755_/B _8758_/Y VGND VGND VPWR VPWR _8760_/B sky130_fd_sc_hd__a31o_2
XFILLER_12_147 VGND VGND VPWR VPWR sky130_fd_sc_hd__decap_3
XTAP_TAPCELL_ROW_51_974 VGND VPWR sky130_fd_sc_hd__tapvpwrvgnd_1
XFILLER_32_32 VGND VGND VPWR VPWR sky130_fd_sc_hd__decap_3
XFILLER_32_65 VGND VGND VPWR VPWR sky130_fd_sc_hd__decap_3
XFILLER_120_3 VGND VGND VPWR VPWR sky130_fd_sc_hd__decap_3
XFILLER_20_180 VGND VGND VPWR VPWR sky130_fd_sc_hd__decap_3
XFILLER_126_539 VGND VGND VPWR VPWR sky130_fd_sc_hd__decap_3
XFILLER_4_368 VGND VGND VPWR VPWR sky130_fd_sc_hd__decap_3
XFILLER_122_701 VGND VGND VPWR VPWR sky130_fd_sc_hd__fill_2
XFILLER_122_712 VGND VGND VPWR VPWR sky130_fd_sc_hd__decap_3
XFILLER_106_274 VGND VGND VPWR VPWR sky130_fd_sc_hd__decap_3
XFILLER_121_211 VGND VGND VPWR VPWR sky130_fd_sc_hd__decap_3
XFILLER_122_745 VGND VGND VPWR VPWR sky130_fd_sc_hd__decap_3
XFILLER_121_244 VGND VGND VPWR VPWR sky130_fd_sc_hd__decap_3
XFILLER_95_629 VGND VGND VPWR VPWR sky130_fd_sc_hd__decap_3
XFILLER_121_277 VGND VGND VPWR VPWR sky130_fd_sc_hd__decap_3
XFILLER_48_512 VGND VGND VPWR VPWR sky130_fd_sc_hd__decap_3
XFILLER_0_585 VGND VGND VPWR VPWR sky130_fd_sc_hd__decap_3
XFILLER_121_299 VGND VGND VPWR VPWR sky130_fd_sc_hd__fill_1
XFILLER_102_480 VGND VGND VPWR VPWR sky130_fd_sc_hd__decap_3
XFILLER_57_51 VGND VGND VPWR VPWR sky130_fd_sc_hd__decap_3
XFILLER_48_545 VGND VGND VPWR VPWR sky130_fd_sc_hd__fill_2
XFILLER_48_578 VGND VGND VPWR VPWR sky130_fd_sc_hd__decap_3
XFILLER_36_718 VGND VGND VPWR VPWR sky130_fd_sc_hd__decap_3
XFILLER_48_589 VGND VGND VPWR VPWR sky130_fd_sc_hd__decap_3
XFILLER_90_312 VGND VGND VPWR VPWR sky130_fd_sc_hd__decap_3
XFILLER_75_397 VGND VGND VPWR VPWR sky130_fd_sc_hd__decap_3
XFILLER_35_228 VGND VGND VPWR VPWR sky130_fd_sc_hd__decap_3
XFILLER_113_90 VGND VGND VPWR VPWR sky130_fd_sc_hd__decap_3
XFILLER_44_751 VGND VGND VPWR VPWR sky130_fd_sc_hd__decap_3
XFILLER_16_475 VGND VGND VPWR VPWR sky130_fd_sc_hd__fill_1
XFILLER_31_467 VGND VGND VPWR VPWR sky130_fd_sc_hd__decap_3
XFILLER_8_630 VGND VGND VPWR VPWR sky130_fd_sc_hd__fill_1
XFILLER_12_692 VGND VGND VPWR VPWR sky130_fd_sc_hd__decap_3
XFILLER_117_517 VGND VGND VPWR VPWR sky130_fd_sc_hd__decap_3
XFILLER_7_195 VGND VGND VPWR VPWR sky130_fd_sc_hd__fill_2
XTAP_TAPCELL_ROW_113_1804 VGND VPWR sky130_fd_sc_hd__tapvpwrvgnd_1
XFILLER_125_550 VGND VGND VPWR VPWR sky130_fd_sc_hd__decap_3
XFILLER_125_561 VGND VGND VPWR VPWR sky130_fd_sc_hd__decap_3
XTAP_TAPCELL_ROW_59_1080 VGND VPWR sky130_fd_sc_hd__tapvpwrvgnd_1
XFILLER_113_712 VGND VGND VPWR VPWR sky130_fd_sc_hd__fill_2
X_6110_ _5231_/Y _6805_/A _6113_/A VGND VGND VPWR VPWR _6110_/X sky130_fd_sc_hd__mux2_2
X_7090_ _7090_/A _7090_/B _7090_/C _7090_/D VGND VGND VPWR VPWR _7090_/Y sky130_fd_sc_hd__nand4_2
XFILLER_98_91 VGND VGND VPWR VPWR sky130_fd_sc_hd__decap_3
XFILLER_3_390 VGND VGND VPWR VPWR sky130_fd_sc_hd__fill_2
X_6041_ _6041_/A _6041_/B VGND VGND VPWR VPWR _6042_/B sky130_fd_sc_hd__xor2_4
XFILLER_100_406 VGND VGND VPWR VPWR sky130_fd_sc_hd__fill_2
XFILLER_100_417 VGND VGND VPWR VPWR sky130_fd_sc_hd__decap_3
XFILLER_79_692 VGND VGND VPWR VPWR sky130_fd_sc_hd__fill_1
XFILLER_66_342 VGND VGND VPWR VPWR sky130_fd_sc_hd__decap_3
XFILLER_54_504 VGND VGND VPWR VPWR sky130_fd_sc_hd__decap_3
XFILLER_39_578 VGND VGND VPWR VPWR sky130_fd_sc_hd__fill_1
XFILLER_27_718 VGND VGND VPWR VPWR sky130_fd_sc_hd__decap_3
XFILLER_94_673 VGND VGND VPWR VPWR sky130_fd_sc_hd__decap_3
X_7992_ _7898_/X _7991_/Y _8117_/S VGND VGND VPWR VPWR _7993_/A sky130_fd_sc_hd__mux2_2
XFILLER_66_386 VGND VGND VPWR VPWR sky130_fd_sc_hd__decap_3
XFILLER_54_526 VGND VGND VPWR VPWR sky130_fd_sc_hd__decap_3
X_6943_ _9211_/Q _7090_/A _7924_/B VGND VGND VPWR VPWR _6946_/A sky130_fd_sc_hd__and3_2
XFILLER_54_559 VGND VGND VPWR VPWR sky130_fd_sc_hd__decap_3
XFILLER_35_751 VGND VGND VPWR VPWR sky130_fd_sc_hd__decap_3
XTAP_TAPCELL_ROW_124_1955 VGND VPWR sky130_fd_sc_hd__tapvpwrvgnd_1
XTAP_TAPCELL_ROW_37_779 VGND VPWR sky130_fd_sc_hd__tapvpwrvgnd_1
X_6874_ _7522_/A _7520_/A _6873_/Y VGND VGND VPWR VPWR _6874_/X sky130_fd_sc_hd__a21o_2
X_8613_ _9227_/Q _9226_/Q _8398_/B _8398_/A VGND VGND VPWR VPWR _8613_/X sky130_fd_sc_hd__a31o_2
XFILLER_62_592 VGND VGND VPWR VPWR sky130_fd_sc_hd__decap_3
XFILLER_50_732 VGND VGND VPWR VPWR sky130_fd_sc_hd__decap_3
X_5825_ _5823_/Y _6042_/A _5105_/Y _7951_/A _7952_/A VGND VGND VPWR VPWR _6057_/A
+ sky130_fd_sc_hd__a2111o_2
XFILLER_34_294 VGND VGND VPWR VPWR sky130_fd_sc_hd__decap_3
XFILLER_22_434 VGND VGND VPWR VPWR sky130_fd_sc_hd__decap_3
XFILLER_50_754 VGND VGND VPWR VPWR sky130_fd_sc_hd__fill_2
XFILLER_10_618 VGND VGND VPWR VPWR sky130_fd_sc_hd__fill_2
X_8544_ _8544_/A VGND VGND VPWR VPWR _8560_/A sky130_fd_sc_hd__inv_2
X_5756_ _6765_/A _5754_/Y _5755_/Y VGND VGND VPWR VPWR _5756_/X sky130_fd_sc_hd__a21o_2
X_4707_ _4707_/A VGND VGND VPWR VPWR _9101_/D sky130_fd_sc_hd__buf_1
X_8475_ _9222_/Q _8443_/B _8474_/Y _9221_/Q VGND VGND VPWR VPWR _8475_/X sky130_fd_sc_hd__a211o_2
X_5687_ _5968_/S _5687_/B VGND VGND VPWR VPWR _5687_/Y sky130_fd_sc_hd__nor2_2
XFILLER_108_539 VGND VGND VPWR VPWR sky130_fd_sc_hd__decap_3
X_7426_ _7426_/A _7426_/B VGND VGND VPWR VPWR _7434_/A sky130_fd_sc_hd__xnor2_2
X_4638_ _9069_/Q hold870/X _4650_/S VGND VGND VPWR VPWR _4638_/X sky130_fd_sc_hd__mux2_2
XFILLER_118_24 VGND VGND VPWR VPWR sky130_fd_sc_hd__decap_3
XFILLER_118_35 VGND VGND VPWR VPWR sky130_fd_sc_hd__decap_3
XTAP_TAPCELL_ROW_9_405 VGND VPWR sky130_fd_sc_hd__tapvpwrvgnd_1
XFILLER_116_550 VGND VGND VPWR VPWR sky130_fd_sc_hd__decap_3
XFILLER_104_701 VGND VGND VPWR VPWR sky130_fd_sc_hd__decap_3
X_7357_ _7357_/A _7357_/B _7357_/C VGND VGND VPWR VPWR _7357_/Y sky130_fd_sc_hd__nand3_2
XFILLER_118_68 VGND VGND VPWR VPWR sky130_fd_sc_hd__decap_3
X_4569_ _9036_/Q hold825/X _4587_/S VGND VGND VPWR VPWR _4569_/X sky130_fd_sc_hd__mux2_2
X_6308_ _6575_/B _6308_/B VGND VGND VPWR VPWR _6309_/B sky130_fd_sc_hd__xnor2_2
X_7288_ _7288_/A1 _7288_/A2 _7288_/A3 _7287_/Y VGND VGND VPWR VPWR _7394_/A sky130_fd_sc_hd__o31ai_2
XFILLER_103_233 VGND VGND VPWR VPWR sky130_fd_sc_hd__decap_3
X_9027_ _9343_/CLK _9027_/D fanout395/X VGND VGND VPWR VPWR _9027_/Q sky130_fd_sc_hd__dfrtp_2
XFILLER_49_309 VGND VGND VPWR VPWR sky130_fd_sc_hd__fill_1
X_6239_ _6239_/A _6239_/B _6239_/C VGND VGND VPWR VPWR _6240_/D sky130_fd_sc_hd__nand3_2
XFILLER_77_629 VGND VGND VPWR VPWR sky130_fd_sc_hd__fill_2
XFILLER_89_489 VGND VGND VPWR VPWR sky130_fd_sc_hd__decap_3
XFILLER_103_277 VGND VGND VPWR VPWR sky130_fd_sc_hd__decap_3
XFILLER_76_128 VGND VGND VPWR VPWR sky130_fd_sc_hd__fill_2
XFILLER_76_139 VGND VGND VPWR VPWR sky130_fd_sc_hd__fill_1
XFILLER_85_651 VGND VGND VPWR VPWR sky130_fd_sc_hd__decap_3
XFILLER_18_707 VGND VGND VPWR VPWR sky130_fd_sc_hd__decap_3
XFILLER_27_32 VGND VGND VPWR VPWR sky130_fd_sc_hd__fill_2
XFILLER_85_695 VGND VGND VPWR VPWR sky130_fd_sc_hd__decap_3
XTAP_TAPCELL_ROW_86_1438 VGND VPWR sky130_fd_sc_hd__tapvpwrvgnd_1
XFILLER_84_172 VGND VGND VPWR VPWR sky130_fd_sc_hd__fill_2
XFILLER_45_537 VGND VGND VPWR VPWR sky130_fd_sc_hd__decap_3
XTAP_TAPCELL_ROW_86_1449 VGND VPWR sky130_fd_sc_hd__tapvpwrvgnd_1
XFILLER_45_559 VGND VGND VPWR VPWR sky130_fd_sc_hd__fill_1
XFILLER_27_76 VGND VGND VPWR VPWR sky130_fd_sc_hd__decap_3
XFILLER_41_721 VGND VGND VPWR VPWR sky130_fd_sc_hd__decap_3
XFILLER_53_592 VGND VGND VPWR VPWR sky130_fd_sc_hd__decap_3
XFILLER_43_31 VGND VGND VPWR VPWR sky130_fd_sc_hd__decap_3
XFILLER_25_294 VGND VGND VPWR VPWR sky130_fd_sc_hd__decap_3
XFILLER_43_53 VGND VGND VPWR VPWR sky130_fd_sc_hd__decap_3
XFILLER_40_231 VGND VGND VPWR VPWR sky130_fd_sc_hd__decap_3
XFILLER_13_456 VGND VGND VPWR VPWR sky130_fd_sc_hd__decap_3
XFILLER_9_405 VGND VGND VPWR VPWR sky130_fd_sc_hd__decap_3
XFILLER_40_253 VGND VGND VPWR VPWR sky130_fd_sc_hd__decap_3
XFILLER_43_75 VGND VGND VPWR VPWR sky130_fd_sc_hd__decap_3
XFILLER_9_449 VGND VGND VPWR VPWR sky130_fd_sc_hd__decap_3
XFILLER_126_347 VGND VGND VPWR VPWR sky130_fd_sc_hd__decap_3
XTAP_TAPCELL_ROW_97_1589 VGND VPWR sky130_fd_sc_hd__tapvpwrvgnd_1
XFILLER_126_358 VGND VGND VPWR VPWR sky130_fd_sc_hd__decap_3
XFILLER_4_132 VGND VGND VPWR VPWR sky130_fd_sc_hd__decap_3
XFILLER_107_561 VGND VGND VPWR VPWR sky130_fd_sc_hd__decap_3
XFILLER_4_154 VGND VGND VPWR VPWR sky130_fd_sc_hd__decap_3
XFILLER_5_688 VGND VGND VPWR VPWR sky130_fd_sc_hd__decap_3
XFILLER_107_594 VGND VGND VPWR VPWR sky130_fd_sc_hd__decap_3
XFILLER_4_47 VGND VGND VPWR VPWR sky130_fd_sc_hd__decap_3
XFILLER_122_542 VGND VGND VPWR VPWR sky130_fd_sc_hd__decap_3
XFILLER_110_704 VGND VGND VPWR VPWR sky130_fd_sc_hd__decap_3
XFILLER_110_715 VGND VGND VPWR VPWR sky130_fd_sc_hd__decap_3
XTAP_TAPCELL_ROW_128_2011 VGND VPWR sky130_fd_sc_hd__tapvpwrvgnd_1
XFILLER_110_737 VGND VGND VPWR VPWR sky130_fd_sc_hd__fill_1
XFILLER_0_371 VGND VGND VPWR VPWR sky130_fd_sc_hd__decap_3
XFILLER_67_139 VGND VGND VPWR VPWR sky130_fd_sc_hd__decap_3
XFILLER_76_651 VGND VGND VPWR VPWR sky130_fd_sc_hd__fill_2
XFILLER_36_526 VGND VGND VPWR VPWR sky130_fd_sc_hd__decap_3
XFILLER_75_183 VGND VGND VPWR VPWR sky130_fd_sc_hd__decap_3
XFILLER_84_71 VGND VGND VPWR VPWR sky130_fd_sc_hd__fill_2
XFILLER_91_665 VGND VGND VPWR VPWR sky130_fd_sc_hd__decap_3
XFILLER_84_93 VGND VGND VPWR VPWR sky130_fd_sc_hd__decap_3
XFILLER_91_676 VGND VGND VPWR VPWR sky130_fd_sc_hd__fill_1
XFILLER_17_762 VGND VGND VPWR VPWR sky130_fd_sc_hd__decap_3
XFILLER_63_389 VGND VGND VPWR VPWR sky130_fd_sc_hd__decap_3
XFILLER_16_250 VGND VGND VPWR VPWR sky130_fd_sc_hd__fill_2
XTAP_TAPCELL_ROW_34_738 VGND VPWR sky130_fd_sc_hd__tapvpwrvgnd_1
XFILLER_32_732 VGND VGND VPWR VPWR sky130_fd_sc_hd__decap_3
XFILLER_32_754 VGND VGND VPWR VPWR sky130_fd_sc_hd__fill_2
XFILLER_32_765 VGND VGND VPWR VPWR sky130_fd_sc_hd__decap_3
XFILLER_31_242 VGND VGND VPWR VPWR sky130_fd_sc_hd__decap_3
X_5610_ _9204_/Q VGND VGND VPWR VPWR _5753_/A sky130_fd_sc_hd__inv_2
X_6590_ _6591_/A _6708_/A _6708_/B VGND VGND VPWR VPWR _6705_/B sky130_fd_sc_hd__nand3_2
XFILLER_83_3 VGND VGND VPWR VPWR sky130_fd_sc_hd__decap_3
XTAP_TAPCELL_ROW_14_473 VGND VPWR sky130_fd_sc_hd__tapvpwrvgnd_1
X_5541_ _6414_/A _5790_/A VGND VGND VPWR VPWR _5674_/B sky130_fd_sc_hd__nand2_2
XFILLER_129_152 VGND VGND VPWR VPWR sky130_fd_sc_hd__decap_3
X_8260_ _9221_/Q _8260_/B VGND VGND VPWR VPWR _8367_/A sky130_fd_sc_hd__xnor2_2
X_5472_ _5110_/Y _5470_/X _5471_/X _4515_/A VGND VGND VPWR VPWR _5473_/A sky130_fd_sc_hd__a22o_2
XFILLER_129_196 VGND VGND VPWR VPWR sky130_fd_sc_hd__decap_3
X_7211_ _7212_/A _7212_/B _6857_/B VGND VGND VPWR VPWR _7211_/X sky130_fd_sc_hd__a21o_2
X_8191_ _8109_/A _8192_/A2 _8108_/A VGND VGND VPWR VPWR _8191_/X sky130_fd_sc_hd__a21o_2
XFILLER_99_732 VGND VGND VPWR VPWR sky130_fd_sc_hd__fill_1
X_7142_ _7274_/B _7272_/B _7142_/C VGND VGND VPWR VPWR _7142_/X sky130_fd_sc_hd__and3b_2
XFILLER_125_391 VGND VGND VPWR VPWR sky130_fd_sc_hd__fill_1
XTAP_TAPCELL_ROW_70_1228 VGND VPWR sky130_fd_sc_hd__tapvpwrvgnd_1
XFILLER_98_264 VGND VGND VPWR VPWR sky130_fd_sc_hd__fill_2
X_7073_ _7073_/A _7073_/B VGND VGND VPWR VPWR _7300_/A sky130_fd_sc_hd__or2_4
XFILLER_59_629 VGND VGND VPWR VPWR sky130_fd_sc_hd__decap_3
XFILLER_100_225 VGND VGND VPWR VPWR sky130_fd_sc_hd__decap_3
X_6024_ _5843_/A _5842_/B _5842_/A VGND VGND VPWR VPWR _6024_/X sky130_fd_sc_hd__o21a_2
XFILLER_86_448 VGND VGND VPWR VPWR sky130_fd_sc_hd__decap_3
XFILLER_39_353 VGND VGND VPWR VPWR sky130_fd_sc_hd__decap_3
XFILLER_67_673 VGND VGND VPWR VPWR sky130_fd_sc_hd__decap_3
XFILLER_94_470 VGND VGND VPWR VPWR sky130_fd_sc_hd__decap_3
XFILLER_39_375 VGND VGND VPWR VPWR sky130_fd_sc_hd__decap_3
XFILLER_27_526 VGND VGND VPWR VPWR sky130_fd_sc_hd__decap_3
XFILLER_54_323 VGND VGND VPWR VPWR sky130_fd_sc_hd__decap_3
XFILLER_94_492 VGND VGND VPWR VPWR sky130_fd_sc_hd__decap_3
XFILLER_27_559 VGND VGND VPWR VPWR sky130_fd_sc_hd__fill_1
X_7975_ _7799_/A _8216_/A _7974_/Y VGND VGND VPWR VPWR _7976_/B sky130_fd_sc_hd__a21oi_2
XFILLER_82_654 VGND VGND VPWR VPWR sky130_fd_sc_hd__decap_3
XFILLER_42_507 VGND VGND VPWR VPWR sky130_fd_sc_hd__decap_3
X_6926_ _6926_/A _6926_/B VGND VGND VPWR VPWR _6926_/Y sky130_fd_sc_hd__nand2_2
XFILLER_35_570 VGND VGND VPWR VPWR sky130_fd_sc_hd__decap_3
XFILLER_23_732 VGND VGND VPWR VPWR sky130_fd_sc_hd__decap_3
XFILLER_120_47 VGND VGND VPWR VPWR sky130_fd_sc_hd__decap_3
X_6857_ input6/X _6857_/B VGND VGND VPWR VPWR _6857_/Y sky130_fd_sc_hd__xnor2_2
XFILLER_50_540 VGND VGND VPWR VPWR sky130_fd_sc_hd__decap_3
XFILLER_23_765 VGND VGND VPWR VPWR sky130_fd_sc_hd__decap_3
XFILLER_80_29 VGND VGND VPWR VPWR sky130_fd_sc_hd__decap_3
XFILLER_22_253 VGND VGND VPWR VPWR sky130_fd_sc_hd__decap_3
X_5808_ _5808_/A _5808_/B VGND VGND VPWR VPWR _5809_/B sky130_fd_sc_hd__xor2_2
XTAP_TAPCELL_ROW_81_1379 VGND VPWR sky130_fd_sc_hd__tapvpwrvgnd_1
XFILLER_50_584 VGND VGND VPWR VPWR sky130_fd_sc_hd__decap_3
XFILLER_13_12 VGND VGND VPWR VPWR sky130_fd_sc_hd__decap_3
X_6788_ _6788_/A _6788_/B VGND VGND VPWR VPWR _6856_/A sky130_fd_sc_hd__nand2_2
XFILLER_129_12 VGND VGND VPWR VPWR sky130_fd_sc_hd__decap_3
X_8527_ wire67/X _8526_/Y _8493_/A _9224_/Q VGND VGND VPWR VPWR _8527_/X sky130_fd_sc_hd__o211a_2
X_5739_ _9043_/Q _9107_/Q _5739_/S VGND VGND VPWR VPWR _5739_/X sky130_fd_sc_hd__mux2_2
XFILLER_6_408 VGND VGND VPWR VPWR sky130_fd_sc_hd__decap_3
XFILLER_129_45 VGND VGND VPWR VPWR sky130_fd_sc_hd__decap_3
X_8458_ _8459_/A _8459_/B _8459_/C VGND VGND VPWR VPWR _8458_/X sky130_fd_sc_hd__a21o_2
XFILLER_129_78 VGND VGND VPWR VPWR sky130_fd_sc_hd__decap_3
X_7409_ _7342_/A _7342_/B _7408_/Y VGND VGND VPWR VPWR _7409_/X sky130_fd_sc_hd__a21o_2
X_8389_ _8446_/A VGND VGND VPWR VPWR _8389_/Y sky130_fd_sc_hd__inv_2
XFILLER_123_317 VGND VGND VPWR VPWR sky130_fd_sc_hd__fill_1
XFILLER_2_625 VGND VGND VPWR VPWR sky130_fd_sc_hd__decap_3
XFILLER_1_113 VGND VGND VPWR VPWR sky130_fd_sc_hd__decap_3
Xmax_cap190 _5716_/A VGND VGND VPWR VPWR _8780_/C sky130_fd_sc_hd__buf_4
XFILLER_89_253 VGND VGND VPWR VPWR sky130_fd_sc_hd__decap_3
XFILLER_2_669 VGND VGND VPWR VPWR sky130_fd_sc_hd__decap_3
XFILLER_77_415 VGND VGND VPWR VPWR sky130_fd_sc_hd__decap_3
XFILLER_104_586 VGND VGND VPWR VPWR sky130_fd_sc_hd__fill_2
XFILLER_104_597 VGND VGND VPWR VPWR sky130_fd_sc_hd__decap_3
XFILLER_49_128 VGND VGND VPWR VPWR sky130_fd_sc_hd__fill_2
XFILLER_58_651 VGND VGND VPWR VPWR sky130_fd_sc_hd__decap_3
XFILLER_38_64 VGND VGND VPWR VPWR sky130_fd_sc_hd__decap_3
XFILLER_100_770 VGND VGND VPWR VPWR sky130_fd_sc_hd__fill_1
Xhold1160 _9144_/Q VGND VGND VPWR VPWR _4830_/A1 sky130_fd_sc_hd__dlygate4sd3_1
XFILLER_18_526 VGND VGND VPWR VPWR sky130_fd_sc_hd__decap_3
Xhold1171 _9321_/Q VGND VGND VPWR VPWR _8993_/A1 sky130_fd_sc_hd__dlygate4sd3_1
Xhold1182 _9095_/Q VGND VGND VPWR VPWR _4727_/A1 sky130_fd_sc_hd__dlygate4sd3_1
Xhold1193 _9110_/Q VGND VGND VPWR VPWR _4759_/A1 sky130_fd_sc_hd__dlygate4sd3_1
XFILLER_73_654 VGND VGND VPWR VPWR sky130_fd_sc_hd__decap_3
XFILLER_72_153 VGND VGND VPWR VPWR sky130_fd_sc_hd__fill_1
XFILLER_73_687 VGND VGND VPWR VPWR sky130_fd_sc_hd__fill_2
XFILLER_72_164 VGND VGND VPWR VPWR sky130_fd_sc_hd__decap_3
XFILLER_60_315 VGND VGND VPWR VPWR sky130_fd_sc_hd__fill_2
XFILLER_33_529 VGND VGND VPWR VPWR sky130_fd_sc_hd__decap_3
XFILLER_14_710 VGND VGND VPWR VPWR sky130_fd_sc_hd__decap_3
XFILLER_72_197 VGND VGND VPWR VPWR sky130_fd_sc_hd__decap_3
XFILLER_54_85 VGND VGND VPWR VPWR sky130_fd_sc_hd__decap_3
XFILLER_14_743 VGND VGND VPWR VPWR sky130_fd_sc_hd__decap_3
XFILLER_13_242 VGND VGND VPWR VPWR sky130_fd_sc_hd__decap_3
XFILLER_9_213 VGND VGND VPWR VPWR sky130_fd_sc_hd__decap_3
XFILLER_41_573 VGND VGND VPWR VPWR sky130_fd_sc_hd__decap_3
XTAP_TAPCELL_ROW_99_1618 VGND VPWR sky130_fd_sc_hd__tapvpwrvgnd_1
XFILLER_70_40 VGND VGND VPWR VPWR sky130_fd_sc_hd__fill_2
XTAP_TAPCELL_ROW_11_432 VGND VPWR sky130_fd_sc_hd__tapvpwrvgnd_1
XFILLER_127_601 VGND VGND VPWR VPWR sky130_fd_sc_hd__decap_3
XFILLER_127_623 VGND VGND VPWR VPWR sky130_fd_sc_hd__decap_3
XFILLER_126_100 VGND VGND VPWR VPWR sky130_fd_sc_hd__decap_3
Xclkload16 _9348_/CLK VGND VGND VPWR VPWR clkload16/X sky130_fd_sc_hd__clkbuf_4
Xclkload27 _9228_/CLK VGND VGND VPWR VPWR clkload27/X sky130_fd_sc_hd__clkbuf_4
XFILLER_127_656 VGND VGND VPWR VPWR sky130_fd_sc_hd__decap_3
XFILLER_126_133 VGND VGND VPWR VPWR sky130_fd_sc_hd__decap_3
XFILLER_126_144 VGND VGND VPWR VPWR sky130_fd_sc_hd__decap_3
Xrebuffer590 _6505_/A VGND VGND VPWR VPWR _6842_/A2 sky130_fd_sc_hd__buf_2
XFILLER_126_177 VGND VGND VPWR VPWR sky130_fd_sc_hd__decap_3
XFILLER_5_485 VGND VGND VPWR VPWR sky130_fd_sc_hd__decap_3
XFILLER_114_339 VGND VGND VPWR VPWR sky130_fd_sc_hd__decap_3
XFILLER_48_6 VGND VGND VPWR VPWR sky130_fd_sc_hd__decap_3
XFILLER_107_391 VGND VGND VPWR VPWR sky130_fd_sc_hd__fill_1
XFILLER_79_93 VGND VGND VPWR VPWR sky130_fd_sc_hd__decap_3
XFILLER_110_512 VGND VGND VPWR VPWR sky130_fd_sc_hd__fill_2
XFILLER_96_746 VGND VGND VPWR VPWR sky130_fd_sc_hd__decap_3
XFILLER_95_223 VGND VGND VPWR VPWR sky130_fd_sc_hd__fill_1
XFILLER_96_757 VGND VGND VPWR VPWR sky130_fd_sc_hd__decap_3
XFILLER_95_234 VGND VGND VPWR VPWR sky130_fd_sc_hd__fill_2
XFILLER_1_691 VGND VGND VPWR VPWR sky130_fd_sc_hd__decap_3
XFILLER_122_394 VGND VGND VPWR VPWR sky130_fd_sc_hd__decap_3
XFILLER_110_556 VGND VGND VPWR VPWR sky130_fd_sc_hd__decap_3
XTAP_TAPCELL_ROW_39_808 VGND VPWR sky130_fd_sc_hd__tapvpwrvgnd_1
XFILLER_83_407 VGND VGND VPWR VPWR sky130_fd_sc_hd__decap_3
XFILLER_49_651 VGND VGND VPWR VPWR sky130_fd_sc_hd__decap_3
XFILLER_110_578 VGND VGND VPWR VPWR sky130_fd_sc_hd__fill_2
XFILLER_49_673 VGND VGND VPWR VPWR sky130_fd_sc_hd__decap_3
XFILLER_110_589 VGND VGND VPWR VPWR sky130_fd_sc_hd__decap_3
XFILLER_64_621 VGND VGND VPWR VPWR sky130_fd_sc_hd__fill_1
XTAP_TAPCELL_ROW_108_1736 VGND VPWR sky130_fd_sc_hd__tapvpwrvgnd_1
XFILLER_48_183 VGND VGND VPWR VPWR sky130_fd_sc_hd__decap_3
XFILLER_64_643 VGND VGND VPWR VPWR sky130_fd_sc_hd__fill_1
XTAP_TAPCELL_ROW_19_532 VGND VPWR sky130_fd_sc_hd__tapvpwrvgnd_1
XTAP_TAPCELL_ROW_19_543 VGND VPWR sky130_fd_sc_hd__tapvpwrvgnd_1
XFILLER_91_440 VGND VGND VPWR VPWR sky130_fd_sc_hd__decap_3
XFILLER_64_676 VGND VGND VPWR VPWR sky130_fd_sc_hd__fill_2
XFILLER_63_153 VGND VGND VPWR VPWR sky130_fd_sc_hd__decap_3
X_7760_ _8050_/A _8155_/A VGND VGND VPWR VPWR _7931_/B sky130_fd_sc_hd__nor2_2
X_4972_ _4972_/A1 _4968_/X _4971_/X VGND VGND VPWR VPWR _4973_/A sky130_fd_sc_hd__o21ba_2
XTAP_TAPCELL_ROW_121_1914 VGND VPWR sky130_fd_sc_hd__tapvpwrvgnd_1
XFILLER_17_570 VGND VGND VPWR VPWR sky130_fd_sc_hd__decap_3
XFILLER_51_326 VGND VGND VPWR VPWR sky130_fd_sc_hd__decap_3
XFILLER_51_337 VGND VGND VPWR VPWR sky130_fd_sc_hd__decap_3
X_6711_ _6972_/A _7071_/A _6711_/C _7071_/B VGND VGND VPWR VPWR _6711_/X sky130_fd_sc_hd__and4_2
XTAP_TAPCELL_ROW_67_1190 VGND VPWR sky130_fd_sc_hd__tapvpwrvgnd_1
X_7691_ _8013_/A _7702_/B VGND VGND VPWR VPWR _7692_/B sky130_fd_sc_hd__xnor2_2
XFILLER_32_551 VGND VGND VPWR VPWR sky130_fd_sc_hd__decap_3
XFILLER_20_713 VGND VGND VPWR VPWR sky130_fd_sc_hd__decap_3
X_6642_ _6642_/A _6643_/B VGND VGND VPWR VPWR _6642_/X sky130_fd_sc_hd__or2_2
XFILLER_20_746 VGND VGND VPWR VPWR sky130_fd_sc_hd__decap_3
XFILLER_20_757 VGND VGND VPWR VPWR sky130_fd_sc_hd__decap_3
X_6573_ _6570_/X _6571_/X _6573_/B1 _5844_/X VGND VGND VPWR VPWR _6695_/D sky130_fd_sc_hd__o211ai_2
XFILLER_118_601 VGND VGND VPWR VPWR sky130_fd_sc_hd__decap_3
X_8312_ _8312_/A _8411_/A VGND VGND VPWR VPWR _8406_/B sky130_fd_sc_hd__nand2_2
X_5524_ _5524_/A _5524_/B _5524_/C VGND VGND VPWR VPWR _5528_/C sky130_fd_sc_hd__and3_2
XFILLER_117_111 VGND VGND VPWR VPWR sky130_fd_sc_hd__fill_1
X_9292_ _9308_/CLK _9292_/D load_slew368/X VGND VGND VPWR VPWR _9292_/Q sky130_fd_sc_hd__dfrtp_2
XFILLER_118_645 VGND VGND VPWR VPWR sky130_fd_sc_hd__decap_3
XTAP_TAPCELL_ROW_119_1887 VGND VPWR sky130_fd_sc_hd__tapvpwrvgnd_1
X_8243_ _8329_/A _8243_/B VGND VGND VPWR VPWR _8321_/A sky130_fd_sc_hd__xor2_2
X_5455_ _9203_/Q VGND VGND VPWR VPWR _5481_/A sky130_fd_sc_hd__inv_2
X_8174_ _8174_/A _8174_/B VGND VGND VPWR VPWR _8175_/B sky130_fd_sc_hd__xnor2_2
X_5386_ _5386_/A _5386_/B _5386_/C _5386_/D VGND VGND VPWR VPWR _5386_/Y sky130_fd_sc_hd__nor4_4
XFILLER_99_551 VGND VGND VPWR VPWR sky130_fd_sc_hd__decap_3
XFILLER_120_309 VGND VGND VPWR VPWR sky130_fd_sc_hd__decap_3
X_7125_ _7496_/B _7377_/B VGND VGND VPWR VPWR _7126_/B sky130_fd_sc_hd__xnor2_2
XFILLER_113_350 VGND VGND VPWR VPWR sky130_fd_sc_hd__decap_3
XFILLER_101_501 VGND VGND VPWR VPWR sky130_fd_sc_hd__decap_3
XFILLER_87_724 VGND VGND VPWR VPWR sky130_fd_sc_hd__decap_3
XFILLER_115_36 VGND VGND VPWR VPWR sky130_fd_sc_hd__decap_3
X_7056_ _7056_/A _7056_/B VGND VGND VPWR VPWR _7357_/A sky130_fd_sc_hd__or2_4
Xfanout269 _9233_/Q VGND VGND VPWR VPWR _6231_/B sky130_fd_sc_hd__buf_8
XFILLER_115_69 VGND VGND VPWR VPWR sky130_fd_sc_hd__decap_3
X_6007_ _6007_/A _6007_/B VGND VGND VPWR VPWR _6008_/B sky130_fd_sc_hd__and2_2
XFILLER_39_172 VGND VGND VPWR VPWR sky130_fd_sc_hd__decap_3
XFILLER_55_665 VGND VGND VPWR VPWR sky130_fd_sc_hd__decap_3
XTAP_TAPCELL_ROW_83_1408 VGND VPWR sky130_fd_sc_hd__tapvpwrvgnd_1
XFILLER_55_676 VGND VGND VPWR VPWR sky130_fd_sc_hd__fill_1
XFILLER_27_367 VGND VGND VPWR VPWR sky130_fd_sc_hd__decap_3
XFILLER_55_687 VGND VGND VPWR VPWR sky130_fd_sc_hd__decap_3
XFILLER_42_315 VGND VGND VPWR VPWR sky130_fd_sc_hd__decap_3
XFILLER_27_389 VGND VGND VPWR VPWR sky130_fd_sc_hd__decap_3
X_7958_ _7770_/B _7956_/X _7957_/X VGND VGND VPWR VPWR _7962_/A sky130_fd_sc_hd__a21oi_2
XFILLER_91_39 VGND VGND VPWR VPWR sky130_fd_sc_hd__fill_2
XFILLER_42_348 VGND VGND VPWR VPWR sky130_fd_sc_hd__decap_3
X_6909_ _6908_/A _6908_/B _6666_/A VGND VGND VPWR VPWR _6909_/X sky130_fd_sc_hd__a21bo_2
X_7889_ _7889_/A _7889_/B VGND VGND VPWR VPWR _7890_/B sky130_fd_sc_hd__xnor2_2
XFILLER_23_551 VGND VGND VPWR VPWR sky130_fd_sc_hd__decap_3
XFILLER_24_44 VGND VGND VPWR VPWR sky130_fd_sc_hd__decap_3
XFILLER_11_702 VGND VGND VPWR VPWR sky130_fd_sc_hd__decap_3
XFILLER_23_573 VGND VGND VPWR VPWR sky130_fd_sc_hd__decap_3
XFILLER_11_735 VGND VGND VPWR VPWR sky130_fd_sc_hd__decap_3
XFILLER_10_212 VGND VGND VPWR VPWR sky130_fd_sc_hd__decap_3
XFILLER_50_392 VGND VGND VPWR VPWR sky130_fd_sc_hd__decap_3
XFILLER_128_409 VGND VGND VPWR VPWR sky130_fd_sc_hd__fill_2
XFILLER_11_768 VGND VGND VPWR VPWR sky130_fd_sc_hd__decap_3
XFILLER_109_612 VGND VGND VPWR VPWR sky130_fd_sc_hd__decap_3
XFILLER_109_623 VGND VGND VPWR VPWR sky130_fd_sc_hd__decap_3
XFILLER_109_634 VGND VGND VPWR VPWR sky130_fd_sc_hd__decap_3
XFILLER_6_227 VGND VGND VPWR VPWR sky130_fd_sc_hd__decap_3
XFILLER_6_238 VGND VGND VPWR VPWR sky130_fd_sc_hd__decap_3
XFILLER_10_289 VGND VGND VPWR VPWR sky130_fd_sc_hd__decap_3
XFILLER_108_144 VGND VGND VPWR VPWR sky130_fd_sc_hd__fill_1
XTAP_TAPCELL_ROW_94_1548 VGND VPWR sky130_fd_sc_hd__tapvpwrvgnd_1
XFILLER_124_637 VGND VGND VPWR VPWR sky130_fd_sc_hd__decap_3
XFILLER_124_648 VGND VGND VPWR VPWR sky130_fd_sc_hd__decap_3
XFILLER_123_125 VGND VGND VPWR VPWR sky130_fd_sc_hd__decap_3
XFILLER_123_158 VGND VGND VPWR VPWR sky130_fd_sc_hd__decap_3
XFILLER_123_169 VGND VGND VPWR VPWR sky130_fd_sc_hd__decap_3
XFILLER_2_477 VGND VGND VPWR VPWR sky130_fd_sc_hd__decap_3
XFILLER_104_361 VGND VGND VPWR VPWR sky130_fd_sc_hd__decap_3
XFILLER_49_63 VGND VGND VPWR VPWR sky130_fd_sc_hd__fill_1
XFILLER_104_394 VGND VGND VPWR VPWR sky130_fd_sc_hd__fill_1
XFILLER_49_96 VGND VGND VPWR VPWR sky130_fd_sc_hd__decap_3
XFILLER_1_15 VGND VGND VPWR VPWR sky130_fd_sc_hd__decap_3
XFILLER_93_727 VGND VGND VPWR VPWR sky130_fd_sc_hd__fill_1
XFILLER_1_48 VGND VGND VPWR VPWR sky130_fd_sc_hd__decap_3
XFILLER_18_312 VGND VGND VPWR VPWR sky130_fd_sc_hd__decap_3
XFILLER_105_91 VGND VGND VPWR VPWR sky130_fd_sc_hd__fill_1
XFILLER_46_632 VGND VGND VPWR VPWR sky130_fd_sc_hd__decap_3
XFILLER_46_676 VGND VGND VPWR VPWR sky130_fd_sc_hd__decap_3
XFILLER_45_142 VGND VGND VPWR VPWR sky130_fd_sc_hd__decap_3
XFILLER_73_473 VGND VGND VPWR VPWR sky130_fd_sc_hd__decap_3
XFILLER_61_613 VGND VGND VPWR VPWR sky130_fd_sc_hd__decap_3
XTAP_TAPCELL_ROW_16_502 VGND VPWR sky130_fd_sc_hd__tapvpwrvgnd_1
XFILLER_45_175 VGND VGND VPWR VPWR sky130_fd_sc_hd__decap_3
XFILLER_18_389 VGND VGND VPWR VPWR sky130_fd_sc_hd__fill_2
XFILLER_33_337 VGND VGND VPWR VPWR sky130_fd_sc_hd__decap_3
XFILLER_60_123 VGND VGND VPWR VPWR sky130_fd_sc_hd__decap_3
XFILLER_45_197 VGND VGND VPWR VPWR sky130_fd_sc_hd__decap_3
XFILLER_61_657 VGND VGND VPWR VPWR sky130_fd_sc_hd__decap_3
XTAP_TAPCELL_ROW_44_877 VGND VPWR sky130_fd_sc_hd__tapvpwrvgnd_1
XFILLER_60_156 VGND VGND VPWR VPWR sky130_fd_sc_hd__decap_3
XFILLER_14_551 VGND VGND VPWR VPWR sky130_fd_sc_hd__decap_3
XFILLER_121_90 VGND VGND VPWR VPWR sky130_fd_sc_hd__decap_3
XTAP_TAPCELL_ROW_103_1666 VGND VPWR sky130_fd_sc_hd__tapvpwrvgnd_1
XTAP_TAPCELL_ROW_103_1677 VGND VPWR sky130_fd_sc_hd__tapvpwrvgnd_1
XFILLER_41_370 VGND VGND VPWR VPWR sky130_fd_sc_hd__decap_3
XFILLER_115_604 VGND VGND VPWR VPWR sky130_fd_sc_hd__decap_3
XFILLER_6_772 VGND VGND VPWR VPWR sky130_fd_sc_hd__fill_1
XFILLER_115_637 VGND VGND VPWR VPWR sky130_fd_sc_hd__decap_3
X_5240_ _5135_/A _5149_/X _5239_/X VGND VGND VPWR VPWR _5241_/B sky130_fd_sc_hd__a21o_2
XTAP_TAPCELL_ROW_54_1009 VGND VPWR sky130_fd_sc_hd__tapvpwrvgnd_1
XFILLER_46_3 VGND VGND VPWR VPWR sky130_fd_sc_hd__fill_2
XFILLER_130_607 VGND VGND VPWR VPWR sky130_fd_sc_hd__decap_3
XFILLER_102_309 VGND VGND VPWR VPWR sky130_fd_sc_hd__decap_3
XFILLER_69_713 VGND VGND VPWR VPWR sky130_fd_sc_hd__decap_3
XFILLER_130_629 VGND VGND VPWR VPWR sky130_fd_sc_hd__decap_3
X_5171_ _5168_/Y _5169_/X _5170_/X VGND VGND VPWR VPWR _5211_/A sky130_fd_sc_hd__o21ai_2
XPHY_EDGE_ROW_18_Right_18 VGND VGND VPWR VPWR sky130_fd_sc_hd__decap_3
XFILLER_123_670 VGND VGND VPWR VPWR sky130_fd_sc_hd__fill_2
XFILLER_69_746 VGND VGND VPWR VPWR sky130_fd_sc_hd__decap_3
XFILLER_122_180 VGND VGND VPWR VPWR sky130_fd_sc_hd__decap_3
XFILLER_96_565 VGND VGND VPWR VPWR sky130_fd_sc_hd__fill_1
XFILLER_68_256 VGND VGND VPWR VPWR sky130_fd_sc_hd__fill_2
XFILLER_110_353 VGND VGND VPWR VPWR sky130_fd_sc_hd__decap_3
XFILLER_56_418 VGND VGND VPWR VPWR sky130_fd_sc_hd__fill_2
X_8930_ _8963_/A1 _8930_/A1 _8946_/S VGND VGND VPWR VPWR _8931_/A sky130_fd_sc_hd__mux2_2
Xinput3 sample_in[10] VGND VGND VPWR VPWR input3/X sky130_fd_sc_hd__clkdlybuf4s25_1
XFILLER_49_481 VGND VGND VPWR VPWR sky130_fd_sc_hd__decap_3
XFILLER_37_643 VGND VGND VPWR VPWR sky130_fd_sc_hd__decap_3
X_8861_ _8861_/A VGND VGND VPWR VPWR _9274_/D sky130_fd_sc_hd__buf_1
XFILLER_64_440 VGND VGND VPWR VPWR sky130_fd_sc_hd__fill_2
XFILLER_37_676 VGND VGND VPWR VPWR sky130_fd_sc_hd__decap_3
XFILLER_36_153 VGND VGND VPWR VPWR sky130_fd_sc_hd__decap_3
X_7812_ _7812_/A _7812_/B VGND VGND VPWR VPWR _7826_/A sky130_fd_sc_hd__xnor2_2
XFILLER_52_624 VGND VGND VPWR VPWR sky130_fd_sc_hd__decap_3
XFILLER_24_315 VGND VGND VPWR VPWR sky130_fd_sc_hd__decap_3
X_8792_ _8792_/A VGND VGND VPWR VPWR _9241_/D sky130_fd_sc_hd__buf_1
XFILLER_64_495 VGND VGND VPWR VPWR sky130_fd_sc_hd__decap_3
XFILLER_51_134 VGND VGND VPWR VPWR sky130_fd_sc_hd__fill_1
X_7743_ _7857_/A _7857_/B VGND VGND VPWR VPWR _7853_/B sky130_fd_sc_hd__and2_2
X_4955_ _5738_/S _4955_/B _4955_/C VGND VGND VPWR VPWR _4955_/X sky130_fd_sc_hd__and3_2
XPHY_EDGE_ROW_27_Right_27 VGND VGND VPWR VPWR sky130_fd_sc_hd__decap_3
XFILLER_52_679 VGND VGND VPWR VPWR sky130_fd_sc_hd__decap_3
XFILLER_51_178 VGND VGND VPWR VPWR sky130_fd_sc_hd__decap_3
X_7674_ _6414_/X _7186_/X _7673_/X VGND VGND VPWR VPWR _7674_/X sky130_fd_sc_hd__a21o_2
XFILLER_20_510 VGND VGND VPWR VPWR sky130_fd_sc_hd__decap_3
X_4886_ _4876_/X _4885_/Y _4878_/X hold789/X VGND VGND VPWR VPWR _4886_/X sky130_fd_sc_hd__a2bb2o_2
X_6625_ _6625_/A _6625_/B VGND VGND VPWR VPWR _6661_/A sky130_fd_sc_hd__xnor2_2
XFILLER_20_554 VGND VGND VPWR VPWR sky130_fd_sc_hd__decap_3
X_6556_ _6745_/B _6745_/A VGND VGND VPWR VPWR _6556_/Y sky130_fd_sc_hd__xnor2_2
X_9344_ _9344_/CLK _9344_/D load_slew380/X VGND VGND VPWR VPWR _9344_/Q sky130_fd_sc_hd__dfrtp_2
XFILLER_20_598 VGND VGND VPWR VPWR sky130_fd_sc_hd__decap_3
XFILLER_118_442 VGND VGND VPWR VPWR sky130_fd_sc_hd__fill_1
XFILLER_106_604 VGND VGND VPWR VPWR sky130_fd_sc_hd__decap_3
XFILLER_117_9 VGND VGND VPWR VPWR sky130_fd_sc_hd__decap_3
X_5507_ _5507_/A _6096_/B VGND VGND VPWR VPWR _5507_/Y sky130_fd_sc_hd__nand2_2
X_9275_ _9339_/CLK _9275_/D load_slew384/X VGND VGND VPWR VPWR _9275_/Q sky130_fd_sc_hd__dfrtp_2
XFILLER_118_475 VGND VGND VPWR VPWR sky130_fd_sc_hd__fill_1
XFILLER_105_103 VGND VGND VPWR VPWR sky130_fd_sc_hd__decap_3
X_6487_ _6817_/A _6487_/B VGND VGND VPWR VPWR _6812_/S sky130_fd_sc_hd__xnor2_2
XFILLER_118_486 VGND VGND VPWR VPWR sky130_fd_sc_hd__decap_3
XFILLER_10_24 VGND VGND VPWR VPWR sky130_fd_sc_hd__decap_3
XFILLER_106_648 VGND VGND VPWR VPWR sky130_fd_sc_hd__fill_2
XFILLER_10_35 VGND VGND VPWR VPWR sky130_fd_sc_hd__decap_3
XFILLER_106_659 VGND VGND VPWR VPWR sky130_fd_sc_hd__decap_3
X_8226_ _8233_/B2 _8231_/B _8229_/B _8231_/A VGND VGND VPWR VPWR _8226_/X sky130_fd_sc_hd__a211o_2
X_5438_ _5105_/Y _5438_/B _7407_/A VGND VGND VPWR VPWR _5438_/X sky130_fd_sc_hd__and3b_2
XPHY_EDGE_ROW_36_Right_36 VGND VGND VPWR VPWR sky130_fd_sc_hd__decap_3
XFILLER_126_24 VGND VGND VPWR VPWR sky130_fd_sc_hd__decap_3
XFILLER_126_35 VGND VGND VPWR VPWR sky130_fd_sc_hd__decap_3
XFILLER_10_68 VGND VGND VPWR VPWR sky130_fd_sc_hd__decap_3
XFILLER_105_169 VGND VGND VPWR VPWR sky130_fd_sc_hd__decap_3
XFILLER_121_629 VGND VGND VPWR VPWR sky130_fd_sc_hd__decap_3
X_8157_ _8154_/A _8157_/A2 _8153_/Y _8156_/X _8050_/B VGND VGND VPWR VPWR _8157_/X
+ sky130_fd_sc_hd__a32o_2
XFILLER_120_106 VGND VGND VPWR VPWR sky130_fd_sc_hd__decap_3
X_5369_ _5369_/A _5369_/B VGND VGND VPWR VPWR _5369_/Y sky130_fd_sc_hd__nand2_2
XFILLER_126_68 VGND VGND VPWR VPWR sky130_fd_sc_hd__decap_3
XFILLER_120_139 VGND VGND VPWR VPWR sky130_fd_sc_hd__fill_1
XFILLER_114_692 VGND VGND VPWR VPWR sky130_fd_sc_hd__decap_3
X_7108_ _7108_/A _7108_/B VGND VGND VPWR VPWR _7375_/A sky130_fd_sc_hd__nand2_2
XFILLER_87_543 VGND VGND VPWR VPWR sky130_fd_sc_hd__decap_3
X_8088_ _7962_/A _7962_/B _8087_/X VGND VGND VPWR VPWR _8215_/B sky130_fd_sc_hd__a21oi_2
XFILLER_59_256 VGND VGND VPWR VPWR sky130_fd_sc_hd__fill_1
XFILLER_87_576 VGND VGND VPWR VPWR sky130_fd_sc_hd__decap_3
XFILLER_19_44 VGND VGND VPWR VPWR sky130_fd_sc_hd__decap_3
XFILLER_59_278 VGND VGND VPWR VPWR sky130_fd_sc_hd__fill_2
X_7039_ _7117_/A _6956_/X _7036_/Y _7038_/X VGND VGND VPWR VPWR _7039_/X sky130_fd_sc_hd__o22a_2
XFILLER_28_610 VGND VGND VPWR VPWR sky130_fd_sc_hd__fill_2
XFILLER_28_621 VGND VGND VPWR VPWR sky130_fd_sc_hd__decap_3
XFILLER_19_77 VGND VGND VPWR VPWR sky130_fd_sc_hd__decap_3
XFILLER_27_153 VGND VGND VPWR VPWR sky130_fd_sc_hd__decap_3
XPHY_EDGE_ROW_45_Right_45 VGND VGND VPWR VPWR sky130_fd_sc_hd__decap_3
XFILLER_70_421 VGND VGND VPWR VPWR sky130_fd_sc_hd__decap_3
XFILLER_42_112 VGND VGND VPWR VPWR sky130_fd_sc_hd__decap_3
XFILLER_35_54 VGND VGND VPWR VPWR sky130_fd_sc_hd__fill_2
XFILLER_27_197 VGND VGND VPWR VPWR sky130_fd_sc_hd__decap_3
XFILLER_15_337 VGND VGND VPWR VPWR sky130_fd_sc_hd__decap_3
XFILLER_43_668 VGND VGND VPWR VPWR sky130_fd_sc_hd__decap_3
XFILLER_35_76 VGND VGND VPWR VPWR sky130_fd_sc_hd__decap_3
XFILLER_43_679 VGND VGND VPWR VPWR sky130_fd_sc_hd__decap_3
XFILLER_42_156 VGND VGND VPWR VPWR sky130_fd_sc_hd__decap_3
XTAP_TAPCELL_ROW_41_836 VGND VPWR sky130_fd_sc_hd__tapvpwrvgnd_1
XFILLER_129_718 VGND VGND VPWR VPWR sky130_fd_sc_hd__decap_3
XFILLER_129_729 VGND VGND VPWR VPWR sky130_fd_sc_hd__decap_3
XFILLER_128_206 VGND VGND VPWR VPWR sky130_fd_sc_hd__decap_3
XFILLER_11_554 VGND VGND VPWR VPWR sky130_fd_sc_hd__decap_3
XFILLER_11_576 VGND VGND VPWR VPWR sky130_fd_sc_hd__decap_3
XFILLER_109_420 VGND VGND VPWR VPWR sky130_fd_sc_hd__decap_3
XTAP_TAPCELL_ROW_21_560 VGND VPWR sky130_fd_sc_hd__tapvpwrvgnd_1
XTAP_TAPCELL_ROW_21_571 VGND VPWR sky130_fd_sc_hd__tapvpwrvgnd_1
XFILLER_7_547 VGND VGND VPWR VPWR sky130_fd_sc_hd__decap_3
XFILLER_109_464 VGND VGND VPWR VPWR sky130_fd_sc_hd__decap_3
XFILLER_109_486 VGND VGND VPWR VPWR sky130_fd_sc_hd__decap_3
XFILLER_124_412 VGND VGND VPWR VPWR sky130_fd_sc_hd__decap_3
XPHY_EDGE_ROW_54_Right_54 VGND VGND VPWR VPWR sky130_fd_sc_hd__decap_3
XFILLER_3_753 VGND VGND VPWR VPWR sky130_fd_sc_hd__decap_3
XFILLER_78_554 VGND VGND VPWR VPWR sky130_fd_sc_hd__fill_1
XFILLER_120_651 VGND VGND VPWR VPWR sky130_fd_sc_hd__fill_1
XFILLER_19_610 VGND VGND VPWR VPWR sky130_fd_sc_hd__decap_3
XFILLER_66_749 VGND VGND VPWR VPWR sky130_fd_sc_hd__decap_3
XTAP_TAPCELL_ROW_49_947 VGND VPWR sky130_fd_sc_hd__tapvpwrvgnd_1
XFILLER_93_546 VGND VGND VPWR VPWR sky130_fd_sc_hd__fill_2
XFILLER_76_83 VGND VGND VPWR VPWR sky130_fd_sc_hd__fill_1
XFILLER_19_654 VGND VGND VPWR VPWR sky130_fd_sc_hd__decap_3
XPHY_EDGE_ROW_63_Right_63 VGND VGND VPWR VPWR sky130_fd_sc_hd__decap_3
XFILLER_93_579 VGND VGND VPWR VPWR sky130_fd_sc_hd__decap_3
XFILLER_81_719 VGND VGND VPWR VPWR sky130_fd_sc_hd__fill_1
XFILLER_19_665 VGND VGND VPWR VPWR sky130_fd_sc_hd__decap_3
XFILLER_46_451 VGND VGND VPWR VPWR sky130_fd_sc_hd__decap_3
XFILLER_19_676 VGND VGND VPWR VPWR sky130_fd_sc_hd__decap_3
XTAP_TAPCELL_ROW_29_671 VGND VPWR sky130_fd_sc_hd__tapvpwrvgnd_1
XFILLER_19_698 VGND VGND VPWR VPWR sky130_fd_sc_hd__decap_3
XFILLER_46_495 VGND VGND VPWR VPWR sky130_fd_sc_hd__decap_3
XFILLER_73_281 VGND VGND VPWR VPWR sky130_fd_sc_hd__decap_3
XFILLER_18_197 VGND VGND VPWR VPWR sky130_fd_sc_hd__decap_3
XFILLER_61_443 VGND VGND VPWR VPWR sky130_fd_sc_hd__decap_3
XFILLER_33_134 VGND VGND VPWR VPWR sky130_fd_sc_hd__decap_3
XFILLER_34_679 VGND VGND VPWR VPWR sky130_fd_sc_hd__decap_3
XFILLER_33_156 VGND VGND VPWR VPWR sky130_fd_sc_hd__decap_3
XPHY_EDGE_ROW_1_Left_132 VGND VGND VPWR VPWR sky130_fd_sc_hd__decap_3
XPHY_EDGE_ROW_38_Left_169 VGND VGND VPWR VPWR sky130_fd_sc_hd__decap_3
X_4740_ hold928/X _4740_/A1 _4756_/S VGND VGND VPWR VPWR _4741_/A sky130_fd_sc_hd__mux2_2
XFILLER_21_329 VGND VGND VPWR VPWR sky130_fd_sc_hd__decap_3
X_4671_ _4671_/A VGND VGND VPWR VPWR _9084_/D sky130_fd_sc_hd__buf_1
X_6410_ _6788_/A _6470_/A _6426_/A VGND VGND VPWR VPWR _6411_/B sky130_fd_sc_hd__mux2_2
X_7390_ _7031_/A _7388_/X _7389_/X VGND VGND VPWR VPWR _7392_/B sky130_fd_sc_hd__a21oi_2
XFILLER_128_740 VGND VGND VPWR VPWR sky130_fd_sc_hd__decap_3
XPHY_EDGE_ROW_72_Right_72 VGND VGND VPWR VPWR sky130_fd_sc_hd__decap_3
X_6341_ _6342_/A _6342_/B _9111_/Q VGND VGND VPWR VPWR _6341_/X sky130_fd_sc_hd__and3b_2
XTAP_TAPCELL_ROW_116_1846 VGND VPWR sky130_fd_sc_hd__tapvpwrvgnd_1
X_9060_ _9345_/CLK _9060_/D load_slew388/X VGND VGND VPWR VPWR _9060_/Q sky130_fd_sc_hd__dfrtp_2
X_6272_ _6522_/A _6519_/C VGND VGND VPWR VPWR _6385_/B sky130_fd_sc_hd__nor2_2
X_8011_ _8011_/A _8011_/B _8011_/C VGND VGND VPWR VPWR _8011_/X sky130_fd_sc_hd__or3_2
XFILLER_115_478 VGND VGND VPWR VPWR sky130_fd_sc_hd__decap_3
XFILLER_103_629 VGND VGND VPWR VPWR sky130_fd_sc_hd__fill_1
X_5223_ _6395_/A _5219_/Y _5221_/Y _5222_/X VGND VGND VPWR VPWR _5224_/B sky130_fd_sc_hd__o22a_2
XPHY_EDGE_ROW_47_Left_178 VGND VGND VPWR VPWR sky130_fd_sc_hd__decap_3
XFILLER_69_543 VGND VGND VPWR VPWR sky130_fd_sc_hd__decap_3
X_5154_ _7480_/C _5011_/X _7114_/B _9197_/Q VGND VGND VPWR VPWR _5154_/X sky130_fd_sc_hd__o211a_2
XFILLER_111_640 VGND VGND VPWR VPWR sky130_fd_sc_hd__fill_1
XFILLER_29_407 VGND VGND VPWR VPWR sky130_fd_sc_hd__decap_3
XFILLER_111_662 VGND VGND VPWR VPWR sky130_fd_sc_hd__fill_1
XFILLER_111_673 VGND VGND VPWR VPWR sky130_fd_sc_hd__decap_3
XFILLER_57_738 VGND VGND VPWR VPWR sky130_fd_sc_hd__fill_1
X_5085_ _5934_/A _5513_/A VGND VGND VPWR VPWR _5086_/A sky130_fd_sc_hd__or2_2
XPHY_EDGE_ROW_81_Right_81 VGND VGND VPWR VPWR sky130_fd_sc_hd__decap_3
XFILLER_2_80 VGND VGND VPWR VPWR sky130_fd_sc_hd__decap_3
XFILLER_2_91 VGND VGND VPWR VPWR sky130_fd_sc_hd__decap_3
X_8913_ _8946_/A1 _8913_/A1 _8925_/S VGND VGND VPWR VPWR _8914_/A sky130_fd_sc_hd__mux2_2
XFILLER_72_708 VGND VGND VPWR VPWR sky130_fd_sc_hd__decap_3
XFILLER_84_579 VGND VGND VPWR VPWR sky130_fd_sc_hd__decap_3
XFILLER_65_760 VGND VGND VPWR VPWR sky130_fd_sc_hd__decap_3
XFILLER_112_15 VGND VGND VPWR VPWR sky130_fd_sc_hd__decap_3
XFILLER_37_462 VGND VGND VPWR VPWR sky130_fd_sc_hd__decap_3
X_8844_ _8877_/A1 _9250_/Q _8862_/S VGND VGND VPWR VPWR _8844_/X sky130_fd_sc_hd__mux2_2
XTAP_TAPCELL_ROW_127_1997 VGND VPWR sky130_fd_sc_hd__tapvpwrvgnd_1
XFILLER_112_59 VGND VGND VPWR VPWR sky130_fd_sc_hd__decap_3
XFILLER_37_495 VGND VGND VPWR VPWR sky130_fd_sc_hd__fill_1
XPHY_EDGE_ROW_56_Left_187 VGND VGND VPWR VPWR sky130_fd_sc_hd__decap_3
XFILLER_25_679 VGND VGND VPWR VPWR sky130_fd_sc_hd__decap_3
X_5987_ _9265_/Q _5062_/X _5066_/X _9157_/Q VGND VGND VPWR VPWR _5987_/X sky130_fd_sc_hd__a22o_2
X_8775_ _8773_/Y wire110/X _8774_/X VGND VGND VPWR VPWR _9232_/D sky130_fd_sc_hd__a21oi_2
XFILLER_40_605 VGND VGND VPWR VPWR sky130_fd_sc_hd__decap_3
XFILLER_24_156 VGND VGND VPWR VPWR sky130_fd_sc_hd__fill_2
XFILLER_12_318 VGND VGND VPWR VPWR sky130_fd_sc_hd__decap_3
XFILLER_24_189 VGND VGND VPWR VPWR sky130_fd_sc_hd__decap_3
XFILLER_12_329 VGND VGND VPWR VPWR sky130_fd_sc_hd__decap_3
X_4938_ _9318_/Q _9114_/Q _6239_/A VGND VGND VPWR VPWR _4938_/X sky130_fd_sc_hd__mux2_2
X_7726_ _8011_/B _7682_/A _7717_/X VGND VGND VPWR VPWR _7726_/X sky130_fd_sc_hd__o21a_2
X_4869_ _9227_/Q _9226_/Q _9229_/Q _9228_/Q VGND VGND VPWR VPWR _4869_/X sky130_fd_sc_hd__or4_2
X_7657_ _7657_/A VGND VGND VPWR VPWR _7857_/B sky130_fd_sc_hd__clkbuf_1
XPHY_EDGE_ROW_90_Right_90 VGND VGND VPWR VPWR sky130_fd_sc_hd__decap_3
X_6608_ _9300_/Q _6753_/B _6608_/C VGND VGND VPWR VPWR _6608_/X sky130_fd_sc_hd__and3_2
XFILLER_21_12 VGND VGND VPWR VPWR sky130_fd_sc_hd__decap_3
X_7588_ _7763_/A _7590_/C _7617_/B VGND VGND VPWR VPWR _7588_/X sky130_fd_sc_hd__a21o_2
XTAP_TAPCELL_ROW_78_1329 VGND VPWR sky130_fd_sc_hd__tapvpwrvgnd_1
XFILLER_119_762 VGND VGND VPWR VPWR sky130_fd_sc_hd__decap_3
XFILLER_118_250 VGND VGND VPWR VPWR sky130_fd_sc_hd__fill_2
XFILLER_115_6 VGND VGND VPWR VPWR sky130_fd_sc_hd__decap_3
X_6539_ _6540_/A _6540_/B VGND VGND VPWR VPWR _6539_/Y sky130_fd_sc_hd__nand2_2
X_9327_ _9343_/CLK _9327_/D fanout402/X VGND VGND VPWR VPWR _9327_/Q sky130_fd_sc_hd__dfrtp_2
XFILLER_4_528 VGND VGND VPWR VPWR sky130_fd_sc_hd__decap_3
XFILLER_4_539 VGND VGND VPWR VPWR sky130_fd_sc_hd__decap_3
XFILLER_118_283 VGND VGND VPWR VPWR sky130_fd_sc_hd__decap_3
XTAP_TAPCELL_ROW_91_1507 VGND VPWR sky130_fd_sc_hd__tapvpwrvgnd_1
XPHY_EDGE_ROW_65_Left_196 VGND VGND VPWR VPWR sky130_fd_sc_hd__decap_3
X_9258_ clkload4/A _9258_/D wire372/X VGND VGND VPWR VPWR _9258_/Q sky130_fd_sc_hd__dfrtp_2
XFILLER_0_701 VGND VGND VPWR VPWR sky130_fd_sc_hd__decap_3
XFILLER_121_404 VGND VGND VPWR VPWR sky130_fd_sc_hd__decap_3
XFILLER_106_489 VGND VGND VPWR VPWR sky130_fd_sc_hd__decap_3
X_8209_ _8043_/A _8043_/B _8208_/X VGND VGND VPWR VPWR _8210_/A sky130_fd_sc_hd__o21ai_4
X_9189_ _9189_/CLK _9189_/D load_slew414/X VGND VGND VPWR VPWR _9189_/Q sky130_fd_sc_hd__dfrtp_2
XFILLER_102_651 VGND VGND VPWR VPWR sky130_fd_sc_hd__decap_3
XTAP_TAPCELL_ROW_7_377 VGND VPWR sky130_fd_sc_hd__tapvpwrvgnd_1
XFILLER_48_705 VGND VGND VPWR VPWR sky130_fd_sc_hd__fill_2
XFILLER_102_673 VGND VGND VPWR VPWR sky130_fd_sc_hd__decap_3
XFILLER_47_215 VGND VGND VPWR VPWR sky130_fd_sc_hd__decap_3
XFILLER_101_183 VGND VGND VPWR VPWR sky130_fd_sc_hd__fill_1
XFILLER_75_546 VGND VGND VPWR VPWR sky130_fd_sc_hd__decap_3
XFILLER_63_708 VGND VGND VPWR VPWR sky130_fd_sc_hd__decap_3
XTAP_TAPCELL_ROW_46_906 VGND VPWR sky130_fd_sc_hd__tapvpwrvgnd_1
XFILLER_28_440 VGND VGND VPWR VPWR sky130_fd_sc_hd__decap_3
XFILLER_56_760 VGND VGND VPWR VPWR sky130_fd_sc_hd__fill_2
XFILLER_90_516 VGND VGND VPWR VPWR sky130_fd_sc_hd__decap_3
XFILLER_28_462 VGND VGND VPWR VPWR sky130_fd_sc_hd__fill_1
XFILLER_90_538 VGND VGND VPWR VPWR sky130_fd_sc_hd__decap_3
Xmax_cap54 _8328_/Y VGND VGND VPWR VPWR _8418_/B sky130_fd_sc_hd__clkbuf_2
XFILLER_43_410 VGND VGND VPWR VPWR sky130_fd_sc_hd__decap_3
XFILLER_16_624 VGND VGND VPWR VPWR sky130_fd_sc_hd__fill_2
Xmax_cap65 _8218_/A VGND VGND VPWR VPWR _8397_/A sky130_fd_sc_hd__buf_2
XFILLER_83_590 VGND VGND VPWR VPWR sky130_fd_sc_hd__fill_1
XFILLER_55_281 VGND VGND VPWR VPWR sky130_fd_sc_hd__fill_1
Xmax_cap87 _7946_/A VGND VGND VPWR VPWR _8047_/S sky130_fd_sc_hd__buf_2
XTAP_TAPCELL_ROW_26_630 VGND VPWR sky130_fd_sc_hd__tapvpwrvgnd_1
Xmax_cap98 _7763_/B VGND VGND VPWR VPWR _5631_/B sky130_fd_sc_hd__buf_2
XFILLER_15_145 VGND VGND VPWR VPWR sky130_fd_sc_hd__decap_3
XFILLER_43_476 VGND VGND VPWR VPWR sky130_fd_sc_hd__fill_1
XFILLER_43_487 VGND VGND VPWR VPWR sky130_fd_sc_hd__decap_3
XFILLER_62_41 VGND VGND VPWR VPWR sky130_fd_sc_hd__decap_3
XFILLER_30_104 VGND VGND VPWR VPWR sky130_fd_sc_hd__decap_3
XTAP_TAPCELL_ROW_100_1625 VGND VPWR sky130_fd_sc_hd__tapvpwrvgnd_1
XFILLER_30_137 VGND VGND VPWR VPWR sky130_fd_sc_hd__decap_3
XFILLER_24_690 VGND VGND VPWR VPWR sky130_fd_sc_hd__decap_3
XTAP_TAPCELL_ROW_100_1636 VGND VPWR sky130_fd_sc_hd__tapvpwrvgnd_1
XFILLER_62_96 VGND VGND VPWR VPWR sky130_fd_sc_hd__decap_3
XFILLER_11_340 VGND VGND VPWR VPWR sky130_fd_sc_hd__decap_3
Xwire220 wire220/A VGND VGND VPWR VPWR result_out[8] sky130_fd_sc_hd__buf_4
Xwire231 wire231/A VGND VGND VPWR VPWR result_out[12] sky130_fd_sc_hd__buf_4
XFILLER_7_36 VGND VGND VPWR VPWR sky130_fd_sc_hd__decap_3
XFILLER_129_559 VGND VGND VPWR VPWR sky130_fd_sc_hd__fill_1
XFILLER_125_710 VGND VGND VPWR VPWR sky130_fd_sc_hd__decap_3
XFILLER_7_388 VGND VGND VPWR VPWR sky130_fd_sc_hd__decap_3
XFILLER_7_399 VGND VGND VPWR VPWR sky130_fd_sc_hd__decap_3
XFILLER_125_732 VGND VGND VPWR VPWR sky130_fd_sc_hd__decap_3
XFILLER_125_765 VGND VGND VPWR VPWR sky130_fd_sc_hd__decap_3
XFILLER_98_605 VGND VGND VPWR VPWR sky130_fd_sc_hd__decap_3
XFILLER_124_242 VGND VGND VPWR VPWR sky130_fd_sc_hd__decap_3
XFILLER_124_253 VGND VGND VPWR VPWR sky130_fd_sc_hd__decap_3
XFILLER_98_638 VGND VGND VPWR VPWR sky130_fd_sc_hd__decap_3
XFILLER_3_561 VGND VGND VPWR VPWR sky130_fd_sc_hd__decap_3
XFILLER_3_572 VGND VGND VPWR VPWR sky130_fd_sc_hd__decap_3
XFILLER_30_6 VGND VGND VPWR VPWR sky130_fd_sc_hd__fill_1
XFILLER_112_437 VGND VGND VPWR VPWR sky130_fd_sc_hd__decap_3
Xload_slew236 _5283_/A VGND VGND VPWR VPWR _6302_/A sky130_fd_sc_hd__buf_4
XFILLER_112_459 VGND VGND VPWR VPWR sky130_fd_sc_hd__decap_3
Xload_slew247 _5059_/S VGND VGND VPWR VPWR _5197_/A sky130_fd_sc_hd__buf_4
Xload_slew258 _5361_/A1 VGND VGND VPWR VPWR _8174_/A sky130_fd_sc_hd__buf_6
XTAP_TAPCELL_ROW_111_1776 VGND VPWR sky130_fd_sc_hd__tapvpwrvgnd_1
XFILLER_38_237 VGND VGND VPWR VPWR sky130_fd_sc_hd__decap_3
XFILLER_54_708 VGND VGND VPWR VPWR sky130_fd_sc_hd__decap_3
XFILLER_93_354 VGND VGND VPWR VPWR sky130_fd_sc_hd__decap_3
XFILLER_66_579 VGND VGND VPWR VPWR sky130_fd_sc_hd__decap_3
XFILLER_93_376 VGND VGND VPWR VPWR sky130_fd_sc_hd__fill_2
X_5910_ _5765_/A _5766_/B _5768_/A _5768_/B VGND VGND VPWR VPWR _5911_/C sky130_fd_sc_hd__o211a_2
X_6890_ wire91/X _6890_/B VGND VGND VPWR VPWR _6891_/B sky130_fd_sc_hd__xnor2_2
XFILLER_34_421 VGND VGND VPWR VPWR sky130_fd_sc_hd__decap_3
XFILLER_62_752 VGND VGND VPWR VPWR sky130_fd_sc_hd__decap_3
X_5841_ _5841_/A _5841_/B VGND VGND VPWR VPWR _5842_/B sky130_fd_sc_hd__xnor2_2
XFILLER_62_774 VGND VGND VPWR VPWR sky130_fd_sc_hd__decap_3
XFILLER_22_616 VGND VGND VPWR VPWR sky130_fd_sc_hd__decap_3
XTAP_TAPCELL_ROW_62_1119 VGND VPWR sky130_fd_sc_hd__tapvpwrvgnd_1
XFILLER_61_284 VGND VGND VPWR VPWR sky130_fd_sc_hd__decap_3
X_5772_ _5642_/A _5642_/B _5773_/B VGND VGND VPWR VPWR _5772_/X sky130_fd_sc_hd__o21a_2
X_8560_ _8560_/A _8560_/B VGND VGND VPWR VPWR _8560_/Y sky130_fd_sc_hd__xnor2_2
XFILLER_21_137 VGND VGND VPWR VPWR sky130_fd_sc_hd__decap_3
X_4723_ hold906/X _4723_/A1 _4735_/S VGND VGND VPWR VPWR _4724_/A sky130_fd_sc_hd__mux2_2
X_7511_ _7508_/A _7262_/X _7508_/B _7510_/X VGND VGND VPWR VPWR _7511_/X sky130_fd_sc_hd__a22o_4
X_8491_ _9223_/Q wire67/X _8490_/X VGND VGND VPWR VPWR _8492_/B sky130_fd_sc_hd__a21oi_2
X_7442_ _7299_/A _7440_/X _7441_/X VGND VGND VPWR VPWR _7458_/A sky130_fd_sc_hd__a21o_2
X_4654_ _9076_/Q hold920/X _4672_/S VGND VGND VPWR VPWR _4654_/X sky130_fd_sc_hd__mux2_2
XFILLER_116_710 VGND VGND VPWR VPWR sky130_fd_sc_hd__decap_3
X_7373_ _7373_/A _7373_/B VGND VGND VPWR VPWR _7387_/A sky130_fd_sc_hd__xnor2_2
XFILLER_128_570 VGND VGND VPWR VPWR sky130_fd_sc_hd__decap_3
X_4585_ _9044_/Q hold983/X _4587_/S VGND VGND VPWR VPWR _4585_/X sky130_fd_sc_hd__mux2_2
Xhold801 _9193_/Q VGND VGND VPWR VPWR hold801/X sky130_fd_sc_hd__dlygate4sd3_1
Xhold812 _6859_/A VGND VGND VPWR VPWR hold812/X sky130_fd_sc_hd__dlygate4sd3_1
XFILLER_128_592 VGND VGND VPWR VPWR sky130_fd_sc_hd__decap_3
Xhold823 _5337_/Y VGND VGND VPWR VPWR _5338_/B sky130_fd_sc_hd__dlygate4sd3_1
X_6324_ _6325_/D _6325_/C _6325_/B _6325_/A VGND VGND VPWR VPWR _6363_/C sky130_fd_sc_hd__a31o_4
Xhold834 _8955_/X VGND VGND VPWR VPWR _8956_/A sky130_fd_sc_hd__dlygate4sd3_1
X_9112_ _9159_/CLK _9112_/D fanout391/X VGND VGND VPWR VPWR _9112_/Q sky130_fd_sc_hd__dfrtp_2
XFILLER_115_231 VGND VGND VPWR VPWR sky130_fd_sc_hd__decap_3
XFILLER_89_605 VGND VGND VPWR VPWR sky130_fd_sc_hd__decap_3
XFILLER_107_15 VGND VGND VPWR VPWR sky130_fd_sc_hd__decap_3
Xhold856 _9316_/Q VGND VGND VPWR VPWR hold856/X sky130_fd_sc_hd__dlygate4sd3_1
Xhold867 _9261_/Q VGND VGND VPWR VPWR hold867/X sky130_fd_sc_hd__dlygate4sd3_1
Xhold878 _9276_/Q VGND VGND VPWR VPWR hold878/X sky130_fd_sc_hd__dlygate4sd3_1
X_9043_ _9343_/CLK _9043_/D load_slew397/X VGND VGND VPWR VPWR _9043_/Q sky130_fd_sc_hd__dfrtp_2
X_6255_ _9206_/Q _8232_/A _6252_/X _6253_/Y _6254_/X VGND VGND VPWR VPWR _6255_/X
+ sky130_fd_sc_hd__a32o_2
Xhold889 _4606_/X VGND VGND VPWR VPWR _4607_/A sky130_fd_sc_hd__dlygate4sd3_1
XFILLER_88_126 VGND VGND VPWR VPWR sky130_fd_sc_hd__decap_3
XFILLER_130_212 VGND VGND VPWR VPWR sky130_fd_sc_hd__decap_3
XFILLER_115_297 VGND VGND VPWR VPWR sky130_fd_sc_hd__fill_2
XFILLER_130_234 VGND VGND VPWR VPWR sky130_fd_sc_hd__decap_3
X_5206_ _7313_/A _7313_/B _5016_/B VGND VGND VPWR VPWR _5255_/B sky130_fd_sc_hd__a21o_2
XFILLER_88_148 VGND VGND VPWR VPWR sky130_fd_sc_hd__decap_3
X_6186_ _6186_/A _6186_/B VGND VGND VPWR VPWR _6188_/A sky130_fd_sc_hd__nand2_2
XFILLER_130_256 VGND VGND VPWR VPWR sky130_fd_sc_hd__decap_3
XFILLER_97_682 VGND VGND VPWR VPWR sky130_fd_sc_hd__decap_3
X_5137_ _5137_/A VGND VGND VPWR VPWR _5137_/X sky130_fd_sc_hd__buf_6
XTAP_TAPCELL_ROW_4_336 VGND VPWR sky130_fd_sc_hd__tapvpwrvgnd_1
XFILLER_111_470 VGND VGND VPWR VPWR sky130_fd_sc_hd__fill_2
XFILLER_57_535 VGND VGND VPWR VPWR sky130_fd_sc_hd__decap_3
XFILLER_123_36 VGND VGND VPWR VPWR sky130_fd_sc_hd__decap_3
XFILLER_111_492 VGND VGND VPWR VPWR sky130_fd_sc_hd__decap_3
XFILLER_29_248 VGND VGND VPWR VPWR sky130_fd_sc_hd__fill_1
XFILLER_57_568 VGND VGND VPWR VPWR sky130_fd_sc_hd__decap_3
XFILLER_45_708 VGND VGND VPWR VPWR sky130_fd_sc_hd__decap_3
X_5068_ _9068_/Q _9132_/Q _5739_/S VGND VGND VPWR VPWR _5068_/X sky130_fd_sc_hd__mux2_2
XFILLER_84_365 VGND VGND VPWR VPWR sky130_fd_sc_hd__fill_1
XFILLER_38_760 VGND VGND VPWR VPWR sky130_fd_sc_hd__decap_3
XFILLER_123_69 VGND VGND VPWR VPWR sky130_fd_sc_hd__decap_3
XFILLER_44_218 VGND VGND VPWR VPWR sky130_fd_sc_hd__decap_3
XFILLER_16_12 VGND VGND VPWR VPWR sky130_fd_sc_hd__decap_3
XFILLER_37_281 VGND VGND VPWR VPWR sky130_fd_sc_hd__decap_3
XFILLER_25_443 VGND VGND VPWR VPWR sky130_fd_sc_hd__decap_3
X_8827_ hold937/X _8827_/A1 _8841_/S VGND VGND VPWR VPWR _8828_/A sky130_fd_sc_hd__mux2_2
XFILLER_16_56 VGND VGND VPWR VPWR sky130_fd_sc_hd__decap_3
XFILLER_52_251 VGND VGND VPWR VPWR sky130_fd_sc_hd__fill_1
XPHY_EDGE_ROW_0_Right_0 VGND VGND VPWR VPWR sky130_fd_sc_hd__decap_3
XFILLER_80_582 VGND VGND VPWR VPWR sky130_fd_sc_hd__decap_3
XFILLER_25_498 VGND VGND VPWR VPWR sky130_fd_sc_hd__decap_3
X_8758_ _8758_/A _8758_/B VGND VGND VPWR VPWR _8758_/Y sky130_fd_sc_hd__nor2_2
XTAP_TAPCELL_ROW_51_964 VGND VPWR sky130_fd_sc_hd__tapvpwrvgnd_1
XFILLER_32_11 VGND VGND VPWR VPWR sky130_fd_sc_hd__fill_2
XFILLER_12_159 VGND VGND VPWR VPWR sky130_fd_sc_hd__decap_3
X_7709_ _7893_/A _7893_/C VGND VGND VPWR VPWR _7737_/B sky130_fd_sc_hd__nand2_2
XTAP_TAPCELL_ROW_51_975 VGND VPWR sky130_fd_sc_hd__tapvpwrvgnd_1
XFILLER_32_22 VGND VGND VPWR VPWR sky130_fd_sc_hd__decap_3
XFILLER_32_44 VGND VGND VPWR VPWR sky130_fd_sc_hd__decap_3
XFILLER_21_671 VGND VGND VPWR VPWR sky130_fd_sc_hd__fill_1
XFILLER_21_682 VGND VGND VPWR VPWR sky130_fd_sc_hd__decap_3
XFILLER_32_77 VGND VGND VPWR VPWR sky130_fd_sc_hd__decap_3
XFILLER_32_88 VGND VGND VPWR VPWR sky130_fd_sc_hd__decap_3
XFILLER_126_507 VGND VGND VPWR VPWR sky130_fd_sc_hd__decap_3
XFILLER_20_192 VGND VGND VPWR VPWR sky130_fd_sc_hd__decap_3
XFILLER_126_518 VGND VGND VPWR VPWR sky130_fd_sc_hd__decap_3
XPHY_EDGE_ROW_73_Left_204 VGND VGND VPWR VPWR sky130_fd_sc_hd__decap_3
XFILLER_107_710 VGND VGND VPWR VPWR sky130_fd_sc_hd__decap_3
XFILLER_113_3 VGND VGND VPWR VPWR sky130_fd_sc_hd__decap_3
XFILLER_107_732 VGND VGND VPWR VPWR sky130_fd_sc_hd__decap_3
XFILLER_106_231 VGND VGND VPWR VPWR sky130_fd_sc_hd__decap_3
XFILLER_122_724 VGND VGND VPWR VPWR sky130_fd_sc_hd__decap_3
XFILLER_106_286 VGND VGND VPWR VPWR sky130_fd_sc_hd__decap_3
XFILLER_0_520 VGND VGND VPWR VPWR sky130_fd_sc_hd__decap_3
XFILLER_122_757 VGND VGND VPWR VPWR sky130_fd_sc_hd__decap_3
XFILLER_121_223 VGND VGND VPWR VPWR sky130_fd_sc_hd__fill_1
XFILLER_79_148 VGND VGND VPWR VPWR sky130_fd_sc_hd__fill_1
XFILLER_0_542 VGND VGND VPWR VPWR sky130_fd_sc_hd__decap_3
XFILLER_95_608 VGND VGND VPWR VPWR sky130_fd_sc_hd__decap_3
XFILLER_0_564 VGND VGND VPWR VPWR sky130_fd_sc_hd__decap_3
XFILLER_48_502 VGND VGND VPWR VPWR sky130_fd_sc_hd__decap_3
XFILLER_88_682 VGND VGND VPWR VPWR sky130_fd_sc_hd__decap_3
XFILLER_57_30 VGND VGND VPWR VPWR sky130_fd_sc_hd__decap_3
XFILLER_102_470 VGND VGND VPWR VPWR sky130_fd_sc_hd__decap_3
XFILLER_48_524 VGND VGND VPWR VPWR sky130_fd_sc_hd__decap_3
XFILLER_87_181 VGND VGND VPWR VPWR sky130_fd_sc_hd__decap_3
XFILLER_48_557 VGND VGND VPWR VPWR sky130_fd_sc_hd__decap_3
XPHY_EDGE_ROW_82_Left_213 VGND VGND VPWR VPWR sky130_fd_sc_hd__decap_3
XFILLER_29_760 VGND VGND VPWR VPWR sky130_fd_sc_hd__decap_3
XFILLER_63_527 VGND VGND VPWR VPWR sky130_fd_sc_hd__decap_3
XFILLER_90_324 VGND VGND VPWR VPWR sky130_fd_sc_hd__decap_3
XFILLER_28_270 VGND VGND VPWR VPWR sky130_fd_sc_hd__fill_2
XFILLER_63_549 VGND VGND VPWR VPWR sky130_fd_sc_hd__decap_3
XPHY_EDGE_ROW_121_Right_121 VGND VGND VPWR VPWR sky130_fd_sc_hd__decap_3
XFILLER_90_368 VGND VGND VPWR VPWR sky130_fd_sc_hd__decap_3
XFILLER_44_763 VGND VGND VPWR VPWR sky130_fd_sc_hd__fill_1
XFILLER_43_262 VGND VGND VPWR VPWR sky130_fd_sc_hd__fill_1
XFILLER_71_582 VGND VGND VPWR VPWR sky130_fd_sc_hd__fill_2
XFILLER_43_284 VGND VGND VPWR VPWR sky130_fd_sc_hd__decap_3
XPHY_EDGE_ROW_91_Left_222 VGND VGND VPWR VPWR sky130_fd_sc_hd__decap_3
XFILLER_78_6 VGND VGND VPWR VPWR sky130_fd_sc_hd__decap_3
XFILLER_8_697 VGND VGND VPWR VPWR sky130_fd_sc_hd__decap_3
XTAP_TAPCELL_ROW_113_1805 VGND VPWR sky130_fd_sc_hd__tapvpwrvgnd_1
XTAP_TAPCELL_ROW_59_1081 VGND VPWR sky130_fd_sc_hd__tapvpwrvgnd_1
XFILLER_125_573 VGND VGND VPWR VPWR sky130_fd_sc_hd__decap_3
X_6040_ _5165_/A _5165_/B _6963_/C VGND VGND VPWR VPWR _6041_/A sky130_fd_sc_hd__a21o_2
XFILLER_98_468 VGND VGND VPWR VPWR sky130_fd_sc_hd__decap_3
XFILLER_79_671 VGND VGND VPWR VPWR sky130_fd_sc_hd__fill_1
XFILLER_66_321 VGND VGND VPWR VPWR sky130_fd_sc_hd__decap_3
XFILLER_66_354 VGND VGND VPWR VPWR sky130_fd_sc_hd__decap_3
XFILLER_66_365 VGND VGND VPWR VPWR sky130_fd_sc_hd__decap_3
X_7991_ _7991_/A _8119_/A VGND VGND VPWR VPWR _7991_/Y sky130_fd_sc_hd__xnor2_2
XFILLER_93_162 VGND VGND VPWR VPWR sky130_fd_sc_hd__decap_3
XFILLER_26_218 VGND VGND VPWR VPWR sky130_fd_sc_hd__decap_3
XFILLER_94_696 VGND VGND VPWR VPWR sky130_fd_sc_hd__decap_3
XFILLER_81_313 VGND VGND VPWR VPWR sky130_fd_sc_hd__fill_2
X_6942_ _6942_/A _8406_/A VGND VGND VPWR VPWR _7924_/B sky130_fd_sc_hd__nand2_2
XFILLER_81_335 VGND VGND VPWR VPWR sky130_fd_sc_hd__fill_1
XFILLER_19_281 VGND VGND VPWR VPWR sky130_fd_sc_hd__decap_3
XTAP_TAPCELL_ROW_124_1956 VGND VPWR sky130_fd_sc_hd__tapvpwrvgnd_1
XFILLER_81_368 VGND VGND VPWR VPWR sky130_fd_sc_hd__decap_3
X_6873_ _6873_/A _7170_/S VGND VGND VPWR VPWR _6873_/Y sky130_fd_sc_hd__xnor2_2
XFILLER_62_560 VGND VGND VPWR VPWR sky130_fd_sc_hd__decap_3
XFILLER_34_251 VGND VGND VPWR VPWR sky130_fd_sc_hd__fill_1
XFILLER_50_711 VGND VGND VPWR VPWR sky130_fd_sc_hd__decap_3
XFILLER_22_402 VGND VGND VPWR VPWR sky130_fd_sc_hd__decap_3
X_8612_ _8581_/Y _8656_/A _8739_/B VGND VGND VPWR VPWR _8612_/X sky130_fd_sc_hd__a21o_2
X_5824_ _5824_/A1 _5071_/Y _5719_/A VGND VGND VPWR VPWR _6042_/A sky130_fd_sc_hd__a21o_2
XFILLER_50_766 VGND VGND VPWR VPWR sky130_fd_sc_hd__decap_3
X_5755_ _6765_/A _7773_/A _5753_/A VGND VGND VPWR VPWR _5755_/Y sky130_fd_sc_hd__a21oi_2
X_8543_ _8543_/A _8633_/B VGND VGND VPWR VPWR _8543_/X sky130_fd_sc_hd__xor2_2
X_4706_ _9101_/Q _4706_/A1 _4714_/S VGND VGND VPWR VPWR _4706_/X sky130_fd_sc_hd__mux2_2
X_5686_ _9205_/Q VGND VGND VPWR VPWR _5687_/B sky130_fd_sc_hd__inv_2
X_8474_ _9223_/Q _6749_/X _8431_/A _9222_/Q VGND VGND VPWR VPWR _8474_/Y sky130_fd_sc_hd__a211oi_2
X_4637_ _4637_/A VGND VGND VPWR VPWR _9068_/D sky130_fd_sc_hd__buf_1
X_7425_ _7602_/A _7602_/B VGND VGND VPWR VPWR _7426_/B sky130_fd_sc_hd__xnor2_2
XTAP_TAPCELL_ROW_9_406 VGND VPWR sky130_fd_sc_hd__tapvpwrvgnd_1
XFILLER_118_47 VGND VGND VPWR VPWR sky130_fd_sc_hd__decap_3
X_4568_ _9015_/S VGND VGND VPWR VPWR _4587_/S sky130_fd_sc_hd__clkbuf_2
X_7356_ _7357_/A _7357_/C _7357_/B VGND VGND VPWR VPWR _7356_/Y sky130_fd_sc_hd__a21oi_2
XFILLER_78_18 VGND VGND VPWR VPWR sky130_fd_sc_hd__fill_1
XFILLER_116_562 VGND VGND VPWR VPWR sky130_fd_sc_hd__decap_3
XFILLER_104_713 VGND VGND VPWR VPWR sky130_fd_sc_hd__decap_3
X_6307_ _7313_/A _7313_/B _7430_/C VGND VGND VPWR VPWR _6308_/B sky130_fd_sc_hd__a21oi_2
XFILLER_104_735 VGND VGND VPWR VPWR sky130_fd_sc_hd__decap_3
X_7287_ _7287_/A _7287_/B _7287_/C VGND VGND VPWR VPWR _7287_/Y sky130_fd_sc_hd__nor3_2
XFILLER_89_435 VGND VGND VPWR VPWR sky130_fd_sc_hd__decap_3
X_6238_ _9158_/Q _6756_/C _5446_/A VGND VGND VPWR VPWR _6239_/C sky130_fd_sc_hd__a21o_2
X_9026_ _9344_/CLK _9026_/D fanout379/X VGND VGND VPWR VPWR _9026_/Q sky130_fd_sc_hd__dfrtp_2
XFILLER_89_468 VGND VGND VPWR VPWR sky130_fd_sc_hd__decap_3
XFILLER_103_256 VGND VGND VPWR VPWR sky130_fd_sc_hd__decap_3
X_6169_ _6172_/A _6169_/B _6172_/C VGND VGND VPWR VPWR _6169_/Y sky130_fd_sc_hd__nand3_2
XFILLER_57_332 VGND VGND VPWR VPWR sky130_fd_sc_hd__decap_3
XFILLER_85_663 VGND VGND VPWR VPWR sky130_fd_sc_hd__decap_3
XFILLER_45_505 VGND VGND VPWR VPWR sky130_fd_sc_hd__decap_3
XFILLER_18_719 VGND VGND VPWR VPWR sky130_fd_sc_hd__decap_3
XFILLER_17_207 VGND VGND VPWR VPWR sky130_fd_sc_hd__decap_3
XTAP_TAPCELL_ROW_86_1439 VGND VPWR sky130_fd_sc_hd__tapvpwrvgnd_1
XFILLER_84_195 VGND VGND VPWR VPWR sky130_fd_sc_hd__fill_1
XFILLER_26_741 VGND VGND VPWR VPWR sky130_fd_sc_hd__decap_3
XFILLER_27_88 VGND VGND VPWR VPWR sky130_fd_sc_hd__decap_3
XFILLER_60_508 VGND VGND VPWR VPWR sky130_fd_sc_hd__decap_3
XFILLER_26_763 VGND VGND VPWR VPWR sky130_fd_sc_hd__decap_3
XFILLER_41_700 VGND VGND VPWR VPWR sky130_fd_sc_hd__decap_3
XFILLER_25_273 VGND VGND VPWR VPWR sky130_fd_sc_hd__decap_3
XFILLER_41_755 VGND VGND VPWR VPWR sky130_fd_sc_hd__decap_3
XFILLER_40_243 VGND VGND VPWR VPWR sky130_fd_sc_hd__fill_1
XFILLER_9_417 VGND VGND VPWR VPWR sky130_fd_sc_hd__decap_3
XFILLER_13_468 VGND VGND VPWR VPWR sky130_fd_sc_hd__decap_3
XFILLER_40_265 VGND VGND VPWR VPWR sky130_fd_sc_hd__decap_3
Xclkbuf_leaf_20_clk clkbuf_leaf_9_clk/A VGND VGND VPWR VPWR _9348_/CLK sky130_fd_sc_hd__clkbuf_8
XFILLER_126_304 VGND VGND VPWR VPWR sky130_fd_sc_hd__decap_3
XFILLER_5_634 VGND VGND VPWR VPWR sky130_fd_sc_hd__decap_3
XFILLER_4_100 VGND VGND VPWR VPWR sky130_fd_sc_hd__decap_3
XFILLER_4_15 VGND VGND VPWR VPWR sky130_fd_sc_hd__decap_3
XFILLER_107_573 VGND VGND VPWR VPWR sky130_fd_sc_hd__decap_3
XFILLER_122_510 VGND VGND VPWR VPWR sky130_fd_sc_hd__decap_3
XFILLER_68_608 VGND VGND VPWR VPWR sky130_fd_sc_hd__decap_3
XFILLER_122_554 VGND VGND VPWR VPWR sky130_fd_sc_hd__decap_3
XFILLER_95_405 VGND VGND VPWR VPWR sky130_fd_sc_hd__decap_3
XFILLER_122_576 VGND VGND VPWR VPWR sky130_fd_sc_hd__decap_3
XTAP_TAPCELL_ROW_128_2012 VGND VPWR sky130_fd_sc_hd__tapvpwrvgnd_1
XFILLER_122_587 VGND VGND VPWR VPWR sky130_fd_sc_hd__fill_1
XFILLER_122_598 VGND VGND VPWR VPWR sky130_fd_sc_hd__decap_3
XFILLER_95_449 VGND VGND VPWR VPWR sky130_fd_sc_hd__decap_3
XFILLER_76_630 VGND VGND VPWR VPWR sky130_fd_sc_hd__decap_3
XFILLER_75_140 VGND VGND VPWR VPWR sky130_fd_sc_hd__decap_3
XFILLER_36_505 VGND VGND VPWR VPWR sky130_fd_sc_hd__decap_3
XFILLER_91_633 VGND VGND VPWR VPWR sky130_fd_sc_hd__decap_3
XFILLER_63_346 VGND VGND VPWR VPWR sky130_fd_sc_hd__decap_3
XFILLER_17_741 VGND VGND VPWR VPWR sky130_fd_sc_hd__decap_3
XFILLER_17_774 VGND VGND VPWR VPWR sky130_fd_sc_hd__decap_3
XFILLER_16_262 VGND VGND VPWR VPWR sky130_fd_sc_hd__decap_3
XTAP_TAPCELL_ROW_34_739 VGND VPWR sky130_fd_sc_hd__tapvpwrvgnd_1
XFILLER_90_187 VGND VGND VPWR VPWR sky130_fd_sc_hd__decap_3
XFILLER_44_582 VGND VGND VPWR VPWR sky130_fd_sc_hd__decap_3
XFILLER_31_210 VGND VGND VPWR VPWR sky130_fd_sc_hd__decap_3
XFILLER_31_265 VGND VGND VPWR VPWR sky130_fd_sc_hd__decap_3
XTAP_TAPCELL_ROW_14_474 VGND VPWR sky130_fd_sc_hd__tapvpwrvgnd_1
X_5540_ _5537_/X _5539_/Y _6808_/S VGND VGND VPWR VPWR _5540_/X sky130_fd_sc_hd__mux2_2
XFILLER_31_298 VGND VGND VPWR VPWR sky130_fd_sc_hd__fill_2
XFILLER_129_131 VGND VGND VPWR VPWR sky130_fd_sc_hd__decap_3
Xclkbuf_leaf_11_clk clkload0/A VGND VGND VPWR VPWR _9293_/CLK sky130_fd_sc_hd__clkbuf_8
XFILLER_129_164 VGND VGND VPWR VPWR sky130_fd_sc_hd__decap_3
XFILLER_129_175 VGND VGND VPWR VPWR sky130_fd_sc_hd__decap_3
X_5471_ _6231_/B _9169_/Q _6232_/C VGND VGND VPWR VPWR _5471_/X sky130_fd_sc_hd__and3b_2
XFILLER_117_337 VGND VGND VPWR VPWR sky130_fd_sc_hd__decap_3
X_7210_ _7210_/A _7210_/B VGND VGND VPWR VPWR _7264_/B sky130_fd_sc_hd__xnor2_2
X_8190_ _8190_/A _8190_/B VGND VGND VPWR VPWR _8204_/A sky130_fd_sc_hd__nor2_2
XFILLER_99_722 VGND VGND VPWR VPWR sky130_fd_sc_hd__decap_3
X_7141_ _7272_/B _7285_/B VGND VGND VPWR VPWR _7141_/Y sky130_fd_sc_hd__nor2_2
Xfanout407 fanout407/A VGND VGND VPWR VPWR fanout407/X sky130_fd_sc_hd__clkdlybuf4s25_1
Xfanout418 input1/X VGND VGND VPWR VPWR fanout418/X sky130_fd_sc_hd__clkdlybuf4s25_1
XFILLER_59_608 VGND VGND VPWR VPWR sky130_fd_sc_hd__decap_3
XFILLER_113_554 VGND VGND VPWR VPWR sky130_fd_sc_hd__decap_3
X_7072_ _8309_/A _6957_/B _7070_/X _7071_/X VGND VGND VPWR VPWR _7301_/A sky130_fd_sc_hd__a31o_2
XFILLER_101_716 VGND VGND VPWR VPWR sky130_fd_sc_hd__decap_3
XTAP_TAPCELL_ROW_70_1229 VGND VPWR sky130_fd_sc_hd__tapvpwrvgnd_1
XFILLER_98_287 VGND VGND VPWR VPWR sky130_fd_sc_hd__decap_3
XFILLER_86_427 VGND VGND VPWR VPWR sky130_fd_sc_hd__decap_3
XFILLER_101_738 VGND VGND VPWR VPWR sky130_fd_sc_hd__fill_1
X_6023_ _6023_/A _6023_/B VGND VGND VPWR VPWR _6221_/B sky130_fd_sc_hd__xnor2_2
XFILLER_100_237 VGND VGND VPWR VPWR sky130_fd_sc_hd__decap_3
XFILLER_27_505 VGND VGND VPWR VPWR sky130_fd_sc_hd__fill_2
XFILLER_67_685 VGND VGND VPWR VPWR sky130_fd_sc_hd__decap_3
XFILLER_82_611 VGND VGND VPWR VPWR sky130_fd_sc_hd__decap_3
XFILLER_66_162 VGND VGND VPWR VPWR sky130_fd_sc_hd__decap_3
XFILLER_39_387 VGND VGND VPWR VPWR sky130_fd_sc_hd__decap_3
XFILLER_27_538 VGND VGND VPWR VPWR sky130_fd_sc_hd__decap_3
X_7974_ _8079_/B _7974_/B VGND VGND VPWR VPWR _7974_/Y sky130_fd_sc_hd__nor2_2
XFILLER_54_346 VGND VGND VPWR VPWR sky130_fd_sc_hd__decap_3
XFILLER_82_666 VGND VGND VPWR VPWR sky130_fd_sc_hd__decap_3
XFILLER_54_368 VGND VGND VPWR VPWR sky130_fd_sc_hd__decap_3
X_6925_ _6701_/B _6701_/C _6923_/X _6924_/X VGND VGND VPWR VPWR _7033_/B sky130_fd_sc_hd__a31o_4
XFILLER_42_519 VGND VGND VPWR VPWR sky130_fd_sc_hd__fill_2
XFILLER_120_15 VGND VGND VPWR VPWR sky130_fd_sc_hd__decap_3
XFILLER_35_582 VGND VGND VPWR VPWR sky130_fd_sc_hd__decap_3
XFILLER_23_722 VGND VGND VPWR VPWR sky130_fd_sc_hd__decap_3
XFILLER_23_744 VGND VGND VPWR VPWR sky130_fd_sc_hd__decap_3
X_6856_ _6856_/A VGND VGND VPWR VPWR _6856_/Y sky130_fd_sc_hd__inv_2
XFILLER_22_221 VGND VGND VPWR VPWR sky130_fd_sc_hd__decap_3
XFILLER_120_59 VGND VGND VPWR VPWR sky130_fd_sc_hd__decap_3
XFILLER_50_552 VGND VGND VPWR VPWR sky130_fd_sc_hd__decap_3
XFILLER_22_243 VGND VGND VPWR VPWR sky130_fd_sc_hd__decap_3
XTAP_TAPCELL_ROW_81_1369 VGND VPWR sky130_fd_sc_hd__tapvpwrvgnd_1
X_5807_ _5662_/B _5662_/A _5806_/X _5949_/B VGND VGND VPWR VPWR _5808_/B sky130_fd_sc_hd__a22o_2
X_6787_ _6458_/A _6785_/A _6785_/X _6510_/S _6786_/Y VGND VGND VPWR VPWR _6850_/A
+ sky130_fd_sc_hd__a221oi_4
XFILLER_22_276 VGND VGND VPWR VPWR sky130_fd_sc_hd__decap_3
XFILLER_13_24 VGND VGND VPWR VPWR sky130_fd_sc_hd__decap_3
XFILLER_10_416 VGND VGND VPWR VPWR sky130_fd_sc_hd__decap_3
XFILLER_22_298 VGND VGND VPWR VPWR sky130_fd_sc_hd__decap_3
X_8526_ _8389_/Y _8345_/A _8521_/S VGND VGND VPWR VPWR _8526_/Y sky130_fd_sc_hd__a21oi_2
X_5738_ _9263_/Q _9295_/Q _5738_/S VGND VGND VPWR VPWR _5738_/X sky130_fd_sc_hd__mux2_2
XFILLER_13_57 VGND VGND VPWR VPWR sky130_fd_sc_hd__fill_1
XFILLER_129_24 VGND VGND VPWR VPWR sky130_fd_sc_hd__decap_3
XFILLER_108_304 VGND VGND VPWR VPWR sky130_fd_sc_hd__fill_1
XFILLER_129_57 VGND VGND VPWR VPWR sky130_fd_sc_hd__decap_3
X_8457_ _8457_/A _8457_/B VGND VGND VPWR VPWR _8459_/C sky130_fd_sc_hd__nand2_2
X_5669_ _5669_/A _5669_/B VGND VGND VPWR VPWR _5671_/B sky130_fd_sc_hd__xnor2_2
XFILLER_89_39 VGND VGND VPWR VPWR sky130_fd_sc_hd__decap_3
X_7408_ _7408_/A _7408_/B VGND VGND VPWR VPWR _7408_/Y sky130_fd_sc_hd__nand2_2
X_8388_ _8388_/A _8388_/B VGND VGND VPWR VPWR _8388_/Y sky130_fd_sc_hd__xnor2_2
XFILLER_2_604 VGND VGND VPWR VPWR sky130_fd_sc_hd__decap_3
XFILLER_123_329 VGND VGND VPWR VPWR sky130_fd_sc_hd__decap_3
XFILLER_1_103 VGND VGND VPWR VPWR sky130_fd_sc_hd__decap_3
XFILLER_104_521 VGND VGND VPWR VPWR sky130_fd_sc_hd__fill_1
X_7339_ _7773_/A _7329_/C _8405_/B _7945_/A VGND VGND VPWR VPWR _7340_/C sky130_fd_sc_hd__a211o_2
XFILLER_8_6 VGND VGND VPWR VPWR sky130_fd_sc_hd__decap_3
XFILLER_89_221 VGND VGND VPWR VPWR sky130_fd_sc_hd__decap_3
XFILLER_2_637 VGND VGND VPWR VPWR sky130_fd_sc_hd__decap_3
XFILLER_2_648 VGND VGND VPWR VPWR sky130_fd_sc_hd__decap_3
XFILLER_1_125 VGND VGND VPWR VPWR sky130_fd_sc_hd__decap_3
Xmax_cap191 _6608_/C VGND VGND VPWR VPWR _6756_/B sky130_fd_sc_hd__clkbuf_4
XFILLER_104_565 VGND VGND VPWR VPWR sky130_fd_sc_hd__fill_2
XFILLER_89_265 VGND VGND VPWR VPWR sky130_fd_sc_hd__decap_3
XFILLER_89_287 VGND VGND VPWR VPWR sky130_fd_sc_hd__fill_1
X_9009_ _9009_/A0 _9329_/Q _9009_/S VGND VGND VPWR VPWR _9009_/X sky130_fd_sc_hd__mux2_2
XFILLER_77_449 VGND VGND VPWR VPWR sky130_fd_sc_hd__decap_3
XFILLER_58_630 VGND VGND VPWR VPWR sky130_fd_sc_hd__decap_3
XFILLER_92_408 VGND VGND VPWR VPWR sky130_fd_sc_hd__decap_3
XFILLER_58_674 VGND VGND VPWR VPWR sky130_fd_sc_hd__decap_3
Xhold1150 _9295_/Q VGND VGND VPWR VPWR _8938_/A1 sky130_fd_sc_hd__dlygate4sd3_1
XFILLER_45_302 VGND VGND VPWR VPWR sky130_fd_sc_hd__decap_3
Xhold1161 _4830_/X VGND VGND VPWR VPWR _4831_/A sky130_fd_sc_hd__dlygate4sd3_1
Xhold1172 _9044_/Q VGND VGND VPWR VPWR _4619_/A1 sky130_fd_sc_hd__dlygate4sd3_1
XFILLER_73_633 VGND VGND VPWR VPWR sky130_fd_sc_hd__decap_3
Xhold1183 _4727_/X VGND VGND VPWR VPWR _4728_/A sky130_fd_sc_hd__dlygate4sd3_1
Xhold1194 _9123_/Q VGND VGND VPWR VPWR _4786_/A1 sky130_fd_sc_hd__dlygate4sd3_1
XFILLER_73_666 VGND VGND VPWR VPWR sky130_fd_sc_hd__decap_3
XFILLER_54_20 VGND VGND VPWR VPWR sky130_fd_sc_hd__decap_3
XFILLER_33_508 VGND VGND VPWR VPWR sky130_fd_sc_hd__decap_3
XFILLER_73_699 VGND VGND VPWR VPWR sky130_fd_sc_hd__decap_3
XFILLER_14_722 VGND VGND VPWR VPWR sky130_fd_sc_hd__decap_3
XFILLER_60_338 VGND VGND VPWR VPWR sky130_fd_sc_hd__decap_3
XFILLER_26_593 VGND VGND VPWR VPWR sky130_fd_sc_hd__fill_1
XFILLER_13_210 VGND VGND VPWR VPWR sky130_fd_sc_hd__decap_3
XFILLER_14_755 VGND VGND VPWR VPWR sky130_fd_sc_hd__fill_1
XFILLER_14_766 VGND VGND VPWR VPWR sky130_fd_sc_hd__decap_3
XFILLER_9_225 VGND VGND VPWR VPWR sky130_fd_sc_hd__decap_3
XTAP_TAPCELL_ROW_99_1619 VGND VPWR sky130_fd_sc_hd__tapvpwrvgnd_1
XTAP_TAPCELL_ROW_11_433 VGND VPWR sky130_fd_sc_hd__tapvpwrvgnd_1
XFILLER_127_613 VGND VGND VPWR VPWR sky130_fd_sc_hd__decap_3
Xclkload17 _9142_/CLK VGND VGND VPWR VPWR clkload17/X sky130_fd_sc_hd__clkbuf_4
Xclkload28 _9334_/CLK VGND VGND VPWR VPWR clkload28/X sky130_fd_sc_hd__clkbuf_4
XFILLER_127_635 VGND VGND VPWR VPWR sky130_fd_sc_hd__decap_3
XFILLER_126_112 VGND VGND VPWR VPWR sky130_fd_sc_hd__decap_3
XFILLER_127_668 VGND VGND VPWR VPWR sky130_fd_sc_hd__decap_3
Xrebuffer580 _8385_/B VGND VGND VPWR VPWR _8384_/B sky130_fd_sc_hd__buf_2
XFILLER_127_679 VGND VGND VPWR VPWR sky130_fd_sc_hd__decap_3
XFILLER_126_156 VGND VGND VPWR VPWR sky130_fd_sc_hd__decap_3
Xrebuffer591 _6249_/A VGND VGND VPWR VPWR _5894_/B1 sky130_fd_sc_hd__buf_2
XFILLER_119_90 VGND VGND VPWR VPWR sky130_fd_sc_hd__decap_3
XFILLER_126_189 VGND VGND VPWR VPWR sky130_fd_sc_hd__decap_3
XFILLER_5_497 VGND VGND VPWR VPWR sky130_fd_sc_hd__decap_3
XTAP_TAPCELL_ROW_56_1040 VGND VPWR sky130_fd_sc_hd__tapvpwrvgnd_1
XFILLER_79_72 VGND VGND VPWR VPWR sky130_fd_sc_hd__fill_2
XFILLER_122_340 VGND VGND VPWR VPWR sky130_fd_sc_hd__fill_2
XFILLER_68_449 VGND VGND VPWR VPWR sky130_fd_sc_hd__decap_3
XTAP_TAPCELL_ROW_39_809 VGND VPWR sky130_fd_sc_hd__tapvpwrvgnd_1
XFILLER_95_268 VGND VGND VPWR VPWR sky130_fd_sc_hd__decap_3
Xclkbuf_leaf_0_clk clkload0/A VGND VGND VPWR VPWR _9308_/CLK sky130_fd_sc_hd__clkbuf_8
XFILLER_76_460 VGND VGND VPWR VPWR sky130_fd_sc_hd__fill_1
XFILLER_49_685 VGND VGND VPWR VPWR sky130_fd_sc_hd__decap_3
XFILLER_49_696 VGND VGND VPWR VPWR sky130_fd_sc_hd__decap_3
XTAP_TAPCELL_ROW_108_1737 VGND VPWR sky130_fd_sc_hd__tapvpwrvgnd_1
XFILLER_76_493 VGND VGND VPWR VPWR sky130_fd_sc_hd__decap_3
XFILLER_48_195 VGND VGND VPWR VPWR sky130_fd_sc_hd__fill_1
XTAP_TAPCELL_ROW_19_533 VGND VPWR sky130_fd_sc_hd__tapvpwrvgnd_1
XTAP_TAPCELL_ROW_19_544 VGND VPWR sky130_fd_sc_hd__tapvpwrvgnd_1
X_4971_ _4972_/A1 _4968_/S _5044_/B _4631_/A _5033_/A VGND VGND VPWR VPWR _4971_/X
+ sky130_fd_sc_hd__a32o_2
XTAP_TAPCELL_ROW_121_1915 VGND VPWR sky130_fd_sc_hd__tapvpwrvgnd_1
X_6710_ _7071_/A _6711_/C _7071_/B _5388_/Y VGND VGND VPWR VPWR _6710_/X sky130_fd_sc_hd__a22o_2
XTAP_TAPCELL_ROW_67_1180 VGND VPWR sky130_fd_sc_hd__tapvpwrvgnd_1
XTAP_TAPCELL_ROW_67_1191 VGND VPWR sky130_fd_sc_hd__tapvpwrvgnd_1
XFILLER_51_349 VGND VGND VPWR VPWR sky130_fd_sc_hd__decap_3
X_7690_ _7548_/A _7689_/X _7547_/B VGND VGND VPWR VPWR _7692_/A sky130_fd_sc_hd__a21oi_2
X_6641_ _6643_/A VGND VGND VPWR VPWR _6642_/A sky130_fd_sc_hd__inv_2
XFILLER_20_725 VGND VGND VPWR VPWR sky130_fd_sc_hd__decap_3
X_6572_ _6573_/B1 _5844_/X _6570_/X _6571_/X VGND VGND VPWR VPWR _6695_/C sky130_fd_sc_hd__a211o_2
XFILLER_20_769 VGND VGND VPWR VPWR sky130_fd_sc_hd__decap_3
XFILLER_118_613 VGND VGND VPWR VPWR sky130_fd_sc_hd__fill_1
X_8311_ _8416_/A _8311_/B VGND VGND VPWR VPWR _8402_/B sky130_fd_sc_hd__or2_2
X_5523_ _5524_/A _5524_/B _5524_/C VGND VGND VPWR VPWR _5528_/B sky130_fd_sc_hd__a21oi_2
X_9291_ _9339_/CLK _9291_/D load_slew384/X VGND VGND VPWR VPWR _9291_/Q sky130_fd_sc_hd__dfrtp_2
XFILLER_8_280 VGND VGND VPWR VPWR sky130_fd_sc_hd__decap_3
XFILLER_118_657 VGND VGND VPWR VPWR sky130_fd_sc_hd__decap_3
XTAP_TAPCELL_ROW_119_1888 VGND VPWR sky130_fd_sc_hd__tapvpwrvgnd_1
X_5454_ _5346_/A _5346_/B _5453_/X VGND VGND VPWR VPWR _5482_/A sky130_fd_sc_hd__o21a_2
X_8242_ _8242_/A _8410_/S VGND VGND VPWR VPWR _8243_/B sky130_fd_sc_hd__nor2_2
XFILLER_118_679 VGND VGND VPWR VPWR sky130_fd_sc_hd__decap_3
XFILLER_105_318 VGND VGND VPWR VPWR sky130_fd_sc_hd__fill_1
XFILLER_117_178 VGND VGND VPWR VPWR sky130_fd_sc_hd__decap_3
XFILLER_117_189 VGND VGND VPWR VPWR sky130_fd_sc_hd__decap_3
X_5385_ _5383_/Y _5384_/X _5463_/C _5464_/A1 VGND VGND VPWR VPWR _5386_/A sky130_fd_sc_hd__o211a_2
X_8173_ _8058_/B _8057_/A _8172_/X VGND VGND VPWR VPWR _8177_/A sky130_fd_sc_hd__a21oi_2
XFILLER_126_690 VGND VGND VPWR VPWR sky130_fd_sc_hd__decap_3
X_7124_ _7124_/A _7124_/B VGND VGND VPWR VPWR _7377_/B sky130_fd_sc_hd__xnor2_2
XFILLER_87_714 VGND VGND VPWR VPWR sky130_fd_sc_hd__decap_3
XFILLER_59_405 VGND VGND VPWR VPWR sky130_fd_sc_hd__decap_3
XFILLER_115_15 VGND VGND VPWR VPWR sky130_fd_sc_hd__decap_3
XFILLER_113_373 VGND VGND VPWR VPWR sky130_fd_sc_hd__decap_3
X_7055_ _7055_/A _7055_/B VGND VGND VPWR VPWR _7357_/B sky130_fd_sc_hd__xnor2_2
Xfanout259 fanout265/A VGND VGND VPWR VPWR _5187_/C sky130_fd_sc_hd__buf_4
XFILLER_115_48 VGND VGND VPWR VPWR sky130_fd_sc_hd__decap_3
XFILLER_75_19 VGND VGND VPWR VPWR sky130_fd_sc_hd__decap_3
X_6006_ _6007_/A _6007_/B VGND VGND VPWR VPWR _6149_/A sky130_fd_sc_hd__nor2_2
XFILLER_39_140 VGND VGND VPWR VPWR sky130_fd_sc_hd__fill_1
XFILLER_86_279 VGND VGND VPWR VPWR sky130_fd_sc_hd__fill_2
XFILLER_39_151 VGND VGND VPWR VPWR sky130_fd_sc_hd__decap_3
XFILLER_67_493 VGND VGND VPWR VPWR sky130_fd_sc_hd__fill_2
XFILLER_55_633 VGND VGND VPWR VPWR sky130_fd_sc_hd__decap_3
XFILLER_82_430 VGND VGND VPWR VPWR sky130_fd_sc_hd__decap_3
XFILLER_27_346 VGND VGND VPWR VPWR sky130_fd_sc_hd__fill_2
XFILLER_82_452 VGND VGND VPWR VPWR sky130_fd_sc_hd__decap_3
XFILLER_15_519 VGND VGND VPWR VPWR sky130_fd_sc_hd__decap_3
X_7957_ _8154_/A _8232_/A _8312_/A _8313_/A VGND VGND VPWR VPWR _7957_/X sky130_fd_sc_hd__and4_2
XFILLER_55_699 VGND VGND VPWR VPWR sky130_fd_sc_hd__fill_1
XFILLER_82_496 VGND VGND VPWR VPWR sky130_fd_sc_hd__fill_1
XFILLER_70_636 VGND VGND VPWR VPWR sky130_fd_sc_hd__decap_3
X_6908_ _6908_/A _6908_/B VGND VGND VPWR VPWR _6908_/X sky130_fd_sc_hd__or2_4
XFILLER_24_12 VGND VGND VPWR VPWR sky130_fd_sc_hd__decap_3
XFILLER_35_390 VGND VGND VPWR VPWR sky130_fd_sc_hd__fill_2
XFILLER_23_530 VGND VGND VPWR VPWR sky130_fd_sc_hd__decap_3
X_7888_ _8009_/B _7888_/B VGND VGND VPWR VPWR _7889_/B sky130_fd_sc_hd__xnor2_2
XFILLER_24_56 VGND VGND VPWR VPWR sky130_fd_sc_hd__decap_3
XFILLER_11_714 VGND VGND VPWR VPWR sky130_fd_sc_hd__decap_3
X_6839_ _6900_/A _6900_/B VGND VGND VPWR VPWR _6840_/B sky130_fd_sc_hd__nor2_2
XFILLER_50_360 VGND VGND VPWR VPWR sky130_fd_sc_hd__decap_3
XFILLER_50_371 VGND VGND VPWR VPWR sky130_fd_sc_hd__decap_3
XFILLER_23_585 VGND VGND VPWR VPWR sky130_fd_sc_hd__decap_3
XFILLER_11_747 VGND VGND VPWR VPWR sky130_fd_sc_hd__decap_3
XFILLER_7_707 VGND VGND VPWR VPWR sky130_fd_sc_hd__decap_3
XFILLER_7_729 VGND VGND VPWR VPWR sky130_fd_sc_hd__decap_3
XFILLER_6_206 VGND VGND VPWR VPWR sky130_fd_sc_hd__decap_3
XFILLER_10_268 VGND VGND VPWR VPWR sky130_fd_sc_hd__fill_1
X_8509_ wire110/X _8507_/Y _8508_/X VGND VGND VPWR VPWR _9224_/D sky130_fd_sc_hd__a21oi_2
XFILLER_109_646 VGND VGND VPWR VPWR sky130_fd_sc_hd__decap_3
XFILLER_108_123 VGND VGND VPWR VPWR sky130_fd_sc_hd__decap_3
XFILLER_40_44 VGND VGND VPWR VPWR sky130_fd_sc_hd__fill_2
XFILLER_109_668 VGND VGND VPWR VPWR sky130_fd_sc_hd__decap_3
XFILLER_124_616 VGND VGND VPWR VPWR sky130_fd_sc_hd__decap_3
XTAP_TAPCELL_ROW_94_1549 VGND VPWR sky130_fd_sc_hd__tapvpwrvgnd_1
XFILLER_40_88 VGND VGND VPWR VPWR sky130_fd_sc_hd__decap_3
XFILLER_6_3 VGND VGND VPWR VPWR sky130_fd_sc_hd__decap_3
XFILLER_123_137 VGND VGND VPWR VPWR sky130_fd_sc_hd__decap_3
XFILLER_49_31 VGND VGND VPWR VPWR sky130_fd_sc_hd__decap_3
XFILLER_78_736 VGND VGND VPWR VPWR sky130_fd_sc_hd__decap_3
XFILLER_49_75 VGND VGND VPWR VPWR sky130_fd_sc_hd__decap_3
XFILLER_77_257 VGND VGND VPWR VPWR sky130_fd_sc_hd__fill_2
XFILLER_92_205 VGND VGND VPWR VPWR sky130_fd_sc_hd__decap_3
XFILLER_1_27 VGND VGND VPWR VPWR sky130_fd_sc_hd__decap_3
XFILLER_46_611 VGND VGND VPWR VPWR sky130_fd_sc_hd__decap_3
XFILLER_92_227 VGND VGND VPWR VPWR sky130_fd_sc_hd__fill_1
XFILLER_45_110 VGND VGND VPWR VPWR sky130_fd_sc_hd__fill_2
XFILLER_73_452 VGND VGND VPWR VPWR sky130_fd_sc_hd__decap_3
XFILLER_33_305 VGND VGND VPWR VPWR sky130_fd_sc_hd__fill_2
XTAP_TAPCELL_ROW_16_503 VGND VPWR sky130_fd_sc_hd__tapvpwrvgnd_1
XFILLER_45_165 VGND VGND VPWR VPWR sky130_fd_sc_hd__decap_3
XTAP_TAPCELL_ROW_44_878 VGND VPWR sky130_fd_sc_hd__tapvpwrvgnd_1
XFILLER_60_168 VGND VGND VPWR VPWR sky130_fd_sc_hd__decap_3
XTAP_TAPCELL_ROW_103_1667 VGND VPWR sky130_fd_sc_hd__tapvpwrvgnd_1
XFILLER_81_51 VGND VGND VPWR VPWR sky130_fd_sc_hd__decap_3
XFILLER_14_563 VGND VGND VPWR VPWR sky130_fd_sc_hd__fill_1
XTAP_TAPCELL_ROW_103_1678 VGND VPWR sky130_fd_sc_hd__tapvpwrvgnd_1
XFILLER_41_393 VGND VGND VPWR VPWR sky130_fd_sc_hd__decap_3
XFILLER_127_432 VGND VGND VPWR VPWR sky130_fd_sc_hd__decap_3
XFILLER_6_740 VGND VGND VPWR VPWR sky130_fd_sc_hd__decap_3
XFILLER_60_6 VGND VGND VPWR VPWR sky130_fd_sc_hd__decap_3
XFILLER_5_272 VGND VGND VPWR VPWR sky130_fd_sc_hd__decap_3
X_5170_ _5344_/A _5149_/X _9199_/Q _5135_/A VGND VGND VPWR VPWR _5170_/X sky130_fd_sc_hd__a211o_2
XFILLER_39_3 VGND VGND VPWR VPWR sky130_fd_sc_hd__fill_1
XFILLER_96_522 VGND VGND VPWR VPWR sky130_fd_sc_hd__fill_1
XFILLER_96_533 VGND VGND VPWR VPWR sky130_fd_sc_hd__decap_3
XFILLER_69_758 VGND VGND VPWR VPWR sky130_fd_sc_hd__decap_3
XFILLER_122_192 VGND VGND VPWR VPWR sky130_fd_sc_hd__decap_3
XFILLER_110_365 VGND VGND VPWR VPWR sky130_fd_sc_hd__decap_3
XFILLER_49_460 VGND VGND VPWR VPWR sky130_fd_sc_hd__decap_3
XFILLER_37_600 VGND VGND VPWR VPWR sky130_fd_sc_hd__decap_3
Xinput4 sample_in[11] VGND VGND VPWR VPWR input4/X sky130_fd_sc_hd__clkdlybuf4s25_1
X_8860_ _9274_/Q hold937/X _8862_/S VGND VGND VPWR VPWR _8860_/X sky130_fd_sc_hd__mux2_2
XFILLER_36_121 VGND VGND VPWR VPWR sky130_fd_sc_hd__decap_3
X_7811_ _7981_/A _7981_/B VGND VGND VPWR VPWR _7812_/B sky130_fd_sc_hd__xnor2_2
Xclkbuf_2_1__f_clk clkbuf_0_clk/X VGND VGND VPWR VPWR clkbuf_leaf_9_clk/A sky130_fd_sc_hd__clkbuf_16
XFILLER_92_772 VGND VGND VPWR VPWR sky130_fd_sc_hd__decap_3
XFILLER_37_688 VGND VGND VPWR VPWR sky130_fd_sc_hd__decap_3
X_8791_ _9241_/Q hold751/X _8799_/S VGND VGND VPWR VPWR _8791_/X sky130_fd_sc_hd__mux2_2
XFILLER_24_327 VGND VGND VPWR VPWR sky130_fd_sc_hd__fill_1
X_7742_ _7744_/A _7744_/B VGND VGND VPWR VPWR _7742_/Y sky130_fd_sc_hd__nor2_2
XFILLER_17_390 VGND VGND VPWR VPWR sky130_fd_sc_hd__fill_2
X_4954_ _9286_/Q _9082_/Q _6239_/A VGND VGND VPWR VPWR _4955_/C sky130_fd_sc_hd__mux2_2
XFILLER_51_157 VGND VGND VPWR VPWR sky130_fd_sc_hd__decap_3
XFILLER_20_500 VGND VGND VPWR VPWR sky130_fd_sc_hd__decap_3
X_7673_ _5097_/X _5803_/A _6414_/X _7186_/X VGND VGND VPWR VPWR _7673_/X sky130_fd_sc_hd__o22a_2
X_4885_ _9214_/Q _4899_/B VGND VGND VPWR VPWR _4885_/Y sky130_fd_sc_hd__nor2_2
XFILLER_32_371 VGND VGND VPWR VPWR sky130_fd_sc_hd__decap_3
XFILLER_20_522 VGND VGND VPWR VPWR sky130_fd_sc_hd__decap_3
XFILLER_32_393 VGND VGND VPWR VPWR sky130_fd_sc_hd__decap_3
XFILLER_20_533 VGND VGND VPWR VPWR sky130_fd_sc_hd__decap_3
X_6624_ _9210_/Q _6624_/B VGND VGND VPWR VPWR _6625_/B sky130_fd_sc_hd__xnor2_2
XFILLER_20_577 VGND VGND VPWR VPWR sky130_fd_sc_hd__decap_3
X_9343_ _9343_/CLK _9343_/D fanout402/X VGND VGND VPWR VPWR _9343_/Q sky130_fd_sc_hd__dfrtp_2
XFILLER_118_421 VGND VGND VPWR VPWR sky130_fd_sc_hd__decap_3
X_6555_ _6746_/A _6746_/B VGND VGND VPWR VPWR _6745_/B sky130_fd_sc_hd__xnor2_2
X_5506_ _6083_/B _6076_/A VGND VGND VPWR VPWR _6096_/B sky130_fd_sc_hd__nand2_2
XFILLER_106_616 VGND VGND VPWR VPWR sky130_fd_sc_hd__decap_3
X_9274_ _9338_/CLK _9274_/D load_slew370/X VGND VGND VPWR VPWR _9274_/Q sky130_fd_sc_hd__dfrtp_2
X_6486_ _6406_/B _5537_/B _5674_/B VGND VGND VPWR VPWR _6487_/B sky130_fd_sc_hd__o21a_2
X_8225_ _8179_/A _8179_/B _8224_/X VGND VGND VPWR VPWR _8254_/A sky130_fd_sc_hd__o21ai_2
X_5437_ _7569_/A _7799_/A VGND VGND VPWR VPWR _5438_/B sky130_fd_sc_hd__nor2_2
XFILLER_10_47 VGND VGND VPWR VPWR sky130_fd_sc_hd__decap_3
XFILLER_126_47 VGND VGND VPWR VPWR sky130_fd_sc_hd__decap_3
X_5368_ _5493_/A _5493_/B VGND VGND VPWR VPWR _5396_/A sky130_fd_sc_hd__nand2_2
X_8156_ _8047_/S _8231_/A _8058_/Y _8155_/Y VGND VGND VPWR VPWR _8156_/X sky130_fd_sc_hd__a31o_2
XFILLER_87_500 VGND VGND VPWR VPWR sky130_fd_sc_hd__decap_3
XFILLER_114_660 VGND VGND VPWR VPWR sky130_fd_sc_hd__fill_2
XFILLER_86_18 VGND VGND VPWR VPWR sky130_fd_sc_hd__decap_3
XFILLER_114_671 VGND VGND VPWR VPWR sky130_fd_sc_hd__decap_3
XFILLER_87_522 VGND VGND VPWR VPWR sky130_fd_sc_hd__decap_3
XFILLER_86_29 VGND VGND VPWR VPWR sky130_fd_sc_hd__fill_2
XFILLER_120_118 VGND VGND VPWR VPWR sky130_fd_sc_hd__decap_3
X_7107_ _7106_/B _7106_/C wire55/X VGND VGND VPWR VPWR _7374_/B sky130_fd_sc_hd__o21a_4
XFILLER_99_393 VGND VGND VPWR VPWR sky130_fd_sc_hd__decap_3
XFILLER_101_321 VGND VGND VPWR VPWR sky130_fd_sc_hd__decap_3
XFILLER_19_12 VGND VGND VPWR VPWR sky130_fd_sc_hd__decap_3
X_5299_ _7114_/B _7764_/A VGND VGND VPWR VPWR _5303_/A sky130_fd_sc_hd__nand2_2
X_8087_ _7962_/A _7962_/B _7963_/A VGND VGND VPWR VPWR _8087_/X sky130_fd_sc_hd__o21ba_2
XFILLER_87_555 VGND VGND VPWR VPWR sky130_fd_sc_hd__decap_3
XFILLER_113_192 VGND VGND VPWR VPWR sky130_fd_sc_hd__fill_1
XFILLER_101_343 VGND VGND VPWR VPWR sky130_fd_sc_hd__decap_3
XFILLER_47_408 VGND VGND VPWR VPWR sky130_fd_sc_hd__decap_3
X_7038_ _7038_/A _7038_/B VGND VGND VPWR VPWR _7038_/X sky130_fd_sc_hd__and2_2
XFILLER_87_588 VGND VGND VPWR VPWR sky130_fd_sc_hd__decap_3
XFILLER_87_599 VGND VGND VPWR VPWR sky130_fd_sc_hd__decap_3
XFILLER_19_67 VGND VGND VPWR VPWR sky130_fd_sc_hd__decap_3
XFILLER_27_110 VGND VGND VPWR VPWR sky130_fd_sc_hd__fill_2
XFILLER_19_89 VGND VGND VPWR VPWR sky130_fd_sc_hd__fill_2
XFILLER_67_290 VGND VGND VPWR VPWR sky130_fd_sc_hd__decap_3
XFILLER_55_452 VGND VGND VPWR VPWR sky130_fd_sc_hd__fill_1
XFILLER_55_474 VGND VGND VPWR VPWR sky130_fd_sc_hd__decap_3
XFILLER_28_699 VGND VGND VPWR VPWR sky130_fd_sc_hd__fill_1
X_8989_ _8989_/A VGND VGND VPWR VPWR _9335_/D sky130_fd_sc_hd__buf_1
XFILLER_35_44 VGND VGND VPWR VPWR sky130_fd_sc_hd__decap_3
XFILLER_70_433 VGND VGND VPWR VPWR sky130_fd_sc_hd__decap_3
XFILLER_43_647 VGND VGND VPWR VPWR sky130_fd_sc_hd__decap_3
XFILLER_15_349 VGND VGND VPWR VPWR sky130_fd_sc_hd__fill_2
XFILLER_70_477 VGND VGND VPWR VPWR sky130_fd_sc_hd__fill_2
XFILLER_11_500 VGND VGND VPWR VPWR sky130_fd_sc_hd__fill_1
XTAP_TAPCELL_ROW_41_837 VGND VPWR sky130_fd_sc_hd__tapvpwrvgnd_1
XFILLER_23_393 VGND VGND VPWR VPWR sky130_fd_sc_hd__fill_1
XFILLER_11_533 VGND VGND VPWR VPWR sky130_fd_sc_hd__fill_2
XFILLER_128_218 VGND VGND VPWR VPWR sky130_fd_sc_hd__decap_3
XTAP_TAPCELL_ROW_21_561 VGND VPWR sky130_fd_sc_hd__tapvpwrvgnd_1
XFILLER_109_432 VGND VGND VPWR VPWR sky130_fd_sc_hd__decap_3
XFILLER_7_559 VGND VGND VPWR VPWR sky130_fd_sc_hd__fill_1
XFILLER_109_476 VGND VGND VPWR VPWR sky130_fd_sc_hd__fill_1
XFILLER_3_721 VGND VGND VPWR VPWR sky130_fd_sc_hd__decap_3
XFILLER_3_732 VGND VGND VPWR VPWR sky130_fd_sc_hd__decap_3
XFILLER_124_435 VGND VGND VPWR VPWR sky130_fd_sc_hd__decap_3
XFILLER_3_765 VGND VGND VPWR VPWR sky130_fd_sc_hd__decap_3
XFILLER_2_242 VGND VGND VPWR VPWR sky130_fd_sc_hd__decap_3
XFILLER_2_253 VGND VGND VPWR VPWR sky130_fd_sc_hd__decap_3
XFILLER_105_671 VGND VGND VPWR VPWR sky130_fd_sc_hd__fill_1
XFILLER_105_682 VGND VGND VPWR VPWR sky130_fd_sc_hd__decap_3
XFILLER_116_80 VGND VGND VPWR VPWR sky130_fd_sc_hd__decap_3
XFILLER_93_503 VGND VGND VPWR VPWR sky130_fd_sc_hd__fill_1
XFILLER_38_408 VGND VGND VPWR VPWR sky130_fd_sc_hd__decap_3
XFILLER_116_91 VGND VGND VPWR VPWR sky130_fd_sc_hd__decap_3
XFILLER_93_514 VGND VGND VPWR VPWR sky130_fd_sc_hd__decap_3
XFILLER_66_728 VGND VGND VPWR VPWR sky130_fd_sc_hd__decap_3
XFILLER_65_205 VGND VGND VPWR VPWR sky130_fd_sc_hd__decap_3
XFILLER_78_599 VGND VGND VPWR VPWR sky130_fd_sc_hd__decap_3
XFILLER_76_62 VGND VGND VPWR VPWR sky130_fd_sc_hd__decap_3
XTAP_TAPCELL_ROW_49_937 VGND VPWR sky130_fd_sc_hd__tapvpwrvgnd_1
XTAP_TAPCELL_ROW_49_948 VGND VPWR sky130_fd_sc_hd__tapvpwrvgnd_1
XFILLER_18_121 VGND VGND VPWR VPWR sky130_fd_sc_hd__decap_3
XFILLER_46_463 VGND VGND VPWR VPWR sky130_fd_sc_hd__decap_3
XTAP_TAPCELL_ROW_29_672 VGND VPWR sky130_fd_sc_hd__tapvpwrvgnd_1
XFILLER_34_636 VGND VGND VPWR VPWR sky130_fd_sc_hd__decap_3
XFILLER_33_113 VGND VGND VPWR VPWR sky130_fd_sc_hd__decap_3
XFILLER_92_50 VGND VGND VPWR VPWR sky130_fd_sc_hd__decap_3
XFILLER_92_83 VGND VGND VPWR VPWR sky130_fd_sc_hd__fill_1
XFILLER_61_455 VGND VGND VPWR VPWR sky130_fd_sc_hd__decap_3
XTAP_TAPCELL_ROW_64_1150 VGND VPWR sky130_fd_sc_hd__tapvpwrvgnd_1
XFILLER_92_94 VGND VGND VPWR VPWR sky130_fd_sc_hd__fill_1
XFILLER_14_371 VGND VGND VPWR VPWR sky130_fd_sc_hd__fill_2
XFILLER_42_691 VGND VGND VPWR VPWR sky130_fd_sc_hd__decap_3
XFILLER_14_393 VGND VGND VPWR VPWR sky130_fd_sc_hd__fill_1
X_4670_ hold949/X _4670_/A1 _4672_/S VGND VGND VPWR VPWR _4671_/A sky130_fd_sc_hd__mux2_2
XFILLER_41_190 VGND VGND VPWR VPWR sky130_fd_sc_hd__decap_3
XFILLER_128_752 VGND VGND VPWR VPWR sky130_fd_sc_hd__decap_3
XFILLER_128_763 VGND VGND VPWR VPWR sky130_fd_sc_hd__decap_3
XFILLER_127_240 VGND VGND VPWR VPWR sky130_fd_sc_hd__decap_3
X_6340_ _9331_/Q _6603_/B _6604_/C VGND VGND VPWR VPWR _6340_/X sky130_fd_sc_hd__and3_2
XTAP_TAPCELL_ROW_116_1847 VGND VPWR sky130_fd_sc_hd__tapvpwrvgnd_1
XFILLER_115_413 VGND VGND VPWR VPWR sky130_fd_sc_hd__decap_3
XFILLER_6_570 VGND VGND VPWR VPWR sky130_fd_sc_hd__decap_3
XFILLER_127_284 VGND VGND VPWR VPWR sky130_fd_sc_hd__decap_3
X_6271_ _6271_/A VGND VGND VPWR VPWR _9208_/D sky130_fd_sc_hd__buf_1
XFILLER_115_435 VGND VGND VPWR VPWR sky130_fd_sc_hd__decap_3
X_5222_ _6094_/B _6076_/A VGND VGND VPWR VPWR _5222_/X sky130_fd_sc_hd__or2_2
X_8010_ _8010_/A VGND VGND VPWR VPWR _8015_/A sky130_fd_sc_hd__inv_2
XFILLER_69_500 VGND VGND VPWR VPWR sky130_fd_sc_hd__decap_3
XFILLER_69_511 VGND VGND VPWR VPWR sky130_fd_sc_hd__decap_3
XFILLER_102_129 VGND VGND VPWR VPWR sky130_fd_sc_hd__decap_3
XTAP_TAPCELL_ROW_75_1290 VGND VPWR sky130_fd_sc_hd__tapvpwrvgnd_1
XPHY_EDGE_ROW_102_Left_233 VGND VGND VPWR VPWR sky130_fd_sc_hd__decap_3
X_5153_ _5213_/S _5153_/B VGND VGND VPWR VPWR _5162_/A sky130_fd_sc_hd__xnor2_2
XFILLER_130_449 VGND VGND VPWR VPWR sky130_fd_sc_hd__fill_2
XFILLER_69_566 VGND VGND VPWR VPWR sky130_fd_sc_hd__decap_3
XFILLER_84_503 VGND VGND VPWR VPWR sky130_fd_sc_hd__decap_3
XFILLER_57_717 VGND VGND VPWR VPWR sky130_fd_sc_hd__decap_3
X_5084_ _6436_/A _5084_/B VGND VGND VPWR VPWR _5088_/A sky130_fd_sc_hd__nand2_2
XFILLER_84_536 VGND VGND VPWR VPWR sky130_fd_sc_hd__decap_3
XFILLER_110_173 VGND VGND VPWR VPWR sky130_fd_sc_hd__decap_3
X_8912_ _8912_/A VGND VGND VPWR VPWR _9298_/D sky130_fd_sc_hd__buf_1
XFILLER_56_249 VGND VGND VPWR VPWR sky130_fd_sc_hd__decap_3
XFILLER_112_27 VGND VGND VPWR VPWR sky130_fd_sc_hd__fill_1
XFILLER_65_772 VGND VGND VPWR VPWR sky130_fd_sc_hd__decap_3
X_8843_ _8969_/A VGND VGND VPWR VPWR _8862_/S sky130_fd_sc_hd__clkbuf_2
XFILLER_25_614 VGND VGND VPWR VPWR sky130_fd_sc_hd__fill_2
XFILLER_112_38 VGND VGND VPWR VPWR sky130_fd_sc_hd__decap_3
XTAP_TAPCELL_ROW_127_1998 VGND VPWR sky130_fd_sc_hd__tapvpwrvgnd_1
XFILLER_92_580 VGND VGND VPWR VPWR sky130_fd_sc_hd__decap_3
XFILLER_24_113 VGND VGND VPWR VPWR sky130_fd_sc_hd__decap_3
XFILLER_25_658 VGND VGND VPWR VPWR sky130_fd_sc_hd__fill_1
X_8774_ _8210_/B _4870_/Y _8291_/S _8774_/C1 VGND VGND VPWR VPWR _8774_/X sky130_fd_sc_hd__o211a_2
XFILLER_52_455 VGND VGND VPWR VPWR sky130_fd_sc_hd__decap_3
X_5986_ _5984_/X _5834_/A _5985_/X VGND VGND VPWR VPWR _5986_/Y sky130_fd_sc_hd__a21oi_4
XPHY_EDGE_ROW_111_Left_242 VGND VGND VPWR VPWR sky130_fd_sc_hd__decap_3
XFILLER_80_775 VGND VGND VPWR VPWR sky130_fd_sc_hd__fill_2
XFILLER_52_477 VGND VGND VPWR VPWR sky130_fd_sc_hd__decap_3
X_7725_ _7728_/A _8011_/B _7682_/A _7728_/B VGND VGND VPWR VPWR _7731_/A sky130_fd_sc_hd__a211o_2
X_4937_ _6232_/C _5463_/C _5119_/S _6231_/B VGND VGND VPWR VPWR _5612_/A sky130_fd_sc_hd__and4bb_2
XFILLER_52_499 VGND VGND VPWR VPWR sky130_fd_sc_hd__decap_3
X_7656_ _7656_/A _8009_/A _7659_/B VGND VGND VPWR VPWR _7657_/A sky130_fd_sc_hd__or3b_2
X_4868_ _4868_/A VGND VGND VPWR VPWR _9177_/D sky130_fd_sc_hd__buf_1
XFILLER_20_363 VGND VGND VPWR VPWR sky130_fd_sc_hd__fill_1
X_6607_ _9112_/Q _6607_/B _6607_/C VGND VGND VPWR VPWR _6607_/X sky130_fd_sc_hd__and3_2
XFILLER_119_741 VGND VGND VPWR VPWR sky130_fd_sc_hd__decap_3
X_7587_ _7590_/A _7763_/A VGND VGND VPWR VPWR _7617_/B sky130_fd_sc_hd__nor2_2
X_4799_ _4799_/A VGND VGND VPWR VPWR _9145_/D sky130_fd_sc_hd__buf_1
XFILLER_21_24 VGND VGND VPWR VPWR sky130_fd_sc_hd__decap_3
X_9326_ _9344_/CLK _9326_/D load_slew380/X VGND VGND VPWR VPWR _9326_/Q sky130_fd_sc_hd__dfrtp_2
XFILLER_4_507 VGND VGND VPWR VPWR sky130_fd_sc_hd__decap_3
XFILLER_21_46 VGND VGND VPWR VPWR sky130_fd_sc_hd__decap_3
XFILLER_119_774 VGND VGND VPWR VPWR sky130_fd_sc_hd__decap_3
X_6538_ _6542_/A _6530_/X _6534_/Y _6537_/X VGND VGND VPWR VPWR _6656_/A sky130_fd_sc_hd__a211o_2
XFILLER_21_57 VGND VGND VPWR VPWR sky130_fd_sc_hd__fill_1
XFILLER_106_424 VGND VGND VPWR VPWR sky130_fd_sc_hd__decap_3
XFILLER_108_6 VGND VGND VPWR VPWR sky130_fd_sc_hd__decap_3
X_9257_ clkload6/A _9257_/D wire372/A VGND VGND VPWR VPWR _9257_/Q sky130_fd_sc_hd__dfrtp_2
XTAP_TAPCELL_ROW_91_1508 VGND VPWR sky130_fd_sc_hd__tapvpwrvgnd_1
X_6469_ _6859_/A VGND VGND VPWR VPWR _7885_/B sky130_fd_sc_hd__inv_2
XFILLER_106_457 VGND VGND VPWR VPWR sky130_fd_sc_hd__decap_3
XPHY_EDGE_ROW_120_Left_251 VGND VGND VPWR VPWR sky130_fd_sc_hd__decap_3
X_8208_ _8043_/A _8043_/B _7999_/A _8207_/Y VGND VGND VPWR VPWR _8208_/X sky130_fd_sc_hd__a22o_4
XFILLER_0_713 VGND VGND VPWR VPWR sky130_fd_sc_hd__decap_3
X_9188_ _9189_/CLK _9188_/D load_slew414/X VGND VGND VPWR VPWR _9188_/Q sky130_fd_sc_hd__dfrtp_2
XFILLER_121_427 VGND VGND VPWR VPWR sky130_fd_sc_hd__decap_3
XFILLER_0_735 VGND VGND VPWR VPWR sky130_fd_sc_hd__decap_3
X_8139_ _9219_/Q VGND VGND VPWR VPWR _8268_/S sky130_fd_sc_hd__inv_2
XFILLER_87_330 VGND VGND VPWR VPWR sky130_fd_sc_hd__decap_3
XFILLER_0_757 VGND VGND VPWR VPWR sky130_fd_sc_hd__decap_3
XFILLER_102_641 VGND VGND VPWR VPWR sky130_fd_sc_hd__decap_3
XTAP_TAPCELL_ROW_7_378 VGND VPWR sky130_fd_sc_hd__tapvpwrvgnd_1
XPHY_EDGE_ROW_102_Right_102 VGND VGND VPWR VPWR sky130_fd_sc_hd__decap_3
XFILLER_75_503 VGND VGND VPWR VPWR sky130_fd_sc_hd__fill_1
XFILLER_48_728 VGND VGND VPWR VPWR sky130_fd_sc_hd__fill_2
XFILLER_75_514 VGND VGND VPWR VPWR sky130_fd_sc_hd__fill_2
XFILLER_102_696 VGND VGND VPWR VPWR sky130_fd_sc_hd__decap_3
XFILLER_75_558 VGND VGND VPWR VPWR sky130_fd_sc_hd__fill_2
XFILLER_47_249 VGND VGND VPWR VPWR sky130_fd_sc_hd__decap_3
XFILLER_28_430 VGND VGND VPWR VPWR sky130_fd_sc_hd__decap_3
XFILLER_46_32 VGND VGND VPWR VPWR sky130_fd_sc_hd__decap_3
XTAP_TAPCELL_ROW_46_907 VGND VPWR sky130_fd_sc_hd__tapvpwrvgnd_1
XFILLER_46_54 VGND VGND VPWR VPWR sky130_fd_sc_hd__decap_3
XFILLER_46_76 VGND VGND VPWR VPWR sky130_fd_sc_hd__decap_3
XFILLER_46_98 VGND VGND VPWR VPWR sky130_fd_sc_hd__decap_3
XFILLER_15_113 VGND VGND VPWR VPWR sky130_fd_sc_hd__decap_3
Xmax_cap77 _8244_/A VGND VGND VPWR VPWR _8678_/A sky130_fd_sc_hd__clkbuf_4
XFILLER_43_433 VGND VGND VPWR VPWR sky130_fd_sc_hd__decap_3
XTAP_TAPCELL_ROW_26_631 VGND VPWR sky130_fd_sc_hd__tapvpwrvgnd_1
Xmax_cap99 _5438_/B VGND VGND VPWR VPWR _8350_/A sky130_fd_sc_hd__buf_2
XFILLER_43_455 VGND VGND VPWR VPWR sky130_fd_sc_hd__decap_3
XFILLER_31_617 VGND VGND VPWR VPWR sky130_fd_sc_hd__decap_3
XFILLER_24_680 VGND VGND VPWR VPWR sky130_fd_sc_hd__fill_2
XTAP_TAPCELL_ROW_100_1626 VGND VPWR sky130_fd_sc_hd__tapvpwrvgnd_1
XTAP_TAPCELL_ROW_100_1637 VGND VPWR sky130_fd_sc_hd__tapvpwrvgnd_1
XFILLER_11_352 VGND VGND VPWR VPWR sky130_fd_sc_hd__decap_3
XFILLER_7_15 VGND VGND VPWR VPWR sky130_fd_sc_hd__decap_3
Xwire221 wire221/A VGND VGND VPWR VPWR result_out[7] sky130_fd_sc_hd__buf_4
XFILLER_7_312 VGND VGND VPWR VPWR sky130_fd_sc_hd__decap_3
Xwire232 wire232/A VGND VGND VPWR VPWR result_out[11] sky130_fd_sc_hd__buf_4
Xwire243 wire243/A VGND VGND VPWR VPWR _6342_/B sky130_fd_sc_hd__buf_4
XFILLER_7_48 VGND VGND VPWR VPWR sky130_fd_sc_hd__decap_3
XFILLER_109_273 VGND VGND VPWR VPWR sky130_fd_sc_hd__decap_3
XFILLER_125_722 VGND VGND VPWR VPWR sky130_fd_sc_hd__decap_3
XFILLER_125_744 VGND VGND VPWR VPWR sky130_fd_sc_hd__decap_3
XFILLER_124_221 VGND VGND VPWR VPWR sky130_fd_sc_hd__decap_3
XFILLER_98_617 VGND VGND VPWR VPWR sky130_fd_sc_hd__decap_3
XFILLER_124_265 VGND VGND VPWR VPWR sky130_fd_sc_hd__decap_3
XFILLER_97_116 VGND VGND VPWR VPWR sky130_fd_sc_hd__decap_3
XFILLER_112_416 VGND VGND VPWR VPWR sky130_fd_sc_hd__decap_3
XFILLER_127_90 VGND VGND VPWR VPWR sky130_fd_sc_hd__decap_3
XFILLER_124_298 VGND VGND VPWR VPWR sky130_fd_sc_hd__fill_2
XFILLER_3_595 VGND VGND VPWR VPWR sky130_fd_sc_hd__decap_3
Xload_slew237 _5588_/A VGND VGND VPWR VPWR _5283_/A sky130_fd_sc_hd__clkbuf_4
Xload_slew248 _5050_/A VGND VGND VPWR VPWR _5059_/S sky130_fd_sc_hd__buf_4
XTAP_TAPCELL_ROW_111_1777 VGND VPWR sky130_fd_sc_hd__tapvpwrvgnd_1
XFILLER_87_83 VGND VGND VPWR VPWR sky130_fd_sc_hd__decap_3
XFILLER_87_94 VGND VGND VPWR VPWR sky130_fd_sc_hd__decap_3
XFILLER_66_503 VGND VGND VPWR VPWR sky130_fd_sc_hd__decap_3
XFILLER_23_6 VGND VGND VPWR VPWR sky130_fd_sc_hd__decap_3
XFILLER_78_374 VGND VGND VPWR VPWR sky130_fd_sc_hd__decap_3
XFILLER_120_460 VGND VGND VPWR VPWR sky130_fd_sc_hd__decap_3
XFILLER_39_739 VGND VGND VPWR VPWR sky130_fd_sc_hd__fill_2
XFILLER_66_536 VGND VGND VPWR VPWR sky130_fd_sc_hd__decap_3
XFILLER_38_249 VGND VGND VPWR VPWR sky130_fd_sc_hd__decap_3
XFILLER_66_569 VGND VGND VPWR VPWR sky130_fd_sc_hd__fill_1
XFILLER_47_750 VGND VGND VPWR VPWR sky130_fd_sc_hd__decap_3
XFILLER_19_452 VGND VGND VPWR VPWR sky130_fd_sc_hd__decap_3
XFILLER_47_772 VGND VGND VPWR VPWR sky130_fd_sc_hd__decap_3
XFILLER_19_485 VGND VGND VPWR VPWR sky130_fd_sc_hd__decap_3
XFILLER_62_731 VGND VGND VPWR VPWR sky130_fd_sc_hd__decap_3
XFILLER_46_282 VGND VGND VPWR VPWR sky130_fd_sc_hd__decap_3
X_5840_ _5840_/A _5840_/B VGND VGND VPWR VPWR _5841_/B sky130_fd_sc_hd__xnor2_2
XFILLER_34_466 VGND VGND VPWR VPWR sky130_fd_sc_hd__fill_1
XFILLER_34_477 VGND VGND VPWR VPWR sky130_fd_sc_hd__decap_3
XFILLER_61_263 VGND VGND VPWR VPWR sky130_fd_sc_hd__fill_2
XFILLER_22_628 VGND VGND VPWR VPWR sky130_fd_sc_hd__decap_3
X_5771_ _5911_/A _5771_/B VGND VGND VPWR VPWR _5816_/B sky130_fd_sc_hd__xnor2_2
XFILLER_21_116 VGND VGND VPWR VPWR sky130_fd_sc_hd__decap_3
XFILLER_15_691 VGND VGND VPWR VPWR sky130_fd_sc_hd__decap_3
X_7510_ _7510_/A _7510_/B VGND VGND VPWR VPWR _7510_/X sky130_fd_sc_hd__or2_4
X_4722_ _4722_/A VGND VGND VPWR VPWR _9108_/D sky130_fd_sc_hd__buf_1
X_8490_ _8446_/A _8344_/A wire67/X _9223_/Q VGND VGND VPWR VPWR _8490_/X sky130_fd_sc_hd__o22a_2
X_7441_ _7299_/A _7440_/X _7298_/A VGND VGND VPWR VPWR _7441_/X sky130_fd_sc_hd__o21ba_2
X_4653_ _4842_/A VGND VGND VPWR VPWR _4672_/S sky130_fd_sc_hd__clkbuf_2
X_7372_ _7372_/A _7372_/B VGND VGND VPWR VPWR _7373_/B sky130_fd_sc_hd__xnor2_2
X_4584_ _4584_/A VGND VGND VPWR VPWR _9043_/D sky130_fd_sc_hd__buf_1
Xhold802 _4906_/X VGND VGND VPWR VPWR _9193_/D sky130_fd_sc_hd__dlygate4sd3_1
XFILLER_128_582 VGND VGND VPWR VPWR sky130_fd_sc_hd__decap_3
Xhold813 _8814_/X VGND VGND VPWR VPWR _8815_/A sky130_fd_sc_hd__dlygate4sd3_1
X_9111_ _9159_/CLK _9111_/D load_slew390/X VGND VGND VPWR VPWR _9111_/Q sky130_fd_sc_hd__dfrtp_2
X_6323_ _6568_/A _6568_/B VGND VGND VPWR VPWR _6325_/A sky130_fd_sc_hd__xor2_2
Xhold824 _5338_/Y VGND VGND VPWR VPWR hold824/X sky130_fd_sc_hd__dlygate4sd3_1
Xhold835 _9135_/Q VGND VGND VPWR VPWR hold835/X sky130_fd_sc_hd__dlygate4sd3_1
XFILLER_116_755 VGND VGND VPWR VPWR sky130_fd_sc_hd__fill_1
Xhold846 _5684_/Y VGND VGND VPWR VPWR hold846/X sky130_fd_sc_hd__dlygate4sd3_1
XFILLER_116_766 VGND VGND VPWR VPWR sky130_fd_sc_hd__decap_3
Xhold857 _8982_/X VGND VGND VPWR VPWR _8983_/A sky130_fd_sc_hd__dlygate4sd3_1
XFILLER_89_617 VGND VGND VPWR VPWR sky130_fd_sc_hd__decap_3
XFILLER_107_27 VGND VGND VPWR VPWR sky130_fd_sc_hd__decap_3
Xhold868 _9102_/Q VGND VGND VPWR VPWR hold868/X sky130_fd_sc_hd__dlygate4sd3_1
X_9042_ _9341_/CLK _9042_/D fanout379/X VGND VGND VPWR VPWR _9042_/Q sky130_fd_sc_hd__dfrtp_2
X_6254_ _9206_/Q _8232_/A _5986_/Y VGND VGND VPWR VPWR _6254_/X sky130_fd_sc_hd__a21o_2
Xhold879 _8898_/X VGND VGND VPWR VPWR _8899_/A sky130_fd_sc_hd__dlygate4sd3_1
XFILLER_89_639 VGND VGND VPWR VPWR sky130_fd_sc_hd__decap_3
XFILLER_115_276 VGND VGND VPWR VPWR sky130_fd_sc_hd__decap_3
XFILLER_103_427 VGND VGND VPWR VPWR sky130_fd_sc_hd__decap_3
XFILLER_103_449 VGND VGND VPWR VPWR sky130_fd_sc_hd__decap_3
X_5205_ _5137_/X _5138_/X _5041_/B VGND VGND VPWR VPWR _5255_/A sky130_fd_sc_hd__a21o_2
XFILLER_130_246 VGND VGND VPWR VPWR sky130_fd_sc_hd__decap_3
X_6185_ _6184_/X _6183_/X _6185_/B1 VGND VGND VPWR VPWR _6326_/C sky130_fd_sc_hd__a21o_4
XFILLER_57_503 VGND VGND VPWR VPWR sky130_fd_sc_hd__fill_1
XFILLER_130_268 VGND VGND VPWR VPWR sky130_fd_sc_hd__decap_3
X_5136_ _7317_/A _5345_/A VGND VGND VPWR VPWR _5148_/A sky130_fd_sc_hd__nand2_2
XFILLER_69_374 VGND VGND VPWR VPWR sky130_fd_sc_hd__fill_2
XFILLER_57_514 VGND VGND VPWR VPWR sky130_fd_sc_hd__decap_3
XTAP_TAPCELL_ROW_4_337 VGND VPWR sky130_fd_sc_hd__tapvpwrvgnd_1
XFILLER_123_15 VGND VGND VPWR VPWR sky130_fd_sc_hd__decap_3
XFILLER_96_193 VGND VGND VPWR VPWR sky130_fd_sc_hd__decap_3
XFILLER_57_558 VGND VGND VPWR VPWR sky130_fd_sc_hd__fill_2
X_5067_ _9272_/Q _5065_/X _5066_/X _9148_/Q VGND VGND VPWR VPWR _5071_/B sky130_fd_sc_hd__a22o_2
XFILLER_123_48 VGND VGND VPWR VPWR sky130_fd_sc_hd__decap_3
XFILLER_38_772 VGND VGND VPWR VPWR sky130_fd_sc_hd__decap_3
XTAP_TAPCELL_ROW_88_1470 VGND VPWR sky130_fd_sc_hd__tapvpwrvgnd_1
XFILLER_16_24 VGND VGND VPWR VPWR sky130_fd_sc_hd__decap_3
XFILLER_16_35 VGND VGND VPWR VPWR sky130_fd_sc_hd__decap_3
X_8826_ _8826_/A VGND VGND VPWR VPWR _9257_/D sky130_fd_sc_hd__buf_1
XFILLER_80_561 VGND VGND VPWR VPWR sky130_fd_sc_hd__decap_3
XFILLER_16_68 VGND VGND VPWR VPWR sky130_fd_sc_hd__decap_3
X_8757_ _8728_/S _8755_/B _8741_/A VGND VGND VPWR VPWR _8758_/B sky130_fd_sc_hd__a21oi_2
XFILLER_12_116 VGND VGND VPWR VPWR sky130_fd_sc_hd__decap_3
X_5969_ _5908_/B _5908_/A _5912_/B _5912_/A VGND VGND VPWR VPWR _5969_/X sky130_fd_sc_hd__a22o_4
XFILLER_12_138 VGND VGND VPWR VPWR sky130_fd_sc_hd__fill_2
X_7708_ _7711_/B _7688_/A VGND VGND VPWR VPWR _7708_/X sky130_fd_sc_hd__or2b_2
XTAP_TAPCELL_ROW_51_965 VGND VPWR sky130_fd_sc_hd__tapvpwrvgnd_1
X_8688_ _8686_/Y _8687_/Y _8688_/S VGND VGND VPWR VPWR _9229_/D sky130_fd_sc_hd__mux2_4
XTAP_TAPCELL_ROW_51_976 VGND VPWR sky130_fd_sc_hd__tapvpwrvgnd_1
XFILLER_32_56 VGND VGND VPWR VPWR sky130_fd_sc_hd__decap_3
X_7639_ _7639_/A _7639_/B VGND VGND VPWR VPWR _7647_/A sky130_fd_sc_hd__nand2_4
XFILLER_21_694 VGND VGND VPWR VPWR sky130_fd_sc_hd__decap_3
XFILLER_20_171 VGND VGND VPWR VPWR sky130_fd_sc_hd__decap_3
XFILLER_4_315 VGND VGND VPWR VPWR sky130_fd_sc_hd__decap_3
XFILLER_107_744 VGND VGND VPWR VPWR sky130_fd_sc_hd__decap_3
X_9309_ _9341_/CLK _9309_/D load_slew378/X VGND VGND VPWR VPWR _9309_/Q sky130_fd_sc_hd__dfrtp_2
XFILLER_106_3 VGND VGND VPWR VPWR sky130_fd_sc_hd__decap_3
XFILLER_79_116 VGND VGND VPWR VPWR sky130_fd_sc_hd__fill_2
XFILLER_121_202 VGND VGND VPWR VPWR sky130_fd_sc_hd__decap_3
XFILLER_122_736 VGND VGND VPWR VPWR sky130_fd_sc_hd__decap_3
XFILLER_122_769 VGND VGND VPWR VPWR sky130_fd_sc_hd__decap_3
XFILLER_0_554 VGND VGND VPWR VPWR sky130_fd_sc_hd__decap_3
XFILLER_94_108 VGND VGND VPWR VPWR sky130_fd_sc_hd__fill_2
XFILLER_121_268 VGND VGND VPWR VPWR sky130_fd_sc_hd__decap_3
XFILLER_0_576 VGND VGND VPWR VPWR sky130_fd_sc_hd__fill_1
XFILLER_88_694 VGND VGND VPWR VPWR sky130_fd_sc_hd__fill_1
XFILLER_75_311 VGND VGND VPWR VPWR sky130_fd_sc_hd__decap_3
XFILLER_57_42 VGND VGND VPWR VPWR sky130_fd_sc_hd__decap_3
XFILLER_0_598 VGND VGND VPWR VPWR sky130_fd_sc_hd__decap_3
XFILLER_48_536 VGND VGND VPWR VPWR sky130_fd_sc_hd__decap_3
XFILLER_102_493 VGND VGND VPWR VPWR sky130_fd_sc_hd__decap_3
XFILLER_87_193 VGND VGND VPWR VPWR sky130_fd_sc_hd__fill_2
XFILLER_57_75 VGND VGND VPWR VPWR sky130_fd_sc_hd__fill_1
XFILLER_36_709 VGND VGND VPWR VPWR sky130_fd_sc_hd__decap_3
XFILLER_57_97 VGND VGND VPWR VPWR sky130_fd_sc_hd__decap_3
XFILLER_29_772 VGND VGND VPWR VPWR sky130_fd_sc_hd__decap_3
XFILLER_44_720 VGND VGND VPWR VPWR sky130_fd_sc_hd__fill_2
XFILLER_16_455 VGND VGND VPWR VPWR sky130_fd_sc_hd__fill_2
XFILLER_43_241 VGND VGND VPWR VPWR sky130_fd_sc_hd__fill_2
XFILLER_71_561 VGND VGND VPWR VPWR sky130_fd_sc_hd__decap_3
XFILLER_16_477 VGND VGND VPWR VPWR sky130_fd_sc_hd__decap_3
XFILLER_31_414 VGND VGND VPWR VPWR sky130_fd_sc_hd__decap_3
XFILLER_31_436 VGND VGND VPWR VPWR sky130_fd_sc_hd__decap_3
XFILLER_31_447 VGND VGND VPWR VPWR sky130_fd_sc_hd__fill_1
XFILLER_8_665 VGND VGND VPWR VPWR sky130_fd_sc_hd__decap_3
XFILLER_129_368 VGND VGND VPWR VPWR sky130_fd_sc_hd__fill_2
XTAP_TAPCELL_ROW_113_1806 VGND VPWR sky130_fd_sc_hd__tapvpwrvgnd_1
XFILLER_125_541 VGND VGND VPWR VPWR sky130_fd_sc_hd__decap_3
XTAP_TAPCELL_ROW_59_1082 VGND VPWR sky130_fd_sc_hd__tapvpwrvgnd_1
XFILLER_98_414 VGND VGND VPWR VPWR sky130_fd_sc_hd__decap_3
XFILLER_3_381 VGND VGND VPWR VPWR sky130_fd_sc_hd__decap_3
XFILLER_86_609 VGND VGND VPWR VPWR sky130_fd_sc_hd__fill_1
XTAP_TAPCELL_ROW_72_1260 VGND VPWR sky130_fd_sc_hd__tapvpwrvgnd_1
XFILLER_79_683 VGND VGND VPWR VPWR sky130_fd_sc_hd__decap_3
XFILLER_21_3 VGND VGND VPWR VPWR sky130_fd_sc_hd__decap_3
XFILLER_39_536 VGND VGND VPWR VPWR sky130_fd_sc_hd__decap_3
X_7990_ _7990_/A _7989_/Y VGND VGND VPWR VPWR _8119_/A sky130_fd_sc_hd__or2b_2
XFILLER_94_664 VGND VGND VPWR VPWR sky130_fd_sc_hd__decap_3
XFILLER_81_303 VGND VGND VPWR VPWR sky130_fd_sc_hd__fill_2
XFILLER_66_377 VGND VGND VPWR VPWR sky130_fd_sc_hd__decap_3
X_6941_ _6688_/A _6939_/X _6940_/X VGND VGND VPWR VPWR _7112_/A sky130_fd_sc_hd__a21o_2
XFILLER_19_293 VGND VGND VPWR VPWR sky130_fd_sc_hd__decap_3
XTAP_TAPCELL_ROW_124_1957 VGND VPWR sky130_fd_sc_hd__tapvpwrvgnd_1
X_6872_ _6872_/A _6872_/B VGND VGND VPWR VPWR _6882_/A sky130_fd_sc_hd__xnor2_2
X_8611_ _8611_/A VGND VGND VPWR VPWR _8690_/A sky130_fd_sc_hd__inv_2
X_5823_ _7099_/B _8066_/A VGND VGND VPWR VPWR _5823_/Y sky130_fd_sc_hd__nand2_2
XFILLER_50_723 VGND VGND VPWR VPWR sky130_fd_sc_hd__decap_3
XFILLER_22_414 VGND VGND VPWR VPWR sky130_fd_sc_hd__decap_3
XFILLER_50_745 VGND VGND VPWR VPWR sky130_fd_sc_hd__decap_3
XFILLER_22_458 VGND VGND VPWR VPWR sky130_fd_sc_hd__fill_2
X_8542_ _8578_/A _8578_/B VGND VGND VPWR VPWR _8633_/B sky130_fd_sc_hd__xnor2_2
X_5754_ _9204_/Q _8050_/B _5632_/B VGND VGND VPWR VPWR _5754_/Y sky130_fd_sc_hd__o21ai_2
XFILLER_22_469 VGND VGND VPWR VPWR sky130_fd_sc_hd__decap_3
X_4705_ _4705_/A VGND VGND VPWR VPWR _9100_/D sky130_fd_sc_hd__buf_1
X_8473_ _9221_/Q _8521_/S _8441_/C _8472_/Y _8446_/A VGND VGND VPWR VPWR _8473_/X
+ sky130_fd_sc_hd__o32a_2
XFILLER_30_480 VGND VGND VPWR VPWR sky130_fd_sc_hd__decap_3
X_5685_ _5685_/A _5685_/B VGND VGND VPWR VPWR _5685_/X sky130_fd_sc_hd__or2_4
X_7424_ _5975_/A _7611_/A2 _8066_/A VGND VGND VPWR VPWR _7602_/B sky130_fd_sc_hd__a21o_2
X_4636_ _9068_/Q _4636_/A1 _4650_/S VGND VGND VPWR VPWR _4636_/X sky130_fd_sc_hd__mux2_2
XFILLER_118_15 VGND VGND VPWR VPWR sky130_fd_sc_hd__decap_3
XTAP_TAPCELL_ROW_9_407 VGND VPWR sky130_fd_sc_hd__tapvpwrvgnd_1
X_7355_ _7355_/A _7355_/B VGND VGND VPWR VPWR _7373_/A sky130_fd_sc_hd__and2_2
X_4567_ _4567_/A VGND VGND VPWR VPWR _9035_/D sky130_fd_sc_hd__buf_1
XFILLER_118_59 VGND VGND VPWR VPWR sky130_fd_sc_hd__decap_3
X_6306_ _5137_/X _5138_/X _8405_/B VGND VGND VPWR VPWR _6575_/B sky130_fd_sc_hd__a21oi_2
XFILLER_1_307 VGND VGND VPWR VPWR sky130_fd_sc_hd__decap_3
XFILLER_116_574 VGND VGND VPWR VPWR sky130_fd_sc_hd__fill_2
X_7286_ _7272_/B _7285_/B _7285_/C _7142_/C _7272_/X VGND VGND VPWR VPWR _7287_/C
+ sky130_fd_sc_hd__a32o_2
XFILLER_89_425 VGND VGND VPWR VPWR sky130_fd_sc_hd__decap_3
XFILLER_103_213 VGND VGND VPWR VPWR sky130_fd_sc_hd__fill_2
XFILLER_89_447 VGND VGND VPWR VPWR sky130_fd_sc_hd__fill_1
X_9025_ _9341_/CLK _9025_/D load_slew378/X VGND VGND VPWR VPWR _9025_/Q sky130_fd_sc_hd__dfrtp_2
X_6237_ _9126_/Q _6756_/C _6758_/C _9110_/Q _5738_/S VGND VGND VPWR VPWR _6239_/B
+ sky130_fd_sc_hd__a221o_2
XFILLER_103_268 VGND VGND VPWR VPWR sky130_fd_sc_hd__fill_1
X_6168_ _6010_/A _7071_/A _6279_/C _6279_/B VGND VGND VPWR VPWR _6172_/C sky130_fd_sc_hd__a211o_4
XFILLER_85_620 VGND VGND VPWR VPWR sky130_fd_sc_hd__fill_1
XFILLER_97_491 VGND VGND VPWR VPWR sky130_fd_sc_hd__decap_3
XFILLER_94_29 VGND VGND VPWR VPWR sky130_fd_sc_hd__decap_3
X_5119_ _9289_/Q _9021_/Q _5119_/S VGND VGND VPWR VPWR _5120_/C sky130_fd_sc_hd__mux2_2
XFILLER_84_141 VGND VGND VPWR VPWR sky130_fd_sc_hd__fill_1
X_6099_ _6446_/A _6103_/S VGND VGND VPWR VPWR _6099_/Y sky130_fd_sc_hd__nand2_2
XFILLER_57_366 VGND VGND VPWR VPWR sky130_fd_sc_hd__decap_3
XFILLER_27_23 VGND VGND VPWR VPWR sky130_fd_sc_hd__decap_3
XFILLER_85_686 VGND VGND VPWR VPWR sky130_fd_sc_hd__decap_3
XFILLER_84_163 VGND VGND VPWR VPWR sky130_fd_sc_hd__decap_3
XFILLER_45_528 VGND VGND VPWR VPWR sky130_fd_sc_hd__decap_3
XFILLER_17_219 VGND VGND VPWR VPWR sky130_fd_sc_hd__decap_3
XFILLER_57_399 VGND VGND VPWR VPWR sky130_fd_sc_hd__fill_1
XFILLER_27_67 VGND VGND VPWR VPWR sky130_fd_sc_hd__decap_3
XFILLER_26_753 VGND VGND VPWR VPWR sky130_fd_sc_hd__decap_3
XFILLER_26_775 VGND VGND VPWR VPWR sky130_fd_sc_hd__fill_2
XFILLER_53_561 VGND VGND VPWR VPWR sky130_fd_sc_hd__decap_3
XFILLER_41_712 VGND VGND VPWR VPWR sky130_fd_sc_hd__decap_3
XTAP_TAPCELL_ROW_36_770 VGND VPWR sky130_fd_sc_hd__tapvpwrvgnd_1
XFILLER_40_200 VGND VGND VPWR VPWR sky130_fd_sc_hd__decap_3
X_8809_ _8809_/A VGND VGND VPWR VPWR _9249_/D sky130_fd_sc_hd__buf_1
XFILLER_80_391 VGND VGND VPWR VPWR sky130_fd_sc_hd__decap_3
XFILLER_43_44 VGND VGND VPWR VPWR sky130_fd_sc_hd__decap_3
XFILLER_40_222 VGND VGND VPWR VPWR sky130_fd_sc_hd__decap_3
XFILLER_43_66 VGND VGND VPWR VPWR sky130_fd_sc_hd__fill_2
XFILLER_21_480 VGND VGND VPWR VPWR sky130_fd_sc_hd__decap_3
XFILLER_126_316 VGND VGND VPWR VPWR sky130_fd_sc_hd__decap_3
XFILLER_5_613 VGND VGND VPWR VPWR sky130_fd_sc_hd__decap_3
XFILLER_4_112 VGND VGND VPWR VPWR sky130_fd_sc_hd__fill_1
XFILLER_126_338 VGND VGND VPWR VPWR sky130_fd_sc_hd__decap_3
XFILLER_4_123 VGND VGND VPWR VPWR sky130_fd_sc_hd__decap_3
XFILLER_107_552 VGND VGND VPWR VPWR sky130_fd_sc_hd__decap_3
XFILLER_5_668 VGND VGND VPWR VPWR sky130_fd_sc_hd__decap_3
XFILLER_5_679 VGND VGND VPWR VPWR sky130_fd_sc_hd__decap_3
XFILLER_107_585 VGND VGND VPWR VPWR sky130_fd_sc_hd__decap_3
XFILLER_4_27 VGND VGND VPWR VPWR sky130_fd_sc_hd__fill_1
XFILLER_4_38 VGND VGND VPWR VPWR sky130_fd_sc_hd__decap_3
XFILLER_122_533 VGND VGND VPWR VPWR sky130_fd_sc_hd__decap_3
XFILLER_0_340 VGND VGND VPWR VPWR sky130_fd_sc_hd__decap_3
XTAP_TAPCELL_ROW_128_2013 VGND VPWR sky130_fd_sc_hd__tapvpwrvgnd_1
XFILLER_110_728 VGND VGND VPWR VPWR sky130_fd_sc_hd__decap_3
XFILLER_0_362 VGND VGND VPWR VPWR sky130_fd_sc_hd__fill_2
XFILLER_68_85 VGND VGND VPWR VPWR sky130_fd_sc_hd__decap_3
XFILLER_67_119 VGND VGND VPWR VPWR sky130_fd_sc_hd__decap_3
XFILLER_88_491 VGND VGND VPWR VPWR sky130_fd_sc_hd__fill_1
XFILLER_76_642 VGND VGND VPWR VPWR sky130_fd_sc_hd__fill_2
XFILLER_76_664 VGND VGND VPWR VPWR sky130_fd_sc_hd__decap_3
XFILLER_36_517 VGND VGND VPWR VPWR sky130_fd_sc_hd__decap_3
XFILLER_124_80 VGND VGND VPWR VPWR sky130_fd_sc_hd__decap_3
XFILLER_91_612 VGND VGND VPWR VPWR sky130_fd_sc_hd__decap_3
XFILLER_75_163 VGND VGND VPWR VPWR sky130_fd_sc_hd__decap_3
XFILLER_124_91 VGND VGND VPWR VPWR sky130_fd_sc_hd__decap_3
XFILLER_90_100 VGND VGND VPWR VPWR sky130_fd_sc_hd__decap_3
XFILLER_63_325 VGND VGND VPWR VPWR sky130_fd_sc_hd__fill_2
XFILLER_36_539 VGND VGND VPWR VPWR sky130_fd_sc_hd__decap_3
XFILLER_63_358 VGND VGND VPWR VPWR sky130_fd_sc_hd__decap_3
XFILLER_17_753 VGND VGND VPWR VPWR sky130_fd_sc_hd__decap_3
XFILLER_90_155 VGND VGND VPWR VPWR sky130_fd_sc_hd__fill_2
XFILLER_16_241 VGND VGND VPWR VPWR sky130_fd_sc_hd__decap_3
XFILLER_44_561 VGND VGND VPWR VPWR sky130_fd_sc_hd__decap_3
XFILLER_32_712 VGND VGND VPWR VPWR sky130_fd_sc_hd__decap_3
XFILLER_31_222 VGND VGND VPWR VPWR sky130_fd_sc_hd__fill_2
XFILLER_16_296 VGND VGND VPWR VPWR sky130_fd_sc_hd__fill_2
XFILLER_90_6 VGND VGND VPWR VPWR sky130_fd_sc_hd__decap_3
XTAP_TAPCELL_ROW_14_464 VGND VPWR sky130_fd_sc_hd__tapvpwrvgnd_1
XFILLER_31_277 VGND VGND VPWR VPWR sky130_fd_sc_hd__decap_3
XTAP_TAPCELL_ROW_14_475 VGND VPWR sky130_fd_sc_hd__tapvpwrvgnd_1
XFILLER_129_143 VGND VGND VPWR VPWR sky130_fd_sc_hd__decap_3
XFILLER_117_316 VGND VGND VPWR VPWR sky130_fd_sc_hd__decap_3
X_5470_ _9261_/Q _9057_/Q _5611_/S VGND VGND VPWR VPWR _5470_/X sky130_fd_sc_hd__mux2_2
XFILLER_69_3 VGND VGND VPWR VPWR sky130_fd_sc_hd__decap_3
XFILLER_129_187 VGND VGND VPWR VPWR sky130_fd_sc_hd__decap_3
XFILLER_99_701 VGND VGND VPWR VPWR sky130_fd_sc_hd__decap_3
X_7140_ _7274_/B _7139_/Y _7142_/C _7272_/B VGND VGND VPWR VPWR _7140_/X sky130_fd_sc_hd__a2bb2o_2
XFILLER_98_200 VGND VGND VPWR VPWR sky130_fd_sc_hd__fill_1
XFILLER_125_371 VGND VGND VPWR VPWR sky130_fd_sc_hd__decap_3
XFILLER_113_511 VGND VGND VPWR VPWR sky130_fd_sc_hd__decap_3
XFILLER_125_393 VGND VGND VPWR VPWR sky130_fd_sc_hd__fill_2
X_7071_ _7071_/A _7071_/B _7417_/A _7071_/D VGND VGND VPWR VPWR _7071_/X sky130_fd_sc_hd__and4_2
XFILLER_113_577 VGND VGND VPWR VPWR sky130_fd_sc_hd__decap_3
X_6022_ _6022_/A _6190_/A VGND VGND VPWR VPWR _6023_/A sky130_fd_sc_hd__xor2_2
XFILLER_86_439 VGND VGND VPWR VPWR sky130_fd_sc_hd__decap_3
XFILLER_113_599 VGND VGND VPWR VPWR sky130_fd_sc_hd__fill_1
XFILLER_39_333 VGND VGND VPWR VPWR sky130_fd_sc_hd__decap_3
XFILLER_94_461 VGND VGND VPWR VPWR sky130_fd_sc_hd__decap_3
XFILLER_54_303 VGND VGND VPWR VPWR sky130_fd_sc_hd__decap_3
XFILLER_54_314 VGND VGND VPWR VPWR sky130_fd_sc_hd__decap_3
XFILLER_94_483 VGND VGND VPWR VPWR sky130_fd_sc_hd__decap_3
XFILLER_39_399 VGND VGND VPWR VPWR sky130_fd_sc_hd__decap_3
X_7973_ _7569_/A _8080_/A _8248_/B VGND VGND VPWR VPWR _7974_/B sky130_fd_sc_hd__a21oi_2
XFILLER_82_645 VGND VGND VPWR VPWR sky130_fd_sc_hd__decap_3
X_6924_ _6924_/A _6924_/B _6924_/C VGND VGND VPWR VPWR _6924_/X sky130_fd_sc_hd__and3_4
XFILLER_35_550 VGND VGND VPWR VPWR sky130_fd_sc_hd__decap_3
XFILLER_82_689 VGND VGND VPWR VPWR sky130_fd_sc_hd__decap_3
XFILLER_81_188 VGND VGND VPWR VPWR sky130_fd_sc_hd__decap_3
XFILLER_120_27 VGND VGND VPWR VPWR sky130_fd_sc_hd__fill_1
XFILLER_120_38 VGND VGND VPWR VPWR sky130_fd_sc_hd__decap_3
X_6855_ _6835_/A _6834_/B _6854_/X VGND VGND VPWR VPWR _6893_/A sky130_fd_sc_hd__o21a_2
XFILLER_62_380 VGND VGND VPWR VPWR sky130_fd_sc_hd__decap_3
XFILLER_35_594 VGND VGND VPWR VPWR sky130_fd_sc_hd__decap_3
XFILLER_22_211 VGND VGND VPWR VPWR sky130_fd_sc_hd__fill_1
XFILLER_23_756 VGND VGND VPWR VPWR sky130_fd_sc_hd__decap_3
XFILLER_22_233 VGND VGND VPWR VPWR sky130_fd_sc_hd__fill_1
X_5806_ _5950_/A _5802_/X _5805_/X VGND VGND VPWR VPWR _5806_/X sky130_fd_sc_hd__a21o_2
X_6786_ _6786_/A _6786_/B VGND VGND VPWR VPWR _6786_/Y sky130_fd_sc_hd__nor2_2
XFILLER_50_575 VGND VGND VPWR VPWR sky130_fd_sc_hd__decap_3
X_8525_ _9224_/Q wire67/X VGND VGND VPWR VPWR _8525_/Y sky130_fd_sc_hd__nand2_2
XFILLER_22_288 VGND VGND VPWR VPWR sky130_fd_sc_hd__decap_3
XFILLER_13_36 VGND VGND VPWR VPWR sky130_fd_sc_hd__decap_3
X_5737_ _8780_/A _5737_/B _7794_/B _5737_/D VGND VGND VPWR VPWR _5742_/B sky130_fd_sc_hd__and4_2
XFILLER_129_36 VGND VGND VPWR VPWR sky130_fd_sc_hd__decap_3
X_8456_ _8463_/A _8463_/B VGND VGND VPWR VPWR _8457_/B sky130_fd_sc_hd__nand2_2
X_5668_ _5668_/A _5668_/B VGND VGND VPWR VPWR _5669_/B sky130_fd_sc_hd__xnor2_4
XFILLER_89_18 VGND VGND VPWR VPWR sky130_fd_sc_hd__decap_3
XFILLER_129_69 VGND VGND VPWR VPWR sky130_fd_sc_hd__decap_3
X_7407_ _7407_/A _7408_/A _7408_/B VGND VGND VPWR VPWR _7407_/X sky130_fd_sc_hd__or3_2
X_4619_ hold920/X _4619_/A1 _4629_/S VGND VGND VPWR VPWR _4620_/A sky130_fd_sc_hd__mux2_2
X_8387_ _8459_/A _8387_/B VGND VGND VPWR VPWR _8388_/B sky130_fd_sc_hd__nand2_2
X_5599_ _7099_/C _6010_/A VGND VGND VPWR VPWR _5603_/A sky130_fd_sc_hd__nand2_2
XTAP_TAPCELL_ROW_96_1580 VGND VPWR sky130_fd_sc_hd__tapvpwrvgnd_1
XFILLER_2_616 VGND VGND VPWR VPWR sky130_fd_sc_hd__decap_3
X_7338_ _7416_/A _7417_/B _5855_/B _7430_/B VGND VGND VPWR VPWR _7340_/B sky130_fd_sc_hd__a211o_2
XFILLER_116_371 VGND VGND VPWR VPWR sky130_fd_sc_hd__decap_3
XFILLER_104_533 VGND VGND VPWR VPWR sky130_fd_sc_hd__decap_3
Xmax_cap181 _7153_/A VGND VGND VPWR VPWR _8013_/A sky130_fd_sc_hd__buf_4
Xmax_cap192 _4955_/B VGND VGND VPWR VPWR _6753_/B sky130_fd_sc_hd__buf_4
XFILLER_1_137 VGND VGND VPWR VPWR sky130_fd_sc_hd__decap_3
X_7269_ _7259_/X _7261_/Y _7262_/X _7508_/B _7268_/X VGND VGND VPWR VPWR _7270_/B
+ sky130_fd_sc_hd__o221a_2
XFILLER_49_108 VGND VGND VPWR VPWR sky130_fd_sc_hd__decap_3
X_9008_ _9008_/A VGND VGND VPWR VPWR _9344_/D sky130_fd_sc_hd__buf_1
XFILLER_49_119 VGND VGND VPWR VPWR sky130_fd_sc_hd__decap_3
XFILLER_58_642 VGND VGND VPWR VPWR sky130_fd_sc_hd__fill_2
Xhold1140 _9318_/Q VGND VGND VPWR VPWR _8986_/A1 sky130_fd_sc_hd__dlygate4sd3_1
Xhold1151 _9112_/Q VGND VGND VPWR VPWR _4763_/A1 sky130_fd_sc_hd__dlygate4sd3_1
XFILLER_73_612 VGND VGND VPWR VPWR sky130_fd_sc_hd__decap_3
XFILLER_58_686 VGND VGND VPWR VPWR sky130_fd_sc_hd__fill_1
Xhold1162 _9335_/Q VGND VGND VPWR VPWR _4532_/A1 sky130_fd_sc_hd__dlygate4sd3_1
XFILLER_38_99 VGND VGND VPWR VPWR sky130_fd_sc_hd__decap_3
Xhold1173 _9126_/Q VGND VGND VPWR VPWR _4792_/A1 sky130_fd_sc_hd__dlygate4sd3_1
XFILLER_85_483 VGND VGND VPWR VPWR sky130_fd_sc_hd__decap_3
Xhold1184 _9078_/Q VGND VGND VPWR VPWR _4691_/A1 sky130_fd_sc_hd__dlygate4sd3_1
XFILLER_73_645 VGND VGND VPWR VPWR sky130_fd_sc_hd__decap_3
Xhold1195 _4786_/X VGND VGND VPWR VPWR _4787_/A sky130_fd_sc_hd__dlygate4sd3_1
XFILLER_54_32 VGND VGND VPWR VPWR sky130_fd_sc_hd__decap_3
XFILLER_14_701 VGND VGND VPWR VPWR sky130_fd_sc_hd__decap_3
XFILLER_41_520 VGND VGND VPWR VPWR sky130_fd_sc_hd__decap_3
XFILLER_14_734 VGND VGND VPWR VPWR sky130_fd_sc_hd__decap_3
XFILLER_53_391 VGND VGND VPWR VPWR sky130_fd_sc_hd__fill_1
XFILLER_13_222 VGND VGND VPWR VPWR sky130_fd_sc_hd__fill_2
XFILLER_13_233 VGND VGND VPWR VPWR sky130_fd_sc_hd__decap_3
XFILLER_41_553 VGND VGND VPWR VPWR sky130_fd_sc_hd__decap_3
XFILLER_9_204 VGND VGND VPWR VPWR sky130_fd_sc_hd__decap_3
XFILLER_13_266 VGND VGND VPWR VPWR sky130_fd_sc_hd__fill_1
XFILLER_110_71 VGND VGND VPWR VPWR sky130_fd_sc_hd__fill_1
XFILLER_13_277 VGND VGND VPWR VPWR sky130_fd_sc_hd__decap_3
XFILLER_9_248 VGND VGND VPWR VPWR sky130_fd_sc_hd__decap_3
XFILLER_110_93 VGND VGND VPWR VPWR sky130_fd_sc_hd__decap_3
XTAP_TAPCELL_ROW_11_434 VGND VPWR sky130_fd_sc_hd__tapvpwrvgnd_1
Xclkload18 _9232_/CLK VGND VGND VPWR VPWR clkload18/Y sky130_fd_sc_hd__inv_4
Xclkload29 _9227_/CLK VGND VGND VPWR VPWR clkload29/X sky130_fd_sc_hd__clkbuf_4
XFILLER_127_647 VGND VGND VPWR VPWR sky130_fd_sc_hd__decap_3
XFILLER_126_124 VGND VGND VPWR VPWR sky130_fd_sc_hd__decap_3
Xrebuffer570 _9236_/Q VGND VGND VPWR VPWR hold1250/A sky130_fd_sc_hd__buf_2
Xrebuffer581 wire48/X VGND VGND VPWR VPWR _6387_/A sky130_fd_sc_hd__buf_2
XFILLER_5_443 VGND VGND VPWR VPWR sky130_fd_sc_hd__decap_3
Xrebuffer592 _6249_/A VGND VGND VPWR VPWR _6544_/B sky130_fd_sc_hd__buf_2
XFILLER_55_9 VGND VGND VPWR VPWR sky130_fd_sc_hd__decap_3
XFILLER_126_168 VGND VGND VPWR VPWR sky130_fd_sc_hd__decap_3
XFILLER_107_360 VGND VGND VPWR VPWR sky130_fd_sc_hd__decap_3
XFILLER_79_51 VGND VGND VPWR VPWR sky130_fd_sc_hd__fill_2
XFILLER_107_382 VGND VGND VPWR VPWR sky130_fd_sc_hd__decap_3
XTAP_TAPCELL_ROW_56_1041 VGND VPWR sky130_fd_sc_hd__tapvpwrvgnd_1
XFILLER_96_704 VGND VGND VPWR VPWR sky130_fd_sc_hd__fill_1
XFILLER_96_726 VGND VGND VPWR VPWR sky130_fd_sc_hd__decap_3
XFILLER_122_363 VGND VGND VPWR VPWR sky130_fd_sc_hd__fill_1
XFILLER_122_374 VGND VGND VPWR VPWR sky130_fd_sc_hd__decap_3
XFILLER_1_671 VGND VGND VPWR VPWR sky130_fd_sc_hd__fill_1
XFILLER_1_682 VGND VGND VPWR VPWR sky130_fd_sc_hd__decap_3
XFILLER_122_385 VGND VGND VPWR VPWR sky130_fd_sc_hd__decap_3
XFILLER_95_61 VGND VGND VPWR VPWR sky130_fd_sc_hd__decap_3
XFILLER_48_141 VGND VGND VPWR VPWR sky130_fd_sc_hd__fill_2
XFILLER_64_601 VGND VGND VPWR VPWR sky130_fd_sc_hd__fill_2
XFILLER_76_472 VGND VGND VPWR VPWR sky130_fd_sc_hd__decap_3
XFILLER_64_612 VGND VGND VPWR VPWR sky130_fd_sc_hd__decap_3
XFILLER_48_174 VGND VGND VPWR VPWR sky130_fd_sc_hd__decap_3
XTAP_TAPCELL_ROW_108_1738 VGND VPWR sky130_fd_sc_hd__tapvpwrvgnd_1
XFILLER_91_420 VGND VGND VPWR VPWR sky130_fd_sc_hd__decap_3
XFILLER_64_645 VGND VGND VPWR VPWR sky130_fd_sc_hd__decap_3
XFILLER_36_336 VGND VGND VPWR VPWR sky130_fd_sc_hd__fill_2
XTAP_TAPCELL_ROW_19_534 VGND VPWR sky130_fd_sc_hd__tapvpwrvgnd_1
XFILLER_63_144 VGND VGND VPWR VPWR sky130_fd_sc_hd__decap_3
X_4970_ _5514_/A VGND VGND VPWR VPWR _4970_/X sky130_fd_sc_hd__clkbuf_1
XFILLER_17_561 VGND VGND VPWR VPWR sky130_fd_sc_hd__decap_3
XFILLER_51_317 VGND VGND VPWR VPWR sky130_fd_sc_hd__decap_3
XTAP_TAPCELL_ROW_121_1916 VGND VPWR sky130_fd_sc_hd__tapvpwrvgnd_1
XFILLER_63_188 VGND VGND VPWR VPWR sky130_fd_sc_hd__fill_2
XTAP_TAPCELL_ROW_67_1181 VGND VPWR sky130_fd_sc_hd__tapvpwrvgnd_1
XTAP_TAPCELL_ROW_67_1192 VGND VPWR sky130_fd_sc_hd__tapvpwrvgnd_1
X_6640_ _6643_/A _6640_/B _6640_/C VGND VGND VPWR VPWR _6657_/A sky130_fd_sc_hd__or3_4
XFILLER_20_704 VGND VGND VPWR VPWR sky130_fd_sc_hd__decap_3
XFILLER_20_737 VGND VGND VPWR VPWR sky130_fd_sc_hd__decap_3
X_6571_ _7430_/A _7065_/A _5584_/X _6972_/A VGND VGND VPWR VPWR _6571_/X sky130_fd_sc_hd__o211a_2
X_8310_ _8066_/B _8163_/A _8309_/Y _8405_/B VGND VGND VPWR VPWR _8311_/B sky130_fd_sc_hd__o22a_2
X_5522_ _6817_/A _5522_/B VGND VGND VPWR VPWR _5524_/C sky130_fd_sc_hd__xnor2_2
XFILLER_9_771 VGND VGND VPWR VPWR sky130_fd_sc_hd__decap_3
X_9290_ _9338_/CLK _9290_/D load_slew370/X VGND VGND VPWR VPWR _9290_/Q sky130_fd_sc_hd__dfrtp_2
XFILLER_117_102 VGND VGND VPWR VPWR sky130_fd_sc_hd__decap_3
XFILLER_117_113 VGND VGND VPWR VPWR sky130_fd_sc_hd__decap_3
X_8241_ _8313_/A _8411_/A VGND VGND VPWR VPWR _8329_/A sky130_fd_sc_hd__nand2_2
XFILLER_8_292 VGND VGND VPWR VPWR sky130_fd_sc_hd__decap_3
XFILLER_118_669 VGND VGND VPWR VPWR sky130_fd_sc_hd__decap_3
X_5453_ _5346_/A _5346_/B _5347_/A VGND VGND VPWR VPWR _5453_/X sky130_fd_sc_hd__a21bo_2
XTAP_TAPCELL_ROW_119_1889 VGND VPWR sky130_fd_sc_hd__tapvpwrvgnd_1
X_8172_ _8058_/B _8057_/A _8057_/B VGND VGND VPWR VPWR _8172_/X sky130_fd_sc_hd__o21a_2
XFILLER_99_520 VGND VGND VPWR VPWR sky130_fd_sc_hd__decap_3
X_5384_ _5384_/A _5462_/S _9136_/Q VGND VGND VPWR VPWR _5384_/X sky130_fd_sc_hd__and3_2
XFILLER_99_542 VGND VGND VPWR VPWR sky130_fd_sc_hd__decap_3
X_7123_ _9213_/Q _7123_/B VGND VGND VPWR VPWR _7124_/B sky130_fd_sc_hd__xor2_2
XFILLER_125_190 VGND VGND VPWR VPWR sky130_fd_sc_hd__decap_3
XFILLER_99_586 VGND VGND VPWR VPWR sky130_fd_sc_hd__fill_1
XFILLER_59_417 VGND VGND VPWR VPWR sky130_fd_sc_hd__decap_3
Xfanout238 _9237_/Q VGND VGND VPWR VPWR _8175_/A sky130_fd_sc_hd__clkbuf_4
XFILLER_99_597 VGND VGND VPWR VPWR sky130_fd_sc_hd__decap_3
XFILLER_115_27 VGND VGND VPWR VPWR sky130_fd_sc_hd__decap_3
XFILLER_101_525 VGND VGND VPWR VPWR sky130_fd_sc_hd__decap_3
X_7054_ _7303_/A _7054_/B VGND VGND VPWR VPWR _7055_/B sky130_fd_sc_hd__xnor2_2
Xfanout249 _9235_/Q VGND VGND VPWR VPWR fanout249/X sky130_fd_sc_hd__buf_6
XFILLER_113_396 VGND VGND VPWR VPWR sky130_fd_sc_hd__decap_3
XFILLER_101_558 VGND VGND VPWR VPWR sky130_fd_sc_hd__fill_2
X_6005_ _6005_/A _6005_/B VGND VGND VPWR VPWR _6007_/B sky130_fd_sc_hd__xnor2_2
XFILLER_86_269 VGND VGND VPWR VPWR sky130_fd_sc_hd__fill_1
XFILLER_27_303 VGND VGND VPWR VPWR sky130_fd_sc_hd__decap_3
XFILLER_27_325 VGND VGND VPWR VPWR sky130_fd_sc_hd__decap_3
XFILLER_55_656 VGND VGND VPWR VPWR sky130_fd_sc_hd__decap_3
X_7956_ _8154_/A _8312_/A _8313_/A _8232_/A VGND VGND VPWR VPWR _7956_/X sky130_fd_sc_hd__a22o_2
XFILLER_42_306 VGND VGND VPWR VPWR sky130_fd_sc_hd__fill_2
X_6907_ _6907_/A _6907_/B VGND VGND VPWR VPWR _6907_/Y sky130_fd_sc_hd__xnor2_2
X_7887_ _8035_/S _7887_/B VGND VGND VPWR VPWR _7888_/B sky130_fd_sc_hd__xnor2_2
XFILLER_24_24 VGND VGND VPWR VPWR sky130_fd_sc_hd__decap_3
XFILLER_23_542 VGND VGND VPWR VPWR sky130_fd_sc_hd__decap_3
X_6838_ _6900_/A _6900_/B VGND VGND VPWR VPWR _6894_/A sky130_fd_sc_hd__and2_2
XFILLER_23_564 VGND VGND VPWR VPWR sky130_fd_sc_hd__decap_3
XFILLER_11_726 VGND VGND VPWR VPWR sky130_fd_sc_hd__fill_2
XFILLER_24_79 VGND VGND VPWR VPWR sky130_fd_sc_hd__decap_3
XFILLER_23_597 VGND VGND VPWR VPWR sky130_fd_sc_hd__decap_3
XFILLER_50_383 VGND VGND VPWR VPWR sky130_fd_sc_hd__decap_3
X_6769_ _6770_/A _6770_/B _6907_/B VGND VGND VPWR VPWR _6769_/Y sky130_fd_sc_hd__a21oi_2
XFILLER_11_759 VGND VGND VPWR VPWR sky130_fd_sc_hd__decap_3
XFILLER_7_719 VGND VGND VPWR VPWR sky130_fd_sc_hd__decap_3
X_8508_ wire313/X _8562_/A _7561_/A _8774_/C1 VGND VGND VPWR VPWR _8508_/X sky130_fd_sc_hd__o211a_2
XFILLER_6_218 VGND VGND VPWR VPWR sky130_fd_sc_hd__decap_3
X_8439_ _8446_/A _8739_/B _8438_/Y VGND VGND VPWR VPWR _8439_/Y sky130_fd_sc_hd__a21oi_2
XFILLER_123_105 VGND VGND VPWR VPWR sky130_fd_sc_hd__decap_3
XFILLER_123_116 VGND VGND VPWR VPWR sky130_fd_sc_hd__decap_3
XFILLER_123_149 VGND VGND VPWR VPWR sky130_fd_sc_hd__decap_3
XFILLER_2_468 VGND VGND VPWR VPWR sky130_fd_sc_hd__decap_3
XFILLER_78_715 VGND VGND VPWR VPWR sky130_fd_sc_hd__fill_2
XFILLER_77_225 VGND VGND VPWR VPWR sky130_fd_sc_hd__decap_3
XFILLER_49_87 VGND VGND VPWR VPWR sky130_fd_sc_hd__decap_3
XFILLER_93_718 VGND VGND VPWR VPWR sky130_fd_sc_hd__decap_3
XFILLER_93_729 VGND VGND VPWR VPWR sky130_fd_sc_hd__decap_3
XFILLER_86_770 VGND VGND VPWR VPWR sky130_fd_sc_hd__decap_3
XFILLER_1_39 VGND VGND VPWR VPWR sky130_fd_sc_hd__decap_3
XFILLER_46_623 VGND VGND VPWR VPWR sky130_fd_sc_hd__decap_3
XFILLER_18_325 VGND VGND VPWR VPWR sky130_fd_sc_hd__decap_3
XFILLER_73_431 VGND VGND VPWR VPWR sky130_fd_sc_hd__decap_3
XFILLER_46_645 VGND VGND VPWR VPWR sky130_fd_sc_hd__decap_3
XFILLER_45_122 VGND VGND VPWR VPWR sky130_fd_sc_hd__decap_3
XFILLER_85_291 VGND VGND VPWR VPWR sky130_fd_sc_hd__decap_3
XFILLER_46_667 VGND VGND VPWR VPWR sky130_fd_sc_hd__decap_3
XFILLER_45_133 VGND VGND VPWR VPWR sky130_fd_sc_hd__decap_3
XFILLER_73_464 VGND VGND VPWR VPWR sky130_fd_sc_hd__decap_3
XFILLER_61_604 VGND VGND VPWR VPWR sky130_fd_sc_hd__decap_3
XTAP_TAPCELL_ROW_16_504 VGND VPWR sky130_fd_sc_hd__tapvpwrvgnd_1
XFILLER_33_317 VGND VGND VPWR VPWR sky130_fd_sc_hd__decap_3
XFILLER_33_328 VGND VGND VPWR VPWR sky130_fd_sc_hd__decap_3
XFILLER_45_188 VGND VGND VPWR VPWR sky130_fd_sc_hd__decap_3
XFILLER_61_648 VGND VGND VPWR VPWR sky130_fd_sc_hd__decap_3
XFILLER_60_136 VGND VGND VPWR VPWR sky130_fd_sc_hd__decap_3
XFILLER_26_380 VGND VGND VPWR VPWR sky130_fd_sc_hd__decap_3
XFILLER_14_531 VGND VGND VPWR VPWR sky130_fd_sc_hd__fill_1
XFILLER_60_147 VGND VGND VPWR VPWR sky130_fd_sc_hd__decap_3
XFILLER_121_81 VGND VGND VPWR VPWR sky130_fd_sc_hd__decap_3
XTAP_TAPCELL_ROW_44_879 VGND VPWR sky130_fd_sc_hd__tapvpwrvgnd_1
XTAP_TAPCELL_ROW_103_1668 VGND VPWR sky130_fd_sc_hd__tapvpwrvgnd_1
XFILLER_14_586 VGND VGND VPWR VPWR sky130_fd_sc_hd__fill_2
XPHY_EDGE_ROW_116_Right_116 VGND VGND VPWR VPWR sky130_fd_sc_hd__decap_3
XFILLER_6_752 VGND VGND VPWR VPWR sky130_fd_sc_hd__decap_3
XFILLER_6_763 VGND VGND VPWR VPWR sky130_fd_sc_hd__decap_3
XFILLER_5_240 VGND VGND VPWR VPWR sky130_fd_sc_hd__decap_3
XFILLER_127_477 VGND VGND VPWR VPWR sky130_fd_sc_hd__decap_3
XFILLER_53_6 VGND VGND VPWR VPWR sky130_fd_sc_hd__fill_2
XFILLER_115_628 VGND VGND VPWR VPWR sky130_fd_sc_hd__decap_3
XFILLER_5_284 VGND VGND VPWR VPWR sky130_fd_sc_hd__decap_3
XFILLER_96_512 VGND VGND VPWR VPWR sky130_fd_sc_hd__decap_3
XFILLER_69_737 VGND VGND VPWR VPWR sky130_fd_sc_hd__decap_3
XFILLER_68_225 VGND VGND VPWR VPWR sky130_fd_sc_hd__decap_3
XFILLER_123_694 VGND VGND VPWR VPWR sky130_fd_sc_hd__decap_3
XFILLER_122_171 VGND VGND VPWR VPWR sky130_fd_sc_hd__decap_3
XFILLER_96_556 VGND VGND VPWR VPWR sky130_fd_sc_hd__decap_3
XFILLER_110_333 VGND VGND VPWR VPWR sky130_fd_sc_hd__decap_3
XFILLER_110_377 VGND VGND VPWR VPWR sky130_fd_sc_hd__fill_1
Xinput5 sample_in[12] VGND VGND VPWR VPWR input5/X sky130_fd_sc_hd__clkdlybuf4s25_1
XFILLER_49_472 VGND VGND VPWR VPWR sky130_fd_sc_hd__decap_3
XFILLER_37_612 VGND VGND VPWR VPWR sky130_fd_sc_hd__decap_3
XTAP_TAPCELL_ROW_69_1210 VGND VPWR sky130_fd_sc_hd__tapvpwrvgnd_1
XFILLER_36_100 VGND VGND VPWR VPWR sky130_fd_sc_hd__decap_3
XFILLER_37_634 VGND VGND VPWR VPWR sky130_fd_sc_hd__decap_3
XFILLER_92_740 VGND VGND VPWR VPWR sky130_fd_sc_hd__decap_3
X_7810_ _7810_/A _7810_/B VGND VGND VPWR VPWR _7981_/B sky130_fd_sc_hd__xnor2_2
XFILLER_64_464 VGND VGND VPWR VPWR sky130_fd_sc_hd__fill_2
X_8790_ _8790_/A VGND VGND VPWR VPWR _9240_/D sky130_fd_sc_hd__buf_1
XFILLER_64_486 VGND VGND VPWR VPWR sky130_fd_sc_hd__decap_3
XFILLER_36_188 VGND VGND VPWR VPWR sky130_fd_sc_hd__decap_3
XFILLER_101_18 VGND VGND VPWR VPWR sky130_fd_sc_hd__fill_1
X_7741_ _7741_/A _7741_/B VGND VGND VPWR VPWR _7741_/Y sky130_fd_sc_hd__xnor2_2
X_4953_ _4953_/A VGND VGND VPWR VPWR _5743_/B sky130_fd_sc_hd__buf_12
XFILLER_51_169 VGND VGND VPWR VPWR sky130_fd_sc_hd__decap_3
X_7672_ _7539_/A _7667_/Y _7671_/X VGND VGND VPWR VPWR _7688_/A sky130_fd_sc_hd__o21a_2
X_4884_ _4876_/X _4883_/Y _4878_/X hold784/X VGND VGND VPWR VPWR _4884_/X sky130_fd_sc_hd__a2bb2o_2
XFILLER_60_670 VGND VGND VPWR VPWR sky130_fd_sc_hd__decap_3
XFILLER_32_361 VGND VGND VPWR VPWR sky130_fd_sc_hd__decap_3
X_6623_ _6285_/A _6286_/A _6622_/X VGND VGND VPWR VPWR _6624_/B sky130_fd_sc_hd__a21oi_2
XFILLER_20_545 VGND VGND VPWR VPWR sky130_fd_sc_hd__decap_3
X_9342_ _9344_/CLK _9342_/D load_slew380/X VGND VGND VPWR VPWR _9342_/Q sky130_fd_sc_hd__dfrtp_2
X_6554_ _6346_/A _6346_/B _6687_/B1 VGND VGND VPWR VPWR _6746_/B sky130_fd_sc_hd__a21o_2
XFILLER_20_589 VGND VGND VPWR VPWR sky130_fd_sc_hd__decap_3
XFILLER_118_433 VGND VGND VPWR VPWR sky130_fd_sc_hd__decap_3
X_5505_ _7528_/B2 _5664_/A _5500_/Y _5504_/Y _7676_/C VGND VGND VPWR VPWR _5524_/A
+ sky130_fd_sc_hd__a311o_2
X_9273_ clkload4/A _9273_/D wire372/X VGND VGND VPWR VPWR _9273_/Q sky130_fd_sc_hd__dfrtp_2
X_6485_ _6485_/A _6485_/B VGND VGND VPWR VPWR _6492_/A sky130_fd_sc_hd__xnor2_2
XFILLER_118_477 VGND VGND VPWR VPWR sky130_fd_sc_hd__decap_3
XFILLER_106_628 VGND VGND VPWR VPWR sky130_fd_sc_hd__decap_3
XFILLER_10_15 VGND VGND VPWR VPWR sky130_fd_sc_hd__decap_3
X_8224_ _8179_/A _8179_/B _8180_/A VGND VGND VPWR VPWR _8224_/X sky130_fd_sc_hd__a21o_2
XFILLER_105_116 VGND VGND VPWR VPWR sky130_fd_sc_hd__decap_3
X_5436_ _5576_/A _5436_/B VGND VGND VPWR VPWR _5451_/A sky130_fd_sc_hd__xnor2_2
XFILLER_126_15 VGND VGND VPWR VPWR sky130_fd_sc_hd__decap_3
XFILLER_105_149 VGND VGND VPWR VPWR sky130_fd_sc_hd__decap_3
X_8155_ _8155_/A _8165_/B VGND VGND VPWR VPWR _8155_/Y sky130_fd_sc_hd__nor2_2
X_5367_ _5367_/A _5452_/A VGND VGND VPWR VPWR _5495_/B sky130_fd_sc_hd__xnor2_2
XFILLER_99_361 VGND VGND VPWR VPWR sky130_fd_sc_hd__fill_1
XFILLER_126_59 VGND VGND VPWR VPWR sky130_fd_sc_hd__decap_3
X_7106_ wire55/X _7106_/B _7106_/C VGND VGND VPWR VPWR _7374_/A sky130_fd_sc_hd__nor3_2
XFILLER_114_683 VGND VGND VPWR VPWR sky130_fd_sc_hd__decap_3
XFILLER_87_534 VGND VGND VPWR VPWR sky130_fd_sc_hd__decap_3
XFILLER_59_225 VGND VGND VPWR VPWR sky130_fd_sc_hd__fill_2
X_8086_ _9219_/Q _8086_/B VGND VGND VPWR VPWR _8127_/A sky130_fd_sc_hd__xnor2_2
X_5298_ _5298_/A _5298_/B VGND VGND VPWR VPWR _5452_/C sky130_fd_sc_hd__nor2_2
XFILLER_101_333 VGND VGND VPWR VPWR sky130_fd_sc_hd__decap_3
XFILLER_19_24 VGND VGND VPWR VPWR sky130_fd_sc_hd__decap_3
XFILLER_87_567 VGND VGND VPWR VPWR sky130_fd_sc_hd__decap_3
XFILLER_75_707 VGND VGND VPWR VPWR sky130_fd_sc_hd__fill_1
X_7037_ _8421_/A _6956_/X _7036_/Y VGND VGND VPWR VPWR _7037_/X sky130_fd_sc_hd__a21o_2
XFILLER_75_729 VGND VGND VPWR VPWR sky130_fd_sc_hd__fill_1
XFILLER_28_601 VGND VGND VPWR VPWR sky130_fd_sc_hd__decap_3
XFILLER_55_442 VGND VGND VPWR VPWR sky130_fd_sc_hd__fill_1
XFILLER_43_615 VGND VGND VPWR VPWR sky130_fd_sc_hd__fill_1
X_8988_ _9335_/Q _8988_/A1 _8988_/S VGND VGND VPWR VPWR _8988_/X sky130_fd_sc_hd__mux2_2
XFILLER_55_486 VGND VGND VPWR VPWR sky130_fd_sc_hd__decap_3
XFILLER_42_103 VGND VGND VPWR VPWR sky130_fd_sc_hd__decap_3
XFILLER_27_188 VGND VGND VPWR VPWR sky130_fd_sc_hd__decap_3
X_7939_ _8315_/A _8313_/A VGND VGND VPWR VPWR _7943_/A sky130_fd_sc_hd__nand2_2
XFILLER_43_659 VGND VGND VPWR VPWR sky130_fd_sc_hd__decap_3
XFILLER_30_309 VGND VGND VPWR VPWR sky130_fd_sc_hd__decap_3
XTAP_TAPCELL_ROW_41_838 VGND VPWR sky130_fd_sc_hd__tapvpwrvgnd_1
XFILLER_129_709 VGND VGND VPWR VPWR sky130_fd_sc_hd__decap_3
XFILLER_50_180 VGND VGND VPWR VPWR sky130_fd_sc_hd__fill_1
XFILLER_7_505 VGND VGND VPWR VPWR sky130_fd_sc_hd__decap_3
XFILLER_11_567 VGND VGND VPWR VPWR sky130_fd_sc_hd__decap_3
XFILLER_51_55 VGND VGND VPWR VPWR sky130_fd_sc_hd__fill_1
XTAP_TAPCELL_ROW_21_562 VGND VPWR sky130_fd_sc_hd__tapvpwrvgnd_1
XFILLER_109_444 VGND VGND VPWR VPWR sky130_fd_sc_hd__decap_3
XFILLER_109_455 VGND VGND VPWR VPWR sky130_fd_sc_hd__decap_3
XFILLER_3_700 VGND VGND VPWR VPWR sky130_fd_sc_hd__decap_3
XFILLER_3_744 VGND VGND VPWR VPWR sky130_fd_sc_hd__decap_3
XFILLER_124_458 VGND VGND VPWR VPWR sky130_fd_sc_hd__decap_3
XFILLER_105_650 VGND VGND VPWR VPWR sky130_fd_sc_hd__decap_3
Xload_slew408 fanout405/A VGND VGND VPWR VPWR load_slew408/X sky130_fd_sc_hd__buf_4
XTAP_TAPCELL_ROW_53_1000 VGND VPWR sky130_fd_sc_hd__tapvpwrvgnd_1
Xload_slew419 fanout418/X VGND VGND VPWR VPWR fanout415/A sky130_fd_sc_hd__clkbuf_4
XFILLER_111_119 VGND VGND VPWR VPWR sky130_fd_sc_hd__decap_3
XFILLER_105_694 VGND VGND VPWR VPWR sky130_fd_sc_hd__decap_3
XFILLER_78_589 VGND VGND VPWR VPWR sky130_fd_sc_hd__decap_3
XFILLER_19_601 VGND VGND VPWR VPWR sky130_fd_sc_hd__decap_3
XFILLER_18_9 VGND VGND VPWR VPWR sky130_fd_sc_hd__decap_3
XTAP_TAPCELL_ROW_49_938 VGND VPWR sky130_fd_sc_hd__tapvpwrvgnd_1
XFILLER_76_74 VGND VGND VPWR VPWR sky130_fd_sc_hd__decap_3
XFILLER_120_697 VGND VGND VPWR VPWR sky130_fd_sc_hd__decap_3
XTAP_TAPCELL_ROW_49_949 VGND VPWR sky130_fd_sc_hd__tapvpwrvgnd_1
XFILLER_76_85 VGND VGND VPWR VPWR sky130_fd_sc_hd__decap_3
XFILLER_19_623 VGND VGND VPWR VPWR sky130_fd_sc_hd__decap_3
XFILLER_93_559 VGND VGND VPWR VPWR sky130_fd_sc_hd__fill_1
XFILLER_19_645 VGND VGND VPWR VPWR sky130_fd_sc_hd__fill_1
XFILLER_18_144 VGND VGND VPWR VPWR sky130_fd_sc_hd__decap_3
XFILLER_73_250 VGND VGND VPWR VPWR sky130_fd_sc_hd__decap_3
XFILLER_46_475 VGND VGND VPWR VPWR sky130_fd_sc_hd__fill_1
XFILLER_34_615 VGND VGND VPWR VPWR sky130_fd_sc_hd__decap_3
XTAP_TAPCELL_ROW_29_673 VGND VPWR sky130_fd_sc_hd__tapvpwrvgnd_1
XFILLER_46_486 VGND VGND VPWR VPWR sky130_fd_sc_hd__decap_3
XFILLER_92_40 VGND VGND VPWR VPWR sky130_fd_sc_hd__fill_2
XFILLER_34_648 VGND VGND VPWR VPWR sky130_fd_sc_hd__decap_3
XFILLER_33_125 VGND VGND VPWR VPWR sky130_fd_sc_hd__decap_3
XTAP_TAPCELL_ROW_64_1140 VGND VPWR sky130_fd_sc_hd__tapvpwrvgnd_1
XFILLER_61_467 VGND VGND VPWR VPWR sky130_fd_sc_hd__decap_3
XTAP_TAPCELL_ROW_64_1151 VGND VPWR sky130_fd_sc_hd__tapvpwrvgnd_1
XFILLER_33_169 VGND VGND VPWR VPWR sky130_fd_sc_hd__decap_3
XFILLER_14_350 VGND VGND VPWR VPWR sky130_fd_sc_hd__fill_1
XFILLER_61_489 VGND VGND VPWR VPWR sky130_fd_sc_hd__decap_3
XFILLER_119_219 VGND VGND VPWR VPWR sky130_fd_sc_hd__decap_3
XFILLER_128_731 VGND VGND VPWR VPWR sky130_fd_sc_hd__decap_3
XFILLER_128_775 VGND VGND VPWR VPWR sky130_fd_sc_hd__fill_2
XTAP_TAPCELL_ROW_116_1848 VGND VPWR sky130_fd_sc_hd__tapvpwrvgnd_1
X_6270_ _6142_/X _6269_/Y _6270_/S VGND VGND VPWR VPWR _6271_/A sky130_fd_sc_hd__mux2_2
XFILLER_51_3 VGND VGND VPWR VPWR sky130_fd_sc_hd__decap_3
XFILLER_115_447 VGND VGND VPWR VPWR sky130_fd_sc_hd__fill_1
XFILLER_115_458 VGND VGND VPWR VPWR sky130_fd_sc_hd__decap_3
X_5221_ _5221_/A _6077_/A VGND VGND VPWR VPWR _5221_/Y sky130_fd_sc_hd__nor2_2
XFILLER_88_309 VGND VGND VPWR VPWR sky130_fd_sc_hd__fill_1
XFILLER_102_119 VGND VGND VPWR VPWR sky130_fd_sc_hd__fill_1
XTAP_TAPCELL_ROW_75_1291 VGND VPWR sky130_fd_sc_hd__tapvpwrvgnd_1
XFILLER_69_523 VGND VGND VPWR VPWR sky130_fd_sc_hd__decap_3
X_5152_ _5152_/A _5152_/B VGND VGND VPWR VPWR _5153_/B sky130_fd_sc_hd__xnor2_2
XFILLER_69_534 VGND VGND VPWR VPWR sky130_fd_sc_hd__decap_3
XFILLER_111_620 VGND VGND VPWR VPWR sky130_fd_sc_hd__decap_3
XFILLER_69_578 VGND VGND VPWR VPWR sky130_fd_sc_hd__decap_3
XFILLER_110_141 VGND VGND VPWR VPWR sky130_fd_sc_hd__decap_3
X_5083_ _5949_/A _5949_/B VGND VGND VPWR VPWR _5084_/B sky130_fd_sc_hd__nor2_2
XFILLER_84_515 VGND VGND VPWR VPWR sky130_fd_sc_hd__fill_2
XFILLER_69_589 VGND VGND VPWR VPWR sky130_fd_sc_hd__decap_3
XFILLER_57_729 VGND VGND VPWR VPWR sky130_fd_sc_hd__decap_3
XFILLER_111_697 VGND VGND VPWR VPWR sky130_fd_sc_hd__decap_3
XFILLER_56_228 VGND VGND VPWR VPWR sky130_fd_sc_hd__decap_3
XFILLER_2_71 VGND VGND VPWR VPWR sky130_fd_sc_hd__decap_3
X_8911_ _8944_/A1 _9282_/Q _8925_/S VGND VGND VPWR VPWR _8911_/X sky130_fd_sc_hd__mux2_2
XFILLER_84_559 VGND VGND VPWR VPWR sky130_fd_sc_hd__fill_2
XFILLER_65_740 VGND VGND VPWR VPWR sky130_fd_sc_hd__fill_1
XFILLER_65_751 VGND VGND VPWR VPWR sky130_fd_sc_hd__decap_3
X_8842_ _8842_/A VGND VGND VPWR VPWR _9265_/D sky130_fd_sc_hd__buf_1
XFILLER_80_710 VGND VGND VPWR VPWR sky130_fd_sc_hd__decap_3
XTAP_TAPCELL_ROW_127_1999 VGND VPWR sky130_fd_sc_hd__tapvpwrvgnd_1
XFILLER_92_592 VGND VGND VPWR VPWR sky130_fd_sc_hd__decap_3
XFILLER_80_732 VGND VGND VPWR VPWR sky130_fd_sc_hd__decap_3
X_8773_ _8773_/A _8773_/B VGND VGND VPWR VPWR _8773_/Y sky130_fd_sc_hd__xnor2_2
X_5985_ _5984_/B _5984_/C _7430_/B _5041_/B VGND VGND VPWR VPWR _5985_/X sky130_fd_sc_hd__o22a_2
XFILLER_80_754 VGND VGND VPWR VPWR sky130_fd_sc_hd__fill_2
XFILLER_24_147 VGND VGND VPWR VPWR sky130_fd_sc_hd__decap_3
XFILLER_52_467 VGND VGND VPWR VPWR sky130_fd_sc_hd__decap_3
X_7724_ _7683_/A _8037_/A _7723_/X VGND VGND VPWR VPWR _7735_/A sky130_fd_sc_hd__o21a_2
XFILLER_12_309 VGND VGND VPWR VPWR sky130_fd_sc_hd__decap_3
X_4936_ _9018_/Q _9146_/Q _6239_/A VGND VGND VPWR VPWR _4936_/X sky130_fd_sc_hd__mux2_2
XFILLER_33_692 VGND VGND VPWR VPWR sky130_fd_sc_hd__decap_3
X_7655_ _7661_/A _7659_/B _7518_/C _7515_/X VGND VGND VPWR VPWR _7655_/X sky130_fd_sc_hd__o31a_2
X_4867_ hold954/X _9161_/Q _8799_/S VGND VGND VPWR VPWR _4867_/X sky130_fd_sc_hd__mux2_2
XFILLER_20_331 VGND VGND VPWR VPWR sky130_fd_sc_hd__fill_1
X_6606_ _9096_/Q _6754_/B _6753_/B VGND VGND VPWR VPWR _6606_/X sky130_fd_sc_hd__and3_2
XFILLER_119_720 VGND VGND VPWR VPWR sky130_fd_sc_hd__decap_3
X_7586_ _7590_/C _7585_/Y _7591_/A VGND VGND VPWR VPWR _7586_/X sky130_fd_sc_hd__a21o_2
X_4798_ _4798_/A0 _9129_/Q _4798_/S VGND VGND VPWR VPWR _4798_/X sky130_fd_sc_hd__mux2_2
XFILLER_122_9 VGND VGND VPWR VPWR sky130_fd_sc_hd__decap_3
XFILLER_119_753 VGND VGND VPWR VPWR sky130_fd_sc_hd__decap_3
X_9325_ _9341_/CLK _9325_/D load_slew378/X VGND VGND VPWR VPWR _9325_/Q sky130_fd_sc_hd__dfrtp_2
X_6537_ _6375_/A1 _6537_/B _6537_/C VGND VGND VPWR VPWR _6537_/X sky130_fd_sc_hd__and3b_2
XFILLER_4_519 VGND VGND VPWR VPWR sky130_fd_sc_hd__decap_3
X_9256_ clkload5/A _9256_/D wire372/A VGND VGND VPWR VPWR _9256_/Q sky130_fd_sc_hd__dfrtp_2
XFILLER_106_436 VGND VGND VPWR VPWR sky130_fd_sc_hd__decap_3
X_6468_ hold759/X _6466_/X _6467_/Y _6412_/A VGND VGND VPWR VPWR _6843_/A sky130_fd_sc_hd__a22o_2
XTAP_TAPCELL_ROW_91_1509 VGND VPWR sky130_fd_sc_hd__tapvpwrvgnd_1
X_8207_ _7997_/A _7997_/B _7859_/Y VGND VGND VPWR VPWR _8207_/Y sky130_fd_sc_hd__o21bai_4
X_5419_ _5339_/X _5418_/Y _6270_/S VGND VGND VPWR VPWR _5420_/A sky130_fd_sc_hd__mux2_2
X_9187_ _9189_/CLK _9187_/D load_slew414/X VGND VGND VPWR VPWR _9187_/Q sky130_fd_sc_hd__dfrtp_2
X_6399_ _6490_/A _5095_/X _5954_/Y _6805_/A VGND VGND VPWR VPWR _6399_/X sky130_fd_sc_hd__o22a_2
XFILLER_0_725 VGND VGND VPWR VPWR sky130_fd_sc_hd__decap_3
X_8138_ _8215_/B _8137_/Y _8350_/B VGND VGND VPWR VPWR _8148_/A sky130_fd_sc_hd__a21oi_2
XFILLER_114_480 VGND VGND VPWR VPWR sky130_fd_sc_hd__decap_3
XFILLER_0_747 VGND VGND VPWR VPWR sky130_fd_sc_hd__decap_3
XFILLER_0_769 VGND VGND VPWR VPWR sky130_fd_sc_hd__decap_3
XTAP_TAPCELL_ROW_7_379 VGND VPWR sky130_fd_sc_hd__tapvpwrvgnd_1
X_8069_ _8070_/A wire88/X _8070_/C VGND VGND VPWR VPWR _8069_/X sky130_fd_sc_hd__a21o_2
XFILLER_47_206 VGND VGND VPWR VPWR sky130_fd_sc_hd__decap_3
XFILLER_101_163 VGND VGND VPWR VPWR sky130_fd_sc_hd__decap_3
XFILLER_87_386 VGND VGND VPWR VPWR sky130_fd_sc_hd__fill_1
XFILLER_75_537 VGND VGND VPWR VPWR sky130_fd_sc_hd__decap_3
XFILLER_47_228 VGND VGND VPWR VPWR sky130_fd_sc_hd__decap_3
XTAP_TAPCELL_ROW_46_908 VGND VPWR sky130_fd_sc_hd__tapvpwrvgnd_1
XFILLER_90_507 VGND VGND VPWR VPWR sky130_fd_sc_hd__decap_3
XFILLER_71_710 VGND VGND VPWR VPWR sky130_fd_sc_hd__fill_2
XFILLER_43_401 VGND VGND VPWR VPWR sky130_fd_sc_hd__decap_3
Xmax_cap56 _6850_/A VGND VGND VPWR VPWR _7150_/A sky130_fd_sc_hd__clkbuf_2
XFILLER_83_581 VGND VGND VPWR VPWR sky130_fd_sc_hd__decap_3
XFILLER_28_497 VGND VGND VPWR VPWR sky130_fd_sc_hd__decap_3
Xmax_cap78 _8149_/A VGND VGND VPWR VPWR _8154_/A sky130_fd_sc_hd__buf_4
XFILLER_16_648 VGND VGND VPWR VPWR sky130_fd_sc_hd__decap_3
XFILLER_55_294 VGND VGND VPWR VPWR sky130_fd_sc_hd__decap_3
Xmax_cap89 _6951_/X VGND VGND VPWR VPWR _8239_/A sky130_fd_sc_hd__clkbuf_2
XTAP_TAPCELL_ROW_26_632 VGND VPWR sky130_fd_sc_hd__tapvpwrvgnd_1
XFILLER_43_445 VGND VGND VPWR VPWR sky130_fd_sc_hd__decap_3
XFILLER_71_776 VGND VGND VPWR VPWR sky130_fd_sc_hd__fill_1
XFILLER_43_467 VGND VGND VPWR VPWR sky130_fd_sc_hd__decap_3
XFILLER_31_607 VGND VGND VPWR VPWR sky130_fd_sc_hd__decap_3
XFILLER_102_72 VGND VGND VPWR VPWR sky130_fd_sc_hd__decap_3
XFILLER_70_253 VGND VGND VPWR VPWR sky130_fd_sc_hd__fill_2
XFILLER_15_169 VGND VGND VPWR VPWR sky130_fd_sc_hd__decap_3
XFILLER_102_94 VGND VGND VPWR VPWR sky130_fd_sc_hd__fill_2
XFILLER_30_128 VGND VGND VPWR VPWR sky130_fd_sc_hd__decap_3
XTAP_TAPCELL_ROW_100_1627 VGND VPWR sky130_fd_sc_hd__tapvpwrvgnd_1
XTAP_TAPCELL_ROW_100_1638 VGND VPWR sky130_fd_sc_hd__tapvpwrvgnd_1
XFILLER_23_180 VGND VGND VPWR VPWR sky130_fd_sc_hd__decap_3
Xwire222 wire222/A VGND VGND VPWR VPWR result_out[6] sky130_fd_sc_hd__buf_4
XFILLER_7_27 VGND VGND VPWR VPWR sky130_fd_sc_hd__decap_3
Xwire233 wire233/A VGND VGND VPWR VPWR result_out[10] sky130_fd_sc_hd__buf_4
XFILLER_7_335 VGND VGND VPWR VPWR sky130_fd_sc_hd__fill_1
XFILLER_7_368 VGND VGND VPWR VPWR sky130_fd_sc_hd__decap_3
XFILLER_125_701 VGND VGND VPWR VPWR sky130_fd_sc_hd__decap_3
XFILLER_124_200 VGND VGND VPWR VPWR sky130_fd_sc_hd__decap_3
XFILLER_125_756 VGND VGND VPWR VPWR sky130_fd_sc_hd__decap_3
XFILLER_3_541 VGND VGND VPWR VPWR sky130_fd_sc_hd__decap_3
XFILLER_98_629 VGND VGND VPWR VPWR sky130_fd_sc_hd__fill_1
XFILLER_78_331 VGND VGND VPWR VPWR sky130_fd_sc_hd__decap_3
XTAP_TAPCELL_ROW_111_1778 VGND VPWR sky130_fd_sc_hd__tapvpwrvgnd_1
XFILLER_39_729 VGND VGND VPWR VPWR sky130_fd_sc_hd__fill_1
XFILLER_66_515 VGND VGND VPWR VPWR sky130_fd_sc_hd__decap_3
XFILLER_38_228 VGND VGND VPWR VPWR sky130_fd_sc_hd__decap_3
XFILLER_16_6 VGND VGND VPWR VPWR sky130_fd_sc_hd__decap_3
XFILLER_120_494 VGND VGND VPWR VPWR sky130_fd_sc_hd__decap_3
XFILLER_19_431 VGND VGND VPWR VPWR sky130_fd_sc_hd__decap_3
XFILLER_93_367 VGND VGND VPWR VPWR sky130_fd_sc_hd__fill_1
XFILLER_19_464 VGND VGND VPWR VPWR sky130_fd_sc_hd__fill_1
XFILLER_93_389 VGND VGND VPWR VPWR sky130_fd_sc_hd__decap_3
XFILLER_34_412 VGND VGND VPWR VPWR sky130_fd_sc_hd__fill_1
XFILLER_74_592 VGND VGND VPWR VPWR sky130_fd_sc_hd__decap_3
XFILLER_62_743 VGND VGND VPWR VPWR sky130_fd_sc_hd__decap_3
XFILLER_46_294 VGND VGND VPWR VPWR sky130_fd_sc_hd__decap_3
XFILLER_34_445 VGND VGND VPWR VPWR sky130_fd_sc_hd__decap_3
X_5770_ _5770_/A _5770_/B VGND VGND VPWR VPWR _5771_/B sky130_fd_sc_hd__or2_2
XFILLER_34_489 VGND VGND VPWR VPWR sky130_fd_sc_hd__decap_3
XFILLER_21_106 VGND VGND VPWR VPWR sky130_fd_sc_hd__decap_3
XFILLER_99_3 VGND VGND VPWR VPWR sky130_fd_sc_hd__decap_3
XFILLER_61_297 VGND VGND VPWR VPWR sky130_fd_sc_hd__fill_2
XFILLER_21_128 VGND VGND VPWR VPWR sky130_fd_sc_hd__decap_3
X_4721_ hold924/X hold934/X _4735_/S VGND VGND VPWR VPWR _4722_/A sky130_fd_sc_hd__mux2_2
X_7440_ _5348_/S _5718_/C _6944_/B _8175_/A VGND VGND VPWR VPWR _7440_/X sky130_fd_sc_hd__a211o_2
X_4652_ _8990_/A VGND VGND VPWR VPWR _4842_/A sky130_fd_sc_hd__buf_1
XFILLER_30_695 VGND VGND VPWR VPWR sky130_fd_sc_hd__decap_3
X_7371_ wire55/X _7106_/C _7106_/B VGND VGND VPWR VPWR _7372_/B sky130_fd_sc_hd__o21ba_2
X_4583_ _4617_/A1 _4583_/A1 _4587_/S VGND VGND VPWR VPWR _4584_/A sky130_fd_sc_hd__mux2_2
XFILLER_128_561 VGND VGND VPWR VPWR sky130_fd_sc_hd__decap_3
XTAP_TAPCELL_ROW_77_1320 VGND VPWR sky130_fd_sc_hd__tapvpwrvgnd_1
Xhold803 _9181_/Q VGND VGND VPWR VPWR hold803/X sky130_fd_sc_hd__dlygate4sd3_1
X_9110_ _9142_/CLK _9110_/D load_slew408/X VGND VGND VPWR VPWR _9110_/Q sky130_fd_sc_hd__dfrtp_2
XFILLER_116_723 VGND VGND VPWR VPWR sky130_fd_sc_hd__decap_3
X_6322_ _6563_/B _6322_/B VGND VGND VPWR VPWR _6568_/B sky130_fd_sc_hd__xnor2_2
Xhold814 _9192_/Q VGND VGND VPWR VPWR hold814/X sky130_fd_sc_hd__dlygate4sd3_1
Xhold825 _9020_/Q VGND VGND VPWR VPWR hold825/X sky130_fd_sc_hd__dlygate4sd3_1
XFILLER_115_211 VGND VGND VPWR VPWR sky130_fd_sc_hd__decap_3
Xhold836 _4811_/X VGND VGND VPWR VPWR _4812_/A sky130_fd_sc_hd__dlygate4sd3_1
Xhold847 _5688_/X VGND VGND VPWR VPWR hold847/X sky130_fd_sc_hd__dlygate4sd3_1
Xhold858 _9285_/Q VGND VGND VPWR VPWR hold858/X sky130_fd_sc_hd__dlygate4sd3_1
X_9041_ _9293_/CLK _9041_/D fanout377/X VGND VGND VPWR VPWR _9041_/Q sky130_fd_sc_hd__dfrtp_2
X_6253_ _9207_/Q _6253_/B VGND VGND VPWR VPWR _6253_/Y sky130_fd_sc_hd__nor2_2
Xhold869 _4742_/X VGND VGND VPWR VPWR _4743_/A sky130_fd_sc_hd__dlygate4sd3_1
XFILLER_107_39 VGND VGND VPWR VPWR sky130_fd_sc_hd__decap_3
XFILLER_130_203 VGND VGND VPWR VPWR sky130_fd_sc_hd__decap_3
XFILLER_103_439 VGND VGND VPWR VPWR sky130_fd_sc_hd__decap_3
X_5204_ _7317_/A _6685_/A VGND VGND VPWR VPWR _5208_/A sky130_fd_sc_hd__nand2_2
XFILLER_130_225 VGND VGND VPWR VPWR sky130_fd_sc_hd__decap_3
X_6184_ _6292_/A _6292_/B _6184_/C _6184_/D VGND VGND VPWR VPWR _6184_/X sky130_fd_sc_hd__or4_4
X_5135_ _5135_/A _5135_/B VGND VGND VPWR VPWR _5213_/S sky130_fd_sc_hd__xnor2_2
XFILLER_97_673 VGND VGND VPWR VPWR sky130_fd_sc_hd__decap_3
XFILLER_29_206 VGND VGND VPWR VPWR sky130_fd_sc_hd__decap_3
XTAP_TAPCELL_ROW_4_338 VGND VPWR sky130_fd_sc_hd__tapvpwrvgnd_1
XFILLER_57_526 VGND VGND VPWR VPWR sky130_fd_sc_hd__decap_3
XFILLER_29_217 VGND VGND VPWR VPWR sky130_fd_sc_hd__decap_3
XFILLER_123_27 VGND VGND VPWR VPWR sky130_fd_sc_hd__decap_3
XFILLER_111_483 VGND VGND VPWR VPWR sky130_fd_sc_hd__decap_3
XFILLER_29_239 VGND VGND VPWR VPWR sky130_fd_sc_hd__decap_3
X_5066_ _5262_/B _6604_/C VGND VGND VPWR VPWR _5066_/X sky130_fd_sc_hd__and2_2
XFILLER_84_378 VGND VGND VPWR VPWR sky130_fd_sc_hd__decap_3
XFILLER_44_209 VGND VGND VPWR VPWR sky130_fd_sc_hd__decap_3
XTAP_TAPCELL_ROW_88_1471 VGND VPWR sky130_fd_sc_hd__tapvpwrvgnd_1
XFILLER_65_570 VGND VGND VPWR VPWR sky130_fd_sc_hd__decap_3
XFILLER_25_401 VGND VGND VPWR VPWR sky130_fd_sc_hd__decap_3
XFILLER_65_592 VGND VGND VPWR VPWR sky130_fd_sc_hd__decap_3
XFILLER_25_434 VGND VGND VPWR VPWR sky130_fd_sc_hd__decap_3
X_8825_ _9257_/Q _8825_/A1 _8837_/S VGND VGND VPWR VPWR _8825_/X sky130_fd_sc_hd__mux2_2
XFILLER_53_754 VGND VGND VPWR VPWR sky130_fd_sc_hd__decap_3
XFILLER_52_231 VGND VGND VPWR VPWR sky130_fd_sc_hd__decap_3
XFILLER_16_47 VGND VGND VPWR VPWR sky130_fd_sc_hd__decap_3
XFILLER_53_776 VGND VGND VPWR VPWR sky130_fd_sc_hd__fill_1
XFILLER_25_478 VGND VGND VPWR VPWR sky130_fd_sc_hd__decap_3
XFILLER_80_573 VGND VGND VPWR VPWR sky130_fd_sc_hd__decap_3
X_5968_ _5968_/A0 _5968_/A1 _5968_/S VGND VGND VPWR VPWR _5968_/X sky130_fd_sc_hd__mux2_2
X_8756_ _8741_/A _8752_/X _8754_/X _8755_/Y VGND VGND VPWR VPWR _8761_/A sky130_fd_sc_hd__o2bb2a_2
X_4919_ _7480_/C VGND VGND VPWR VPWR _5633_/A sky130_fd_sc_hd__clkbuf_2
X_7707_ _7692_/A _7703_/X _7706_/X VGND VGND VPWR VPWR _7741_/A sky130_fd_sc_hd__a21oi_2
XTAP_TAPCELL_ROW_51_966 VGND VPWR sky130_fd_sc_hd__tapvpwrvgnd_1
X_5899_ _9206_/Q _5899_/B VGND VGND VPWR VPWR _5900_/A sky130_fd_sc_hd__xnor2_2
X_8687_ _8210_/B _8729_/S _8687_/B1 VGND VGND VPWR VPWR _8687_/Y sky130_fd_sc_hd__o21ai_2
XFILLER_32_35 VGND VGND VPWR VPWR sky130_fd_sc_hd__decap_3
XFILLER_21_673 VGND VGND VPWR VPWR sky130_fd_sc_hd__decap_3
XFILLER_20_150 VGND VGND VPWR VPWR sky130_fd_sc_hd__decap_3
X_7638_ _7638_/A _7638_/B _7487_/A VGND VGND VPWR VPWR _7639_/A sky130_fd_sc_hd__or3b_4
XFILLER_32_68 VGND VGND VPWR VPWR sky130_fd_sc_hd__decap_3
XFILLER_120_6 VGND VGND VPWR VPWR sky130_fd_sc_hd__decap_3
XFILLER_20_183 VGND VGND VPWR VPWR sky130_fd_sc_hd__decap_3
X_7569_ _7569_/A _8240_/B _7448_/A VGND VGND VPWR VPWR _7569_/X sky130_fd_sc_hd__or3b_2
XFILLER_107_723 VGND VGND VPWR VPWR sky130_fd_sc_hd__decap_3
X_9308_ _9308_/CLK _9308_/D load_slew368/X VGND VGND VPWR VPWR _9308_/Q sky130_fd_sc_hd__dfrtp_2
XFILLER_119_594 VGND VGND VPWR VPWR sky130_fd_sc_hd__decap_3
XFILLER_106_222 VGND VGND VPWR VPWR sky130_fd_sc_hd__decap_3
X_9239_ clkload7/A _9239_/D fanout375/X VGND VGND VPWR VPWR _9239_/Q sky130_fd_sc_hd__dfrtp_2
XFILLER_122_715 VGND VGND VPWR VPWR sky130_fd_sc_hd__decap_3
XFILLER_106_277 VGND VGND VPWR VPWR sky130_fd_sc_hd__decap_3
XFILLER_0_500 VGND VGND VPWR VPWR sky130_fd_sc_hd__decap_3
XFILLER_0_511 VGND VGND VPWR VPWR sky130_fd_sc_hd__decap_3
XFILLER_122_748 VGND VGND VPWR VPWR sky130_fd_sc_hd__decap_3
XFILLER_121_214 VGND VGND VPWR VPWR sky130_fd_sc_hd__decap_3
XFILLER_79_139 VGND VGND VPWR VPWR sky130_fd_sc_hd__decap_3
XFILLER_0_533 VGND VGND VPWR VPWR sky130_fd_sc_hd__decap_3
XFILLER_121_247 VGND VGND VPWR VPWR sky130_fd_sc_hd__decap_3
XFILLER_121_258 VGND VGND VPWR VPWR sky130_fd_sc_hd__fill_2
XFILLER_57_21 VGND VGND VPWR VPWR sky130_fd_sc_hd__decap_3
XFILLER_102_461 VGND VGND VPWR VPWR sky130_fd_sc_hd__decap_3
XFILLER_48_515 VGND VGND VPWR VPWR sky130_fd_sc_hd__decap_3
XFILLER_102_483 VGND VGND VPWR VPWR sky130_fd_sc_hd__decap_3
XFILLER_57_54 VGND VGND VPWR VPWR sky130_fd_sc_hd__fill_2
XFILLER_90_315 VGND VGND VPWR VPWR sky130_fd_sc_hd__decap_3
XFILLER_16_412 VGND VGND VPWR VPWR sky130_fd_sc_hd__decap_3
XFILLER_113_60 VGND VGND VPWR VPWR sky130_fd_sc_hd__decap_3
XFILLER_90_337 VGND VGND VPWR VPWR sky130_fd_sc_hd__decap_3
XFILLER_90_348 VGND VGND VPWR VPWR sky130_fd_sc_hd__decap_3
XFILLER_56_592 VGND VGND VPWR VPWR sky130_fd_sc_hd__decap_3
XFILLER_16_434 VGND VGND VPWR VPWR sky130_fd_sc_hd__decap_3
XFILLER_44_754 VGND VGND VPWR VPWR sky130_fd_sc_hd__fill_2
XFILLER_44_776 VGND VGND VPWR VPWR sky130_fd_sc_hd__fill_1
XTAP_TAPCELL_ROW_61_1110 VGND VPWR sky130_fd_sc_hd__tapvpwrvgnd_1
XFILLER_8_600 VGND VGND VPWR VPWR sky130_fd_sc_hd__decap_3
XFILLER_11_150 VGND VGND VPWR VPWR sky130_fd_sc_hd__fill_2
XFILLER_12_695 VGND VGND VPWR VPWR sky130_fd_sc_hd__decap_3
XTAP_TAPCELL_ROW_113_1807 VGND VPWR sky130_fd_sc_hd__tapvpwrvgnd_1
XTAP_TAPCELL_ROW_59_1072 VGND VPWR sky130_fd_sc_hd__tapvpwrvgnd_1
XFILLER_125_553 VGND VGND VPWR VPWR sky130_fd_sc_hd__decap_3
XFILLER_125_564 VGND VGND VPWR VPWR sky130_fd_sc_hd__decap_3
XTAP_TAPCELL_ROW_59_1083 VGND VPWR sky130_fd_sc_hd__tapvpwrvgnd_1
XFILLER_98_94 VGND VGND VPWR VPWR sky130_fd_sc_hd__decap_3
XFILLER_125_597 VGND VGND VPWR VPWR sky130_fd_sc_hd__decap_3
XFILLER_3_393 VGND VGND VPWR VPWR sky130_fd_sc_hd__decap_3
XTAP_TAPCELL_ROW_72_1250 VGND VPWR sky130_fd_sc_hd__tapvpwrvgnd_1
XFILLER_79_662 VGND VGND VPWR VPWR sky130_fd_sc_hd__decap_3
XFILLER_79_673 VGND VGND VPWR VPWR sky130_fd_sc_hd__fill_1
XFILLER_94_610 VGND VGND VPWR VPWR sky130_fd_sc_hd__decap_3
XFILLER_94_632 VGND VGND VPWR VPWR sky130_fd_sc_hd__decap_3
XFILLER_14_3 VGND VGND VPWR VPWR sky130_fd_sc_hd__decap_3
XFILLER_66_345 VGND VGND VPWR VPWR sky130_fd_sc_hd__decap_3
XFILLER_94_676 VGND VGND VPWR VPWR sky130_fd_sc_hd__decap_3
XFILLER_54_507 VGND VGND VPWR VPWR sky130_fd_sc_hd__fill_2
X_6940_ _5984_/B _6939_/B _6939_/C VGND VGND VPWR VPWR _6940_/X sky130_fd_sc_hd__o21a_2
XFILLER_66_389 VGND VGND VPWR VPWR sky130_fd_sc_hd__decap_3
XFILLER_54_529 VGND VGND VPWR VPWR sky130_fd_sc_hd__decap_3
XFILLER_47_570 VGND VGND VPWR VPWR sky130_fd_sc_hd__decap_3
XFILLER_81_337 VGND VGND VPWR VPWR sky130_fd_sc_hd__decap_3
XFILLER_35_732 VGND VGND VPWR VPWR sky130_fd_sc_hd__decap_3
X_6871_ _7170_/S _6871_/B VGND VGND VPWR VPWR _6872_/B sky130_fd_sc_hd__xor2_2
XFILLER_35_754 VGND VGND VPWR VPWR sky130_fd_sc_hd__fill_2
XFILLER_34_231 VGND VGND VPWR VPWR sky130_fd_sc_hd__fill_2
XTAP_TAPCELL_ROW_124_1958 VGND VPWR sky130_fd_sc_hd__tapvpwrvgnd_1
XFILLER_62_551 VGND VGND VPWR VPWR sky130_fd_sc_hd__decap_3
XFILLER_34_253 VGND VGND VPWR VPWR sky130_fd_sc_hd__decap_3
X_5822_ _5973_/A _5822_/B _5822_/C VGND VGND VPWR VPWR _5907_/D sky130_fd_sc_hd__and3_4
XFILLER_34_275 VGND VGND VPWR VPWR sky130_fd_sc_hd__decap_3
XFILLER_50_735 VGND VGND VPWR VPWR sky130_fd_sc_hd__decap_3
XFILLER_34_297 VGND VGND VPWR VPWR sky130_fd_sc_hd__decap_3
XFILLER_22_437 VGND VGND VPWR VPWR sky130_fd_sc_hd__decap_3
XFILLER_50_757 VGND VGND VPWR VPWR sky130_fd_sc_hd__decap_3
X_5753_ _5753_/A _7773_/A VGND VGND VPWR VPWR _5753_/Y sky130_fd_sc_hd__xnor2_2
X_8541_ _8503_/A _8502_/B _8540_/X VGND VGND VPWR VPWR _8578_/B sky130_fd_sc_hd__o21ai_2
X_4704_ hold882/X hold949/X _4714_/S VGND VGND VPWR VPWR _4705_/A sky130_fd_sc_hd__mux2_2
X_8472_ _9223_/Q _8739_/B _8431_/A VGND VGND VPWR VPWR _8472_/Y sky130_fd_sc_hd__a21oi_2
X_5684_ _5685_/A _5685_/B VGND VGND VPWR VPWR _5684_/Y sky130_fd_sc_hd__nand2_2
XFILLER_30_492 VGND VGND VPWR VPWR sky130_fd_sc_hd__decap_3
X_7423_ _6250_/A _6250_/B _7952_/A VGND VGND VPWR VPWR _7602_/A sky130_fd_sc_hd__a21o_2
X_4635_ _4635_/A VGND VGND VPWR VPWR _9067_/D sky130_fd_sc_hd__buf_1
XFILLER_8_92 VGND VGND VPWR VPWR sky130_fd_sc_hd__decap_3
XFILLER_118_27 VGND VGND VPWR VPWR sky130_fd_sc_hd__fill_1
XFILLER_116_520 VGND VGND VPWR VPWR sky130_fd_sc_hd__decap_3
X_7354_ _7353_/B _7353_/C _7353_/A VGND VGND VPWR VPWR _7355_/B sky130_fd_sc_hd__a21o_2
XFILLER_118_38 VGND VGND VPWR VPWR sky130_fd_sc_hd__decap_3
X_4566_ hold964/X hold997/X _4566_/S VGND VGND VPWR VPWR _4567_/A sky130_fd_sc_hd__mux2_2
XTAP_TAPCELL_ROW_9_408 VGND VPWR sky130_fd_sc_hd__tapvpwrvgnd_1
XFILLER_116_553 VGND VGND VPWR VPWR sky130_fd_sc_hd__decap_3
XFILLER_104_704 VGND VGND VPWR VPWR sky130_fd_sc_hd__fill_2
X_6305_ _6305_/A _6305_/B VGND VGND VPWR VPWR _6575_/A sky130_fd_sc_hd__nor2_2
X_7285_ _7274_/B _7285_/B _7285_/C VGND VGND VPWR VPWR _7287_/B sky130_fd_sc_hd__and3b_2
XFILLER_104_748 VGND VGND VPWR VPWR sky130_fd_sc_hd__decap_3
X_9024_ clkload9/A _9024_/D load_slew368/X VGND VGND VPWR VPWR _9024_/Q sky130_fd_sc_hd__dfrtp_2
X_6236_ _6233_/Y _6234_/Y _6235_/Y _5738_/S _6239_/A VGND VGND VPWR VPWR _6240_/C
+ sky130_fd_sc_hd__a221o_2
XFILLER_103_236 VGND VGND VPWR VPWR sky130_fd_sc_hd__decap_3
X_6167_ _7573_/B _6167_/A2 _6963_/A _6279_/A VGND VGND VPWR VPWR _6172_/B sky130_fd_sc_hd__a211o_4
XFILLER_85_632 VGND VGND VPWR VPWR sky130_fd_sc_hd__decap_3
X_5118_ _9037_/Q _9101_/Q _5180_/S VGND VGND VPWR VPWR _5118_/X sky130_fd_sc_hd__mux2_2
XFILLER_84_120 VGND VGND VPWR VPWR sky130_fd_sc_hd__fill_2
XFILLER_85_654 VGND VGND VPWR VPWR sky130_fd_sc_hd__decap_3
X_6098_ _6098_/A _6103_/S VGND VGND VPWR VPWR _6098_/X sky130_fd_sc_hd__or2_2
X_5049_ _5047_/Y _5048_/X _6304_/A _5016_/B VGND VGND VPWR VPWR _5080_/A sky130_fd_sc_hd__a211o_2
XFILLER_85_698 VGND VGND VPWR VPWR sky130_fd_sc_hd__decap_3
XFILLER_38_570 VGND VGND VPWR VPWR sky130_fd_sc_hd__decap_3
XFILLER_26_710 VGND VGND VPWR VPWR sky130_fd_sc_hd__decap_3
XFILLER_38_592 VGND VGND VPWR VPWR sky130_fd_sc_hd__fill_1
XFILLER_27_79 VGND VGND VPWR VPWR sky130_fd_sc_hd__decap_3
XFILLER_25_220 VGND VGND VPWR VPWR sky130_fd_sc_hd__decap_3
XFILLER_25_242 VGND VGND VPWR VPWR sky130_fd_sc_hd__decap_3
X_8808_ _9249_/Q hold778/X _8812_/S VGND VGND VPWR VPWR _8808_/X sky130_fd_sc_hd__mux2_2
XTAP_TAPCELL_ROW_36_771 VGND VPWR sky130_fd_sc_hd__tapvpwrvgnd_1
XFILLER_41_724 VGND VGND VPWR VPWR sky130_fd_sc_hd__decap_3
XFILLER_43_34 VGND VGND VPWR VPWR sky130_fd_sc_hd__fill_2
XFILLER_25_297 VGND VGND VPWR VPWR sky130_fd_sc_hd__decap_3
XFILLER_40_234 VGND VGND VPWR VPWR sky130_fd_sc_hd__decap_3
XFILLER_9_408 VGND VGND VPWR VPWR sky130_fd_sc_hd__decap_3
XFILLER_13_459 VGND VGND VPWR VPWR sky130_fd_sc_hd__decap_3
X_8739_ _9229_/Q _8739_/B VGND VGND VPWR VPWR _8739_/Y sky130_fd_sc_hd__nor2_2
XFILLER_43_78 VGND VGND VPWR VPWR sky130_fd_sc_hd__decap_3
XFILLER_40_256 VGND VGND VPWR VPWR sky130_fd_sc_hd__decap_3
XFILLER_40_289 VGND VGND VPWR VPWR sky130_fd_sc_hd__decap_3
XFILLER_4_135 VGND VGND VPWR VPWR sky130_fd_sc_hd__decap_3
XFILLER_107_564 VGND VGND VPWR VPWR sky130_fd_sc_hd__decap_3
XFILLER_4_157 VGND VGND VPWR VPWR sky130_fd_sc_hd__fill_2
XFILLER_122_501 VGND VGND VPWR VPWR sky130_fd_sc_hd__decap_3
XFILLER_107_597 VGND VGND VPWR VPWR sky130_fd_sc_hd__decap_3
XFILLER_122_545 VGND VGND VPWR VPWR sky130_fd_sc_hd__decap_3
XFILLER_68_53 VGND VGND VPWR VPWR sky130_fd_sc_hd__decap_3
XFILLER_110_707 VGND VGND VPWR VPWR sky130_fd_sc_hd__decap_3
XTAP_TAPCELL_ROW_128_2003 VGND VPWR sky130_fd_sc_hd__tapvpwrvgnd_1
XFILLER_110_718 VGND VGND VPWR VPWR sky130_fd_sc_hd__decap_3
XTAP_TAPCELL_ROW_128_2014 VGND VPWR sky130_fd_sc_hd__tapvpwrvgnd_1
XFILLER_122_589 VGND VGND VPWR VPWR sky130_fd_sc_hd__decap_3
XFILLER_0_374 VGND VGND VPWR VPWR sky130_fd_sc_hd__decap_3
XFILLER_75_131 VGND VGND VPWR VPWR sky130_fd_sc_hd__decap_3
XFILLER_36_529 VGND VGND VPWR VPWR sky130_fd_sc_hd__decap_3
XFILLER_17_710 VGND VGND VPWR VPWR sky130_fd_sc_hd__decap_3
XFILLER_90_112 VGND VGND VPWR VPWR sky130_fd_sc_hd__decap_3
XFILLER_75_186 VGND VGND VPWR VPWR sky130_fd_sc_hd__fill_2
XFILLER_63_337 VGND VGND VPWR VPWR sky130_fd_sc_hd__decap_3
XFILLER_17_732 VGND VGND VPWR VPWR sky130_fd_sc_hd__decap_3
XFILLER_16_220 VGND VGND VPWR VPWR sky130_fd_sc_hd__decap_3
XFILLER_91_668 VGND VGND VPWR VPWR sky130_fd_sc_hd__decap_3
XFILLER_84_96 VGND VGND VPWR VPWR sky130_fd_sc_hd__decap_3
XFILLER_17_765 VGND VGND VPWR VPWR sky130_fd_sc_hd__decap_3
XFILLER_16_253 VGND VGND VPWR VPWR sky130_fd_sc_hd__decap_3
XFILLER_90_178 VGND VGND VPWR VPWR sky130_fd_sc_hd__fill_1
XFILLER_32_735 VGND VGND VPWR VPWR sky130_fd_sc_hd__decap_3
XFILLER_32_768 VGND VGND VPWR VPWR sky130_fd_sc_hd__decap_3
XFILLER_31_245 VGND VGND VPWR VPWR sky130_fd_sc_hd__decap_3
XTAP_TAPCELL_ROW_14_465 VGND VPWR sky130_fd_sc_hd__tapvpwrvgnd_1
XFILLER_129_111 VGND VGND VPWR VPWR sky130_fd_sc_hd__fill_1
XTAP_TAPCELL_ROW_14_476 VGND VPWR sky130_fd_sc_hd__tapvpwrvgnd_1
XFILLER_129_122 VGND VGND VPWR VPWR sky130_fd_sc_hd__decap_3
XFILLER_129_155 VGND VGND VPWR VPWR sky130_fd_sc_hd__decap_3
XFILLER_8_463 VGND VGND VPWR VPWR sky130_fd_sc_hd__decap_3
XFILLER_117_328 VGND VGND VPWR VPWR sky130_fd_sc_hd__decap_3
XFILLER_129_199 VGND VGND VPWR VPWR sky130_fd_sc_hd__decap_3
XFILLER_99_713 VGND VGND VPWR VPWR sky130_fd_sc_hd__decap_3
X_7070_ _7071_/B _7417_/A _7071_/D _7071_/A VGND VGND VPWR VPWR _7070_/X sky130_fd_sc_hd__a22o_2
XFILLER_4_691 VGND VGND VPWR VPWR sky130_fd_sc_hd__decap_3
X_6021_ _6016_/Y _6224_/A _6019_/Y _6020_/X VGND VGND VPWR VPWR _6022_/A sky130_fd_sc_hd__o211ai_4
XFILLER_86_418 VGND VGND VPWR VPWR sky130_fd_sc_hd__fill_2
XFILLER_101_729 VGND VGND VPWR VPWR sky130_fd_sc_hd__decap_3
XFILLER_39_301 VGND VGND VPWR VPWR sky130_fd_sc_hd__fill_1
XFILLER_100_228 VGND VGND VPWR VPWR sky130_fd_sc_hd__decap_3
XFILLER_67_676 VGND VGND VPWR VPWR sky130_fd_sc_hd__fill_1
XFILLER_94_473 VGND VGND VPWR VPWR sky130_fd_sc_hd__decap_3
XFILLER_39_378 VGND VGND VPWR VPWR sky130_fd_sc_hd__decap_3
XFILLER_81_101 VGND VGND VPWR VPWR sky130_fd_sc_hd__fill_2
XFILLER_27_529 VGND VGND VPWR VPWR sky130_fd_sc_hd__decap_3
X_7972_ _8780_/A _7971_/X _7440_/X VGND VGND VPWR VPWR _8079_/B sky130_fd_sc_hd__a21o_2
XFILLER_94_495 VGND VGND VPWR VPWR sky130_fd_sc_hd__decap_3
XFILLER_82_635 VGND VGND VPWR VPWR sky130_fd_sc_hd__decap_3
XFILLER_54_326 VGND VGND VPWR VPWR sky130_fd_sc_hd__decap_3
XFILLER_54_337 VGND VGND VPWR VPWR sky130_fd_sc_hd__decap_3
XTAP_TAPCELL_ROW_85_1430 VGND VPWR sky130_fd_sc_hd__tapvpwrvgnd_1
XFILLER_82_657 VGND VGND VPWR VPWR sky130_fd_sc_hd__decap_3
X_6923_ _6924_/B _6924_/C _6924_/A VGND VGND VPWR VPWR _6923_/X sky130_fd_sc_hd__a21o_2
XFILLER_81_156 VGND VGND VPWR VPWR sky130_fd_sc_hd__decap_3
XFILLER_35_573 VGND VGND VPWR VPWR sky130_fd_sc_hd__decap_3
XFILLER_23_713 VGND VGND VPWR VPWR sky130_fd_sc_hd__decap_3
X_6854_ _6835_/A _6834_/B _6834_/A VGND VGND VPWR VPWR _6854_/X sky130_fd_sc_hd__a21o_2
XFILLER_23_735 VGND VGND VPWR VPWR sky130_fd_sc_hd__decap_3
XFILLER_62_392 VGND VGND VPWR VPWR sky130_fd_sc_hd__decap_3
XTAP_TAPCELL_ROW_33_730 VGND VPWR sky130_fd_sc_hd__tapvpwrvgnd_1
XFILLER_50_543 VGND VGND VPWR VPWR sky130_fd_sc_hd__decap_3
X_5805_ _5803_/X _5804_/X _5220_/X _5801_/B VGND VGND VPWR VPWR _5805_/X sky130_fd_sc_hd__o211a_2
XFILLER_23_768 VGND VGND VPWR VPWR sky130_fd_sc_hd__decap_3
X_6785_ _6785_/A _6784_/X VGND VGND VPWR VPWR _6785_/X sky130_fd_sc_hd__or2b_4
XFILLER_22_256 VGND VGND VPWR VPWR sky130_fd_sc_hd__fill_1
XFILLER_13_15 VGND VGND VPWR VPWR sky130_fd_sc_hd__decap_3
XFILLER_50_587 VGND VGND VPWR VPWR sky130_fd_sc_hd__fill_1
X_5736_ _9343_/Q _9027_/Q _7794_/A VGND VGND VPWR VPWR _5737_/D sky130_fd_sc_hd__mux2_2
X_8524_ _9223_/Q wire71/X VGND VGND VPWR VPWR _8562_/B sky130_fd_sc_hd__nor2_2
XFILLER_50_598 VGND VGND VPWR VPWR sky130_fd_sc_hd__fill_1
XFILLER_129_15 VGND VGND VPWR VPWR sky130_fd_sc_hd__decap_3
X_5667_ _5803_/C _5664_/A _5667_/S VGND VGND VPWR VPWR _5668_/B sky130_fd_sc_hd__mux2_2
X_8455_ _8463_/A _8463_/B VGND VGND VPWR VPWR _8457_/A sky130_fd_sc_hd__or2_2
XFILLER_129_48 VGND VGND VPWR VPWR sky130_fd_sc_hd__decap_3
X_4618_ _4618_/A VGND VGND VPWR VPWR _9059_/D sky130_fd_sc_hd__buf_1
X_7406_ _7403_/X _7405_/X _7311_/A VGND VGND VPWR VPWR _7406_/X sky130_fd_sc_hd__a21o_2
X_8386_ _8386_/A VGND VGND VPWR VPWR _8387_/B sky130_fd_sc_hd__inv_2
X_5598_ _5356_/A _7573_/B _5425_/A _5597_/X VGND VGND VPWR VPWR _5604_/B sky130_fd_sc_hd__a31oi_4
XTAP_TAPCELL_ROW_96_1581 VGND VPWR sky130_fd_sc_hd__tapvpwrvgnd_1
X_7337_ _7413_/A _7416_/B VGND VGND VPWR VPWR _7337_/Y sky130_fd_sc_hd__nand2_2
X_4549_ _4549_/A VGND VGND VPWR VPWR _9026_/D sky130_fd_sc_hd__buf_1
XFILLER_116_361 VGND VGND VPWR VPWR sky130_fd_sc_hd__decap_3
XFILLER_2_628 VGND VGND VPWR VPWR sky130_fd_sc_hd__decap_3
Xmax_cap171 _5707_/A VGND VGND VPWR VPWR _6166_/A sky130_fd_sc_hd__clkbuf_2
XFILLER_1_116 VGND VGND VPWR VPWR sky130_fd_sc_hd__decap_3
Xmax_cap182 _6817_/Y VGND VGND VPWR VPWR _7179_/A sky130_fd_sc_hd__buf_2
X_7268_ _7266_/X _7267_/X _7268_/S VGND VGND VPWR VPWR _7268_/X sky130_fd_sc_hd__mux2_2
Xmax_cap193 _5262_/B VGND VGND VPWR VPWR _6754_/B sky130_fd_sc_hd__buf_4
XFILLER_89_256 VGND VGND VPWR VPWR sky130_fd_sc_hd__decap_3
XFILLER_77_407 VGND VGND VPWR VPWR sky130_fd_sc_hd__decap_3
XFILLER_104_589 VGND VGND VPWR VPWR sky130_fd_sc_hd__fill_1
X_6219_ _6370_/B _6528_/B _6218_/C _6218_/D VGND VGND VPWR VPWR _6220_/A sky130_fd_sc_hd__a22oi_2
X_9007_ _9007_/A0 _9007_/A1 _9009_/S VGND VGND VPWR VPWR _9008_/A sky130_fd_sc_hd__mux2_2
XFILLER_77_418 VGND VGND VPWR VPWR sky130_fd_sc_hd__decap_3
X_7199_ _7244_/B _7198_/X _8031_/A VGND VGND VPWR VPWR _7199_/X sky130_fd_sc_hd__mux2_2
XFILLER_58_621 VGND VGND VPWR VPWR sky130_fd_sc_hd__fill_2
XFILLER_58_654 VGND VGND VPWR VPWR sky130_fd_sc_hd__fill_1
Xhold1130 _9127_/Q VGND VGND VPWR VPWR _4794_/A1 sky130_fd_sc_hd__dlygate4sd3_1
XFILLER_38_67 VGND VGND VPWR VPWR sky130_fd_sc_hd__fill_2
Xhold1141 _9312_/Q VGND VGND VPWR VPWR _8974_/A1 sky130_fd_sc_hd__dlygate4sd3_1
Xhold1152 _9314_/Q VGND VGND VPWR VPWR _8944_/A0 sky130_fd_sc_hd__dlygate4sd3_1
Xhold1163 _9097_/Q VGND VGND VPWR VPWR _4731_/A1 sky130_fd_sc_hd__dlygate4sd3_1
XFILLER_73_624 VGND VGND VPWR VPWR sky130_fd_sc_hd__decap_3
XFILLER_18_529 VGND VGND VPWR VPWR sky130_fd_sc_hd__decap_3
Xhold1174 _9058_/Q VGND VGND VPWR VPWR _4648_/A1 sky130_fd_sc_hd__dlygate4sd3_1
XFILLER_72_101 VGND VGND VPWR VPWR sky130_fd_sc_hd__decap_3
Xhold1185 _9055_/Q VGND VGND VPWR VPWR _4642_/A1 sky130_fd_sc_hd__dlygate4sd3_1
Xhold1196 _9242_/Q VGND VGND VPWR VPWR _8827_/A1 sky130_fd_sc_hd__dlygate4sd3_1
XFILLER_73_657 VGND VGND VPWR VPWR sky130_fd_sc_hd__decap_3
XFILLER_26_551 VGND VGND VPWR VPWR sky130_fd_sc_hd__fill_1
XFILLER_72_167 VGND VGND VPWR VPWR sky130_fd_sc_hd__decap_3
XFILLER_60_307 VGND VGND VPWR VPWR sky130_fd_sc_hd__fill_1
XFILLER_26_562 VGND VGND VPWR VPWR sky130_fd_sc_hd__decap_3
XFILLER_14_713 VGND VGND VPWR VPWR sky130_fd_sc_hd__decap_3
XFILLER_53_381 VGND VGND VPWR VPWR sky130_fd_sc_hd__fill_2
XFILLER_54_88 VGND VGND VPWR VPWR sky130_fd_sc_hd__fill_1
XFILLER_41_532 VGND VGND VPWR VPWR sky130_fd_sc_hd__decap_3
XFILLER_14_746 VGND VGND VPWR VPWR sky130_fd_sc_hd__decap_3
XFILLER_14_757 VGND VGND VPWR VPWR sky130_fd_sc_hd__decap_3
XFILLER_9_216 VGND VGND VPWR VPWR sky130_fd_sc_hd__decap_3
XFILLER_41_576 VGND VGND VPWR VPWR sky130_fd_sc_hd__decap_3
XFILLER_110_83 VGND VGND VPWR VPWR sky130_fd_sc_hd__fill_1
XTAP_TAPCELL_ROW_11_424 VGND VPWR sky130_fd_sc_hd__tapvpwrvgnd_1
XTAP_TAPCELL_ROW_11_435 VGND VPWR sky130_fd_sc_hd__tapvpwrvgnd_1
XFILLER_127_604 VGND VGND VPWR VPWR sky130_fd_sc_hd__decap_3
Xclkload19 _9346_/CLK VGND VGND VPWR VPWR clkload19/X sky130_fd_sc_hd__clkbuf_8
XFILLER_127_626 VGND VGND VPWR VPWR sky130_fd_sc_hd__decap_3
XFILLER_126_103 VGND VGND VPWR VPWR sky130_fd_sc_hd__decap_3
Xrebuffer560 _6022_/A VGND VGND VPWR VPWR _6190_/B sky130_fd_sc_hd__buf_2
XFILLER_127_659 VGND VGND VPWR VPWR sky130_fd_sc_hd__decap_3
XFILLER_126_136 VGND VGND VPWR VPWR sky130_fd_sc_hd__decap_3
Xrebuffer571 _8264_/A VGND VGND VPWR VPWR _8379_/A sky130_fd_sc_hd__buf_2
XFILLER_126_147 VGND VGND VPWR VPWR sky130_fd_sc_hd__decap_3
Xrebuffer582 _5773_/A VGND VGND VPWR VPWR _5774_/B1 sky130_fd_sc_hd__buf_2
Xrebuffer593 _5720_/A1 VGND VGND VPWR VPWR _7099_/A sky130_fd_sc_hd__buf_2
XFILLER_119_81 VGND VGND VPWR VPWR sky130_fd_sc_hd__decap_3
XFILLER_114_309 VGND VGND VPWR VPWR sky130_fd_sc_hd__decap_3
XFILLER_5_488 VGND VGND VPWR VPWR sky130_fd_sc_hd__decap_3
XTAP_TAPCELL_ROW_56_1031 VGND VPWR sky130_fd_sc_hd__tapvpwrvgnd_1
XTAP_TAPCELL_ROW_56_1042 VGND VPWR sky130_fd_sc_hd__tapvpwrvgnd_1
XFILLER_48_9 VGND VGND VPWR VPWR sky130_fd_sc_hd__fill_2
XPHY_EDGE_ROW_79_Left_210 VGND VGND VPWR VPWR sky130_fd_sc_hd__decap_3
XFILLER_122_331 VGND VGND VPWR VPWR sky130_fd_sc_hd__decap_3
XFILLER_79_96 VGND VGND VPWR VPWR sky130_fd_sc_hd__decap_3
XFILLER_1_650 VGND VGND VPWR VPWR sky130_fd_sc_hd__decap_3
XFILLER_68_418 VGND VGND VPWR VPWR sky130_fd_sc_hd__fill_2
XFILLER_96_749 VGND VGND VPWR VPWR sky130_fd_sc_hd__decap_3
XFILLER_122_397 VGND VGND VPWR VPWR sky130_fd_sc_hd__decap_3
XFILLER_1_694 VGND VGND VPWR VPWR sky130_fd_sc_hd__decap_3
XFILLER_110_559 VGND VGND VPWR VPWR sky130_fd_sc_hd__decap_3
XFILLER_49_654 VGND VGND VPWR VPWR sky130_fd_sc_hd__decap_3
XFILLER_95_73 VGND VGND VPWR VPWR sky130_fd_sc_hd__decap_3
XFILLER_76_451 VGND VGND VPWR VPWR sky130_fd_sc_hd__decap_3
XFILLER_95_84 VGND VGND VPWR VPWR sky130_fd_sc_hd__decap_3
XFILLER_49_676 VGND VGND VPWR VPWR sky130_fd_sc_hd__decap_3
XTAP_TAPCELL_ROW_108_1739 VGND VPWR sky130_fd_sc_hd__tapvpwrvgnd_1
XFILLER_48_186 VGND VGND VPWR VPWR sky130_fd_sc_hd__decap_3
XFILLER_91_432 VGND VGND VPWR VPWR sky130_fd_sc_hd__decap_3
XFILLER_48_197 VGND VGND VPWR VPWR sky130_fd_sc_hd__fill_2
XTAP_TAPCELL_ROW_19_535 VGND VPWR sky130_fd_sc_hd__tapvpwrvgnd_1
XFILLER_17_540 VGND VGND VPWR VPWR sky130_fd_sc_hd__fill_2
XFILLER_63_156 VGND VGND VPWR VPWR sky130_fd_sc_hd__decap_3
XFILLER_51_307 VGND VGND VPWR VPWR sky130_fd_sc_hd__fill_1
XTAP_TAPCELL_ROW_121_1917 VGND VPWR sky130_fd_sc_hd__tapvpwrvgnd_1
XFILLER_51_329 VGND VGND VPWR VPWR sky130_fd_sc_hd__decap_3
XFILLER_17_573 VGND VGND VPWR VPWR sky130_fd_sc_hd__fill_1
XFILLER_91_498 VGND VGND VPWR VPWR sky130_fd_sc_hd__decap_3
XFILLER_32_510 VGND VGND VPWR VPWR sky130_fd_sc_hd__decap_3
XTAP_TAPCELL_ROW_67_1182 VGND VPWR sky130_fd_sc_hd__tapvpwrvgnd_1
XFILLER_20_716 VGND VGND VPWR VPWR sky130_fd_sc_hd__decap_3
XTAP_TAPCELL_ROW_80_1360 VGND VPWR sky130_fd_sc_hd__tapvpwrvgnd_1
X_6570_ _8050_/A _7952_/A _8309_/A _5897_/D VGND VGND VPWR VPWR _6570_/X sky130_fd_sc_hd__o211a_2
XFILLER_81_3 VGND VGND VPWR VPWR sky130_fd_sc_hd__decap_3
XFILLER_20_749 VGND VGND VPWR VPWR sky130_fd_sc_hd__decap_3
XFILLER_9_750 VGND VGND VPWR VPWR sky130_fd_sc_hd__decap_3
X_5521_ _5521_/A _5521_/B VGND VGND VPWR VPWR _5522_/B sky130_fd_sc_hd__xnor2_2
XFILLER_118_604 VGND VGND VPWR VPWR sky130_fd_sc_hd__decap_3
XFILLER_8_271 VGND VGND VPWR VPWR sky130_fd_sc_hd__decap_3
XFILLER_118_648 VGND VGND VPWR VPWR sky130_fd_sc_hd__decap_3
X_8240_ _8240_/A _8240_/B VGND VGND VPWR VPWR _8244_/A sky130_fd_sc_hd__nor2_2
X_5452_ _5452_/A _5452_/B _5452_/C VGND VGND VPWR VPWR _5490_/A sky130_fd_sc_hd__or3_4
XFILLER_117_169 VGND VGND VPWR VPWR sky130_fd_sc_hd__decap_3
X_8171_ _8169_/Y _8170_/Y _8248_/B VGND VGND VPWR VPWR _8178_/A sky130_fd_sc_hd__a21oi_2
X_5383_ _5384_/A _5462_/S _9276_/Q VGND VGND VPWR VPWR _5383_/Y sky130_fd_sc_hd__nor3b_2
XFILLER_126_681 VGND VGND VPWR VPWR sky130_fd_sc_hd__decap_3
X_7122_ _9212_/Q _7924_/B VGND VGND VPWR VPWR _7123_/B sky130_fd_sc_hd__or2_2
XFILLER_5_60 VGND VGND VPWR VPWR sky130_fd_sc_hd__fill_1
XFILLER_99_554 VGND VGND VPWR VPWR sky130_fd_sc_hd__decap_3
XFILLER_87_727 VGND VGND VPWR VPWR sky130_fd_sc_hd__fill_1
X_7053_ _7051_/X _7053_/B VGND VGND VPWR VPWR _7054_/B sky130_fd_sc_hd__and2b_2
XFILLER_59_429 VGND VGND VPWR VPWR sky130_fd_sc_hd__decap_3
Xfanout239 _9237_/Q VGND VGND VPWR VPWR _6232_/C sky130_fd_sc_hd__buf_4
XFILLER_115_39 VGND VGND VPWR VPWR sky130_fd_sc_hd__decap_3
XFILLER_113_386 VGND VGND VPWR VPWR sky130_fd_sc_hd__decap_3
X_6004_ _9207_/Q _6004_/B VGND VGND VPWR VPWR _6005_/B sky130_fd_sc_hd__xnor2_2
XTAP_TAPCELL_ROW_38_800 VGND VPWR sky130_fd_sc_hd__tapvpwrvgnd_1
XFILLER_67_473 VGND VGND VPWR VPWR sky130_fd_sc_hd__fill_2
XFILLER_55_613 VGND VGND VPWR VPWR sky130_fd_sc_hd__decap_3
XFILLER_39_175 VGND VGND VPWR VPWR sky130_fd_sc_hd__decap_3
XFILLER_82_421 VGND VGND VPWR VPWR sky130_fd_sc_hd__decap_3
XFILLER_27_337 VGND VGND VPWR VPWR sky130_fd_sc_hd__decap_3
XFILLER_82_443 VGND VGND VPWR VPWR sky130_fd_sc_hd__decap_3
XFILLER_55_668 VGND VGND VPWR VPWR sky130_fd_sc_hd__decap_3
XFILLER_54_145 VGND VGND VPWR VPWR sky130_fd_sc_hd__decap_3
X_7955_ _7955_/A VGND VGND VPWR VPWR _8149_/A sky130_fd_sc_hd__clkbuf_1
XFILLER_82_487 VGND VGND VPWR VPWR sky130_fd_sc_hd__decap_3
XFILLER_42_318 VGND VGND VPWR VPWR sky130_fd_sc_hd__decap_3
X_6906_ _6905_/Y _6655_/Y _6780_/B VGND VGND VPWR VPWR _7145_/A sky130_fd_sc_hd__a21oi_4
X_7886_ _7656_/A _7885_/Y _7877_/X VGND VGND VPWR VPWR _7887_/B sky130_fd_sc_hd__o21a_2
XFILLER_35_381 VGND VGND VPWR VPWR sky130_fd_sc_hd__decap_3
XFILLER_23_521 VGND VGND VPWR VPWR sky130_fd_sc_hd__decap_3
XFILLER_23_554 VGND VGND VPWR VPWR sky130_fd_sc_hd__decap_3
X_6837_ _6494_/A _6837_/A2 _6836_/X VGND VGND VPWR VPWR _6900_/B sky130_fd_sc_hd__o21ai_2
XFILLER_24_47 VGND VGND VPWR VPWR sky130_fd_sc_hd__decap_3
XFILLER_11_705 VGND VGND VPWR VPWR sky130_fd_sc_hd__decap_3
XFILLER_50_351 VGND VGND VPWR VPWR sky130_fd_sc_hd__decap_3
XFILLER_23_576 VGND VGND VPWR VPWR sky130_fd_sc_hd__decap_3
XFILLER_11_738 VGND VGND VPWR VPWR sky130_fd_sc_hd__decap_3
XFILLER_10_215 VGND VGND VPWR VPWR sky130_fd_sc_hd__decap_3
X_6768_ _6768_/A _6768_/B VGND VGND VPWR VPWR _6907_/B sky130_fd_sc_hd__xnor2_2
XFILLER_50_395 VGND VGND VPWR VPWR sky130_fd_sc_hd__decap_3
XTAP_TAPCELL_ROW_98_1610 VGND VPWR sky130_fd_sc_hd__tapvpwrvgnd_1
XFILLER_10_237 VGND VGND VPWR VPWR sky130_fd_sc_hd__decap_3
XFILLER_109_615 VGND VGND VPWR VPWR sky130_fd_sc_hd__fill_1
X_8507_ _8507_/A _8633_/A VGND VGND VPWR VPWR _8507_/Y sky130_fd_sc_hd__xnor2_2
XFILLER_109_626 VGND VGND VPWR VPWR sky130_fd_sc_hd__fill_2
X_5719_ _5719_/A VGND VGND VPWR VPWR _8066_/A sky130_fd_sc_hd__clkbuf_2
X_6699_ _6699_/A _6699_/B _6699_/C VGND VGND VPWR VPWR _6701_/B sky130_fd_sc_hd__nand3_2
XFILLER_109_637 VGND VGND VPWR VPWR sky130_fd_sc_hd__decap_3
X_8438_ _8446_/A _8446_/B VGND VGND VPWR VPWR _8438_/Y sky130_fd_sc_hd__nor2_2
XFILLER_117_670 VGND VGND VPWR VPWR sky130_fd_sc_hd__fill_2
X_8369_ _8402_/A wire45/A VGND VGND VPWR VPWR _8369_/X sky130_fd_sc_hd__or2_2
XFILLER_123_128 VGND VGND VPWR VPWR sky130_fd_sc_hd__decap_3
XFILLER_104_320 VGND VGND VPWR VPWR sky130_fd_sc_hd__decap_3
XFILLER_49_22 VGND VGND VPWR VPWR sky130_fd_sc_hd__decap_3
XFILLER_49_55 VGND VGND VPWR VPWR sky130_fd_sc_hd__fill_1
XFILLER_78_749 VGND VGND VPWR VPWR sky130_fd_sc_hd__decap_3
XFILLER_49_99 VGND VGND VPWR VPWR sky130_fd_sc_hd__decap_3
XFILLER_1_18 VGND VGND VPWR VPWR sky130_fd_sc_hd__decap_3
XFILLER_18_304 VGND VGND VPWR VPWR sky130_fd_sc_hd__decap_3
XFILLER_100_570 VGND VGND VPWR VPWR sky130_fd_sc_hd__decap_3
XFILLER_58_484 VGND VGND VPWR VPWR sky130_fd_sc_hd__decap_3
XFILLER_18_315 VGND VGND VPWR VPWR sky130_fd_sc_hd__fill_2
XFILLER_85_270 VGND VGND VPWR VPWR sky130_fd_sc_hd__decap_3
XFILLER_46_635 VGND VGND VPWR VPWR sky130_fd_sc_hd__decap_3
XFILLER_85_281 VGND VGND VPWR VPWR sky130_fd_sc_hd__fill_2
XFILLER_65_65 VGND VGND VPWR VPWR sky130_fd_sc_hd__decap_3
XFILLER_45_145 VGND VGND VPWR VPWR sky130_fd_sc_hd__decap_3
XFILLER_46_679 VGND VGND VPWR VPWR sky130_fd_sc_hd__fill_1
XFILLER_45_178 VGND VGND VPWR VPWR sky130_fd_sc_hd__fill_2
XFILLER_60_126 VGND VGND VPWR VPWR sky130_fd_sc_hd__decap_3
XFILLER_121_60 VGND VGND VPWR VPWR sky130_fd_sc_hd__decap_3
XFILLER_26_392 VGND VGND VPWR VPWR sky130_fd_sc_hd__decap_3
XTAP_TAPCELL_ROW_44_869 VGND VPWR sky130_fd_sc_hd__tapvpwrvgnd_1
XFILLER_60_159 VGND VGND VPWR VPWR sky130_fd_sc_hd__decap_3
XFILLER_121_93 VGND VGND VPWR VPWR sky130_fd_sc_hd__decap_3
XFILLER_81_42 VGND VGND VPWR VPWR sky130_fd_sc_hd__fill_1
XFILLER_41_340 VGND VGND VPWR VPWR sky130_fd_sc_hd__decap_3
XFILLER_14_554 VGND VGND VPWR VPWR sky130_fd_sc_hd__decap_3
XTAP_TAPCELL_ROW_103_1669 VGND VPWR sky130_fd_sc_hd__tapvpwrvgnd_1
XFILLER_41_373 VGND VGND VPWR VPWR sky130_fd_sc_hd__decap_3
XFILLER_14_91 VGND VGND VPWR VPWR sky130_fd_sc_hd__decap_3
XFILLER_10_760 VGND VGND VPWR VPWR sky130_fd_sc_hd__decap_3
XFILLER_127_423 VGND VGND VPWR VPWR sky130_fd_sc_hd__decap_3
XFILLER_6_731 VGND VGND VPWR VPWR sky130_fd_sc_hd__decap_3
XFILLER_115_607 VGND VGND VPWR VPWR sky130_fd_sc_hd__decap_3
XFILLER_5_252 VGND VGND VPWR VPWR sky130_fd_sc_hd__fill_1
XFILLER_108_692 VGND VGND VPWR VPWR sky130_fd_sc_hd__decap_3
XFILLER_69_716 VGND VGND VPWR VPWR sky130_fd_sc_hd__decap_3
XFILLER_123_673 VGND VGND VPWR VPWR sky130_fd_sc_hd__fill_2
XFILLER_122_150 VGND VGND VPWR VPWR sky130_fd_sc_hd__decap_3
XFILLER_69_749 VGND VGND VPWR VPWR sky130_fd_sc_hd__decap_3
XFILLER_122_183 VGND VGND VPWR VPWR sky130_fd_sc_hd__decap_3
XFILLER_110_356 VGND VGND VPWR VPWR sky130_fd_sc_hd__decap_3
XFILLER_77_760 VGND VGND VPWR VPWR sky130_fd_sc_hd__fill_2
Xinput6 sample_in[13] VGND VGND VPWR VPWR input6/X sky130_fd_sc_hd__clkdlybuf4s25_1
XTAP_TAPCELL_ROW_69_1211 VGND VPWR sky130_fd_sc_hd__tapvpwrvgnd_1
XFILLER_49_484 VGND VGND VPWR VPWR sky130_fd_sc_hd__decap_3
XFILLER_92_730 VGND VGND VPWR VPWR sky130_fd_sc_hd__decap_3
XFILLER_76_281 VGND VGND VPWR VPWR sky130_fd_sc_hd__decap_3
XFILLER_64_421 VGND VGND VPWR VPWR sky130_fd_sc_hd__fill_1
XFILLER_37_646 VGND VGND VPWR VPWR sky130_fd_sc_hd__fill_1
XFILLER_91_240 VGND VGND VPWR VPWR sky130_fd_sc_hd__fill_1
XFILLER_37_679 VGND VGND VPWR VPWR sky130_fd_sc_hd__decap_3
XFILLER_36_156 VGND VGND VPWR VPWR sky130_fd_sc_hd__decap_3
XFILLER_91_262 VGND VGND VPWR VPWR sky130_fd_sc_hd__decap_3
XFILLER_52_627 VGND VGND VPWR VPWR sky130_fd_sc_hd__decap_3
XFILLER_24_318 VGND VGND VPWR VPWR sky130_fd_sc_hd__decap_3
X_4952_ _4952_/A _8780_/A VGND VGND VPWR VPWR _4952_/Y sky130_fd_sc_hd__xnor2_4
X_7740_ _7740_/A _7740_/B VGND VGND VPWR VPWR _7741_/B sky130_fd_sc_hd__xnor2_2
XFILLER_64_498 VGND VGND VPWR VPWR sky130_fd_sc_hd__decap_3
XFILLER_17_381 VGND VGND VPWR VPWR sky130_fd_sc_hd__decap_3
XFILLER_51_148 VGND VGND VPWR VPWR sky130_fd_sc_hd__decap_3
X_4883_ _9213_/Q _4899_/B VGND VGND VPWR VPWR _4883_/Y sky130_fd_sc_hd__nor2_2
X_7671_ _7539_/A _7667_/Y _7669_/X _7670_/Y VGND VGND VPWR VPWR _7671_/X sky130_fd_sc_hd__a22o_2
XFILLER_20_513 VGND VGND VPWR VPWR sky130_fd_sc_hd__decap_3
X_6622_ _5014_/X _6939_/B _6285_/A _5984_/B _7065_/B VGND VGND VPWR VPWR _6622_/X
+ sky130_fd_sc_hd__o32a_2
XFILLER_20_557 VGND VGND VPWR VPWR sky130_fd_sc_hd__decap_3
X_6553_ _5999_/A _5999_/B _5984_/B VGND VGND VPWR VPWR _6746_/A sky130_fd_sc_hd__a21o_2
X_9341_ _9341_/CLK _9341_/D load_slew378/X VGND VGND VPWR VPWR _9341_/Q sky130_fd_sc_hd__dfrtp_2
XFILLER_20_568 VGND VGND VPWR VPWR sky130_fd_sc_hd__fill_2
XFILLER_118_401 VGND VGND VPWR VPWR sky130_fd_sc_hd__decap_3
X_5504_ _5501_/X _5503_/X _7528_/B2 VGND VGND VPWR VPWR _5504_/Y sky130_fd_sc_hd__a21oi_2
X_6484_ _6793_/B _6484_/B VGND VGND VPWR VPWR _6485_/B sky130_fd_sc_hd__xnor2_2
X_9272_ clkload6/A _9272_/D load_slew376/X VGND VGND VPWR VPWR _9272_/Q sky130_fd_sc_hd__dfrtp_2
XFILLER_118_456 VGND VGND VPWR VPWR sky130_fd_sc_hd__decap_3
XFILLER_106_607 VGND VGND VPWR VPWR sky130_fd_sc_hd__decap_3
XFILLER_105_106 VGND VGND VPWR VPWR sky130_fd_sc_hd__decap_3
X_5435_ _5576_/B _5435_/B VGND VGND VPWR VPWR _5436_/B sky130_fd_sc_hd__xnor2_2
X_8223_ _8178_/A _8177_/B _8222_/Y _8177_/A VGND VGND VPWR VPWR _8337_/B sky130_fd_sc_hd__o22a_2
XFILLER_118_489 VGND VGND VPWR VPWR sky130_fd_sc_hd__decap_3
XFILLER_10_27 VGND VGND VPWR VPWR sky130_fd_sc_hd__fill_1
XFILLER_105_128 VGND VGND VPWR VPWR sky130_fd_sc_hd__decap_3
XFILLER_10_38 VGND VGND VPWR VPWR sky130_fd_sc_hd__decap_3
XTAP_TAPCELL_ROW_93_1540 VGND VPWR sky130_fd_sc_hd__tapvpwrvgnd_1
XFILLER_126_27 VGND VGND VPWR VPWR sky130_fd_sc_hd__fill_1
X_5366_ _5366_/A _5366_/B VGND VGND VPWR VPWR _5452_/A sky130_fd_sc_hd__xnor2_2
X_8154_ _8154_/A _8232_/A VGND VGND VPWR VPWR _8165_/B sky130_fd_sc_hd__nand2_2
XFILLER_126_38 VGND VGND VPWR VPWR sky130_fd_sc_hd__decap_3
XFILLER_114_651 VGND VGND VPWR VPWR sky130_fd_sc_hd__decap_3
XFILLER_120_109 VGND VGND VPWR VPWR sky130_fd_sc_hd__decap_3
X_7105_ _7102_/X _7103_/Y _7063_/X _7064_/Y VGND VGND VPWR VPWR _7106_/C sky130_fd_sc_hd__a211oi_4
XFILLER_101_301 VGND VGND VPWR VPWR sky130_fd_sc_hd__fill_1
X_8085_ _9218_/Q _8257_/B _8084_/X VGND VGND VPWR VPWR _8086_/B sky130_fd_sc_hd__a21oi_2
XFILLER_101_312 VGND VGND VPWR VPWR sky130_fd_sc_hd__fill_1
X_5297_ _5011_/X _7569_/A _8080_/A _6160_/A1 VGND VGND VPWR VPWR _5298_/B sky130_fd_sc_hd__o211a_2
XFILLER_114_695 VGND VGND VPWR VPWR sky130_fd_sc_hd__decap_3
XFILLER_87_546 VGND VGND VPWR VPWR sky130_fd_sc_hd__decap_3
X_7036_ _7036_/A _7036_/B VGND VGND VPWR VPWR _7036_/Y sky130_fd_sc_hd__nand2_2
XFILLER_87_579 VGND VGND VPWR VPWR sky130_fd_sc_hd__decap_3
XFILLER_68_760 VGND VGND VPWR VPWR sky130_fd_sc_hd__decap_3
XFILLER_19_47 VGND VGND VPWR VPWR sky130_fd_sc_hd__decap_3
XFILLER_28_624 VGND VGND VPWR VPWR sky130_fd_sc_hd__decap_3
XFILLER_95_590 VGND VGND VPWR VPWR sky130_fd_sc_hd__decap_3
XFILLER_67_281 VGND VGND VPWR VPWR sky130_fd_sc_hd__decap_3
XFILLER_28_668 VGND VGND VPWR VPWR sky130_fd_sc_hd__decap_3
XFILLER_27_156 VGND VGND VPWR VPWR sky130_fd_sc_hd__decap_3
X_8987_ _8987_/A VGND VGND VPWR VPWR _9334_/D sky130_fd_sc_hd__buf_1
XFILLER_70_424 VGND VGND VPWR VPWR sky130_fd_sc_hd__decap_3
XFILLER_55_498 VGND VGND VPWR VPWR sky130_fd_sc_hd__decap_3
XFILLER_42_115 VGND VGND VPWR VPWR sky130_fd_sc_hd__decap_3
X_7938_ _7775_/A _7932_/X _7933_/Y _7937_/X VGND VGND VPWR VPWR _7965_/A sky130_fd_sc_hd__o211a_2
XFILLER_35_57 VGND VGND VPWR VPWR sky130_fd_sc_hd__decap_3
XFILLER_36_690 VGND VGND VPWR VPWR sky130_fd_sc_hd__decap_3
XFILLER_35_79 VGND VGND VPWR VPWR sky130_fd_sc_hd__decap_3
XFILLER_42_159 VGND VGND VPWR VPWR sky130_fd_sc_hd__decap_3
X_7869_ _7869_/A _7869_/B VGND VGND VPWR VPWR _7869_/X sky130_fd_sc_hd__or2_2
XFILLER_23_351 VGND VGND VPWR VPWR sky130_fd_sc_hd__fill_2
XTAP_TAPCELL_ROW_41_839 VGND VPWR sky130_fd_sc_hd__tapvpwrvgnd_1
XFILLER_51_682 VGND VGND VPWR VPWR sky130_fd_sc_hd__decap_3
XFILLER_23_384 VGND VGND VPWR VPWR sky130_fd_sc_hd__decap_3
XPHY_EDGE_ROW_14_Right_14 VGND VGND VPWR VPWR sky130_fd_sc_hd__decap_3
XFILLER_128_209 VGND VGND VPWR VPWR sky130_fd_sc_hd__decap_3
XFILLER_11_557 VGND VGND VPWR VPWR sky130_fd_sc_hd__decap_3
XFILLER_11_579 VGND VGND VPWR VPWR sky130_fd_sc_hd__fill_1
XFILLER_109_423 VGND VGND VPWR VPWR sky130_fd_sc_hd__decap_3
XTAP_TAPCELL_ROW_21_563 VGND VPWR sky130_fd_sc_hd__tapvpwrvgnd_1
XFILLER_51_78 VGND VGND VPWR VPWR sky130_fd_sc_hd__decap_3
XFILLER_129_3 VGND VGND VPWR VPWR sky130_fd_sc_hd__decap_3
XFILLER_109_467 VGND VGND VPWR VPWR sky130_fd_sc_hd__decap_3
XFILLER_124_415 VGND VGND VPWR VPWR sky130_fd_sc_hd__decap_3
XFILLER_3_712 VGND VGND VPWR VPWR sky130_fd_sc_hd__decap_3
XFILLER_3_756 VGND VGND VPWR VPWR sky130_fd_sc_hd__decap_3
XTAP_TAPCELL_ROW_53_1001 VGND VPWR sky130_fd_sc_hd__tapvpwrvgnd_1
Xload_slew409 fanout407/X VGND VGND VPWR VPWR fanout405/A sky130_fd_sc_hd__buf_2
XFILLER_105_673 VGND VGND VPWR VPWR sky130_fd_sc_hd__decap_3
XFILLER_78_502 VGND VGND VPWR VPWR sky130_fd_sc_hd__decap_3
XFILLER_2_266 VGND VGND VPWR VPWR sky130_fd_sc_hd__fill_1
XPHY_EDGE_ROW_23_Right_23 VGND VGND VPWR VPWR sky130_fd_sc_hd__decap_3
XFILLER_120_621 VGND VGND VPWR VPWR sky130_fd_sc_hd__decap_3
XFILLER_116_71 VGND VGND VPWR VPWR sky130_fd_sc_hd__decap_3
XFILLER_93_505 VGND VGND VPWR VPWR sky130_fd_sc_hd__decap_3
XTAP_TAPCELL_ROW_49_939 VGND VPWR sky130_fd_sc_hd__tapvpwrvgnd_1
XFILLER_19_613 VGND VGND VPWR VPWR sky130_fd_sc_hd__decap_3
XFILLER_46_421 VGND VGND VPWR VPWR sky130_fd_sc_hd__decap_3
XFILLER_18_112 VGND VGND VPWR VPWR sky130_fd_sc_hd__decap_3
XFILLER_19_657 VGND VGND VPWR VPWR sky130_fd_sc_hd__decap_3
XFILLER_46_454 VGND VGND VPWR VPWR sky130_fd_sc_hd__decap_3
XFILLER_19_668 VGND VGND VPWR VPWR sky130_fd_sc_hd__decap_3
XFILLER_19_679 VGND VGND VPWR VPWR sky130_fd_sc_hd__fill_2
XFILLER_74_774 VGND VGND VPWR VPWR sky130_fd_sc_hd__decap_3
XFILLER_73_262 VGND VGND VPWR VPWR sky130_fd_sc_hd__decap_3
XTAP_TAPCELL_ROW_29_674 VGND VPWR sky130_fd_sc_hd__tapvpwrvgnd_1
XFILLER_34_627 VGND VGND VPWR VPWR sky130_fd_sc_hd__decap_3
XFILLER_46_498 VGND VGND VPWR VPWR sky130_fd_sc_hd__decap_3
XFILLER_61_446 VGND VGND VPWR VPWR sky130_fd_sc_hd__fill_2
XFILLER_33_137 VGND VGND VPWR VPWR sky130_fd_sc_hd__decap_3
XTAP_TAPCELL_ROW_64_1141 VGND VPWR sky130_fd_sc_hd__tapvpwrvgnd_1
XFILLER_33_159 VGND VGND VPWR VPWR sky130_fd_sc_hd__decap_3
XPHY_EDGE_ROW_32_Right_32 VGND VGND VPWR VPWR sky130_fd_sc_hd__decap_3
XFILLER_61_479 VGND VGND VPWR VPWR sky130_fd_sc_hd__decap_3
XTAP_TAPCELL_ROW_64_1152 VGND VPWR sky130_fd_sc_hd__tapvpwrvgnd_1
XFILLER_14_362 VGND VGND VPWR VPWR sky130_fd_sc_hd__fill_2
XFILLER_128_710 VGND VGND VPWR VPWR sky130_fd_sc_hd__decap_3
XFILLER_128_743 VGND VGND VPWR VPWR sky130_fd_sc_hd__decap_3
XFILLER_127_220 VGND VGND VPWR VPWR sky130_fd_sc_hd__decap_3
XFILLER_127_231 VGND VGND VPWR VPWR sky130_fd_sc_hd__decap_3
XFILLER_115_404 VGND VGND VPWR VPWR sky130_fd_sc_hd__decap_3
XFILLER_6_561 VGND VGND VPWR VPWR sky130_fd_sc_hd__decap_3
XFILLER_127_264 VGND VGND VPWR VPWR sky130_fd_sc_hd__decap_3
XTAP_TAPCELL_ROW_116_1849 VGND VPWR sky130_fd_sc_hd__tapvpwrvgnd_1
X_5220_ _6436_/A VGND VGND VPWR VPWR _5220_/X sky130_fd_sc_hd__clkbuf_1
XPHY_EDGE_ROW_41_Right_41 VGND VGND VPWR VPWR sky130_fd_sc_hd__decap_3
XFILLER_44_3 VGND VGND VPWR VPWR sky130_fd_sc_hd__decap_3
X_5151_ _5149_/X _5150_/X _6765_/A VGND VGND VPWR VPWR _5152_/B sky130_fd_sc_hd__o21a_2
XTAP_TAPCELL_ROW_75_1292 VGND VPWR sky130_fd_sc_hd__tapvpwrvgnd_1
XFILLER_123_470 VGND VGND VPWR VPWR sky130_fd_sc_hd__fill_1
XFILLER_69_546 VGND VGND VPWR VPWR sky130_fd_sc_hd__decap_3
X_5082_ _5950_/A VGND VGND VPWR VPWR _6436_/A sky130_fd_sc_hd__inv_2
XFILLER_111_676 VGND VGND VPWR VPWR sky130_fd_sc_hd__decap_3
XFILLER_2_50 VGND VGND VPWR VPWR sky130_fd_sc_hd__decap_3
XPHY_EDGE_ROW_16_Left_147 VGND VGND VPWR VPWR sky130_fd_sc_hd__decap_3
XFILLER_84_527 VGND VGND VPWR VPWR sky130_fd_sc_hd__decap_3
XFILLER_56_218 VGND VGND VPWR VPWR sky130_fd_sc_hd__decap_3
XFILLER_110_164 VGND VGND VPWR VPWR sky130_fd_sc_hd__decap_3
X_8910_ _8910_/A VGND VGND VPWR VPWR _9297_/D sky130_fd_sc_hd__buf_1
XFILLER_49_270 VGND VGND VPWR VPWR sky130_fd_sc_hd__decap_3
XFILLER_37_421 VGND VGND VPWR VPWR sky130_fd_sc_hd__fill_2
XFILLER_2_83 VGND VGND VPWR VPWR sky130_fd_sc_hd__fill_1
XFILLER_2_94 VGND VGND VPWR VPWR sky130_fd_sc_hd__decap_3
XFILLER_37_443 VGND VGND VPWR VPWR sky130_fd_sc_hd__decap_3
XFILLER_112_18 VGND VGND VPWR VPWR sky130_fd_sc_hd__decap_3
X_8841_ _8875_/A1 _8841_/A1 _8841_/S VGND VGND VPWR VPWR _8842_/A sky130_fd_sc_hd__mux2_2
XFILLER_65_763 VGND VGND VPWR VPWR sky130_fd_sc_hd__fill_1
XFILLER_64_251 VGND VGND VPWR VPWR sky130_fd_sc_hd__fill_1
XFILLER_37_465 VGND VGND VPWR VPWR sky130_fd_sc_hd__decap_3
XFILLER_25_605 VGND VGND VPWR VPWR sky130_fd_sc_hd__decap_3
XFILLER_112_29 VGND VGND VPWR VPWR sky130_fd_sc_hd__decap_3
XFILLER_92_571 VGND VGND VPWR VPWR sky130_fd_sc_hd__decap_3
XFILLER_52_413 VGND VGND VPWR VPWR sky130_fd_sc_hd__decap_3
X_8772_ _8772_/A _8772_/B _8772_/C VGND VGND VPWR VPWR _8773_/A sky130_fd_sc_hd__and3_4
XPHY_EDGE_ROW_50_Right_50 VGND VGND VPWR VPWR sky130_fd_sc_hd__decap_3
X_5984_ _7050_/B _5984_/B _5984_/C _7430_/B VGND VGND VPWR VPWR _5984_/X sky130_fd_sc_hd__or4_2
XFILLER_40_608 VGND VGND VPWR VPWR sky130_fd_sc_hd__decap_3
X_7723_ _7683_/A _8037_/A _7684_/A VGND VGND VPWR VPWR _7723_/X sky130_fd_sc_hd__a21o_2
X_4935_ _5737_/B _5739_/S VGND VGND VPWR VPWR _4935_/X sky130_fd_sc_hd__and2_2
XFILLER_33_671 VGND VGND VPWR VPWR sky130_fd_sc_hd__fill_1
X_7654_ _7554_/A _7553_/B _7653_/X VGND VGND VPWR VPWR _7857_/A sky130_fd_sc_hd__o21ai_2
X_4866_ _4866_/A VGND VGND VPWR VPWR _9176_/D sky130_fd_sc_hd__buf_1
XFILLER_60_490 VGND VGND VPWR VPWR sky130_fd_sc_hd__decap_3
XPHY_EDGE_ROW_25_Left_156 VGND VGND VPWR VPWR sky130_fd_sc_hd__decap_3
X_6605_ _9176_/Q _4516_/X _6602_/X _6603_/X _6604_/X VGND VGND VPWR VPWR _6612_/A
+ sky130_fd_sc_hd__a2111o_2
X_4797_ _4797_/A VGND VGND VPWR VPWR _9144_/D sky130_fd_sc_hd__buf_1
X_7585_ wire84/X _7763_/A VGND VGND VPWR VPWR _7585_/Y sky130_fd_sc_hd__nand2_2
XFILLER_119_732 VGND VGND VPWR VPWR sky130_fd_sc_hd__decap_3
XFILLER_21_15 VGND VGND VPWR VPWR sky130_fd_sc_hd__decap_3
XFILLER_20_387 VGND VGND VPWR VPWR sky130_fd_sc_hd__decap_3
X_9324_ clkload9/A _9324_/D load_slew368/X VGND VGND VPWR VPWR _9324_/Q sky130_fd_sc_hd__dfrtp_2
X_6536_ _6529_/B _6367_/Y _6529_/A VGND VGND VPWR VPWR _6537_/C sky130_fd_sc_hd__o21a_2
XFILLER_119_765 VGND VGND VPWR VPWR sky130_fd_sc_hd__decap_3
XFILLER_115_9 VGND VGND VPWR VPWR sky130_fd_sc_hd__decap_3
X_9255_ clkload6/A _9255_/D load_slew376/X VGND VGND VPWR VPWR _9255_/Q sky130_fd_sc_hd__dfrtp_2
XFILLER_118_286 VGND VGND VPWR VPWR sky130_fd_sc_hd__decap_3
X_6467_ _6788_/A _6467_/B VGND VGND VPWR VPWR _6467_/Y sky130_fd_sc_hd__xnor2_2
X_8206_ _9220_/Q VGND VGND VPWR VPWR _8445_/A sky130_fd_sc_hd__inv_2
X_5418_ _5418_/A _5418_/B VGND VGND VPWR VPWR _5418_/Y sky130_fd_sc_hd__xnor2_2
X_6398_ _6441_/A1 _6396_/X _6397_/X VGND VGND VPWR VPWR _6398_/Y sky130_fd_sc_hd__o21ai_2
X_9186_ _9189_/CLK _9186_/D load_slew414/X VGND VGND VPWR VPWR _9186_/Q sky130_fd_sc_hd__dfrtp_2
XFILLER_121_407 VGND VGND VPWR VPWR sky130_fd_sc_hd__decap_3
XFILLER_0_704 VGND VGND VPWR VPWR sky130_fd_sc_hd__decap_3
X_5349_ _5446_/A _7472_/A VGND VGND VPWR VPWR _5349_/X sky130_fd_sc_hd__or2_2
X_8137_ _8137_/A _8137_/B VGND VGND VPWR VPWR _8137_/Y sky130_fd_sc_hd__nand2_2
XFILLER_99_181 VGND VGND VPWR VPWR sky130_fd_sc_hd__fill_2
XFILLER_102_632 VGND VGND VPWR VPWR sky130_fd_sc_hd__decap_3
XFILLER_114_492 VGND VGND VPWR VPWR sky130_fd_sc_hd__decap_3
XFILLER_102_654 VGND VGND VPWR VPWR sky130_fd_sc_hd__decap_3
XPHY_EDGE_ROW_34_Left_165 VGND VGND VPWR VPWR sky130_fd_sc_hd__decap_3
XFILLER_87_343 VGND VGND VPWR VPWR sky130_fd_sc_hd__fill_2
X_8068_ _8170_/B _8068_/B VGND VGND VPWR VPWR _8072_/A sky130_fd_sc_hd__xnor2_2
XFILLER_75_505 VGND VGND VPWR VPWR sky130_fd_sc_hd__decap_3
XFILLER_48_719 VGND VGND VPWR VPWR sky130_fd_sc_hd__fill_1
XFILLER_102_676 VGND VGND VPWR VPWR sky130_fd_sc_hd__fill_1
XFILLER_47_218 VGND VGND VPWR VPWR sky130_fd_sc_hd__decap_3
X_7019_ _7019_/A _7108_/A VGND VGND VPWR VPWR _7020_/A sky130_fd_sc_hd__xnor2_4
XFILLER_75_549 VGND VGND VPWR VPWR sky130_fd_sc_hd__decap_3
XFILLER_28_421 VGND VGND VPWR VPWR sky130_fd_sc_hd__decap_3
XFILLER_56_741 VGND VGND VPWR VPWR sky130_fd_sc_hd__decap_3
XTAP_TAPCELL_ROW_46_909 VGND VPWR sky130_fd_sc_hd__tapvpwrvgnd_1
XFILLER_90_519 VGND VGND VPWR VPWR sky130_fd_sc_hd__decap_3
Xmax_cap46 _7741_/Y VGND VGND VPWR VPWR _7856_/A sky130_fd_sc_hd__buf_2
Xmax_cap57 _8627_/A VGND VGND VPWR VPWR _8681_/A sky130_fd_sc_hd__buf_2
XFILLER_43_413 VGND VGND VPWR VPWR sky130_fd_sc_hd__fill_2
Xmax_cap68 _8416_/A VGND VGND VPWR VPWR _8674_/A sky130_fd_sc_hd__buf_2
Xmax_cap79 _7836_/B VGND VGND VPWR VPWR _8344_/A sky130_fd_sc_hd__buf_2
XTAP_TAPCELL_ROW_26_633 VGND VPWR sky130_fd_sc_hd__tapvpwrvgnd_1
XFILLER_15_148 VGND VGND VPWR VPWR sky130_fd_sc_hd__decap_3
XFILLER_62_44 VGND VGND VPWR VPWR sky130_fd_sc_hd__decap_3
XFILLER_30_107 VGND VGND VPWR VPWR sky130_fd_sc_hd__decap_3
XPHY_EDGE_ROW_43_Left_174 VGND VGND VPWR VPWR sky130_fd_sc_hd__decap_3
XFILLER_62_55 VGND VGND VPWR VPWR sky130_fd_sc_hd__fill_2
XTAP_TAPCELL_ROW_100_1628 VGND VPWR sky130_fd_sc_hd__tapvpwrvgnd_1
XFILLER_24_693 VGND VGND VPWR VPWR sky130_fd_sc_hd__decap_3
XFILLER_11_321 VGND VGND VPWR VPWR sky130_fd_sc_hd__fill_2
XFILLER_11_343 VGND VGND VPWR VPWR sky130_fd_sc_hd__fill_1
Xwire223 wire223/A VGND VGND VPWR VPWR result_out[5] sky130_fd_sc_hd__buf_4
Xwire234 wire234/A VGND VGND VPWR VPWR result_out[0] sky130_fd_sc_hd__buf_4
XFILLER_7_39 VGND VGND VPWR VPWR sky130_fd_sc_hd__decap_3
XFILLER_11_387 VGND VGND VPWR VPWR sky130_fd_sc_hd__decap_3
XFILLER_125_713 VGND VGND VPWR VPWR sky130_fd_sc_hd__decap_3
XFILLER_125_735 VGND VGND VPWR VPWR sky130_fd_sc_hd__decap_3
XFILLER_124_212 VGND VGND VPWR VPWR sky130_fd_sc_hd__decap_3
XFILLER_98_608 VGND VGND VPWR VPWR sky130_fd_sc_hd__decap_3
XFILLER_125_768 VGND VGND VPWR VPWR sky130_fd_sc_hd__decap_3
XFILLER_124_245 VGND VGND VPWR VPWR sky130_fd_sc_hd__decap_3
XFILLER_124_256 VGND VGND VPWR VPWR sky130_fd_sc_hd__decap_3
XFILLER_11_92 VGND VGND VPWR VPWR sky130_fd_sc_hd__decap_3
XFILLER_3_564 VGND VGND VPWR VPWR sky130_fd_sc_hd__fill_1
XPHY_EDGE_ROW_52_Left_183 VGND VGND VPWR VPWR sky130_fd_sc_hd__decap_3
XFILLER_3_575 VGND VGND VPWR VPWR sky130_fd_sc_hd__fill_1
XFILLER_127_81 VGND VGND VPWR VPWR sky130_fd_sc_hd__decap_3
XFILLER_87_74 VGND VGND VPWR VPWR sky130_fd_sc_hd__decap_3
XTAP_TAPCELL_ROW_111_1779 VGND VPWR sky130_fd_sc_hd__tapvpwrvgnd_1
XFILLER_78_365 VGND VGND VPWR VPWR sky130_fd_sc_hd__decap_3
XFILLER_120_451 VGND VGND VPWR VPWR sky130_fd_sc_hd__decap_3
XFILLER_93_335 VGND VGND VPWR VPWR sky130_fd_sc_hd__fill_1
XFILLER_93_357 VGND VGND VPWR VPWR sky130_fd_sc_hd__fill_2
XFILLER_74_560 VGND VGND VPWR VPWR sky130_fd_sc_hd__decap_3
XFILLER_74_582 VGND VGND VPWR VPWR sky130_fd_sc_hd__decap_3
XFILLER_34_424 VGND VGND VPWR VPWR sky130_fd_sc_hd__decap_3
XFILLER_19_498 VGND VGND VPWR VPWR sky130_fd_sc_hd__fill_1
XFILLER_62_755 VGND VGND VPWR VPWR sky130_fd_sc_hd__fill_1
XPHY_EDGE_ROW_61_Left_192 VGND VGND VPWR VPWR sky130_fd_sc_hd__decap_3
XFILLER_22_619 VGND VGND VPWR VPWR sky130_fd_sc_hd__decap_3
XFILLER_61_287 VGND VGND VPWR VPWR sky130_fd_sc_hd__fill_1
XFILLER_15_682 VGND VGND VPWR VPWR sky130_fd_sc_hd__decap_3
X_4720_ _4720_/A VGND VGND VPWR VPWR _9107_/D sky130_fd_sc_hd__buf_1
XFILLER_14_170 VGND VGND VPWR VPWR sky130_fd_sc_hd__fill_2
X_4651_ _4651_/A VGND VGND VPWR VPWR _9075_/D sky130_fd_sc_hd__buf_1
X_4582_ _4582_/A VGND VGND VPWR VPWR _9042_/D sky130_fd_sc_hd__buf_1
X_7370_ _7370_/A _7370_/B VGND VGND VPWR VPWR _7372_/A sky130_fd_sc_hd__xnor2_2
XTAP_TAPCELL_ROW_77_1321 VGND VPWR sky130_fd_sc_hd__tapvpwrvgnd_1
XFILLER_116_713 VGND VGND VPWR VPWR sky130_fd_sc_hd__fill_1
XFILLER_128_573 VGND VGND VPWR VPWR sky130_fd_sc_hd__decap_3
X_6321_ _6563_/A _6321_/B VGND VGND VPWR VPWR _6322_/B sky130_fd_sc_hd__xnor2_2
Xhold804 _4882_/X VGND VGND VPWR VPWR _9181_/D sky130_fd_sc_hd__dlygate4sd3_1
Xhold815 _4904_/X VGND VGND VPWR VPWR _9192_/D sky130_fd_sc_hd__dlygate4sd3_1
XFILLER_128_595 VGND VGND VPWR VPWR sky130_fd_sc_hd__decap_3
Xhold826 _4569_/X VGND VGND VPWR VPWR _4570_/A sky130_fd_sc_hd__dlygate4sd3_1
Xhold837 _9022_/Q VGND VGND VPWR VPWR hold837/X sky130_fd_sc_hd__dlygate4sd3_1
XFILLER_116_757 VGND VGND VPWR VPWR sky130_fd_sc_hd__decap_3
Xhold848 _9277_/Q VGND VGND VPWR VPWR hold848/X sky130_fd_sc_hd__dlygate4sd3_1
X_6252_ _9207_/Q _6253_/B _5986_/Y VGND VGND VPWR VPWR _6252_/X sky130_fd_sc_hd__a21o_2
X_9040_ clkload9/A _9040_/D load_slew368/X VGND VGND VPWR VPWR _9040_/Q sky130_fd_sc_hd__dfrtp_2
XFILLER_89_608 VGND VGND VPWR VPWR sky130_fd_sc_hd__decap_3
XFILLER_107_18 VGND VGND VPWR VPWR sky130_fd_sc_hd__decap_3
Xhold859 _8917_/X VGND VGND VPWR VPWR _8918_/A sky130_fd_sc_hd__dlygate4sd3_1
XFILLER_103_418 VGND VGND VPWR VPWR sky130_fd_sc_hd__decap_3
X_5203_ _5350_/B _5142_/Y _5143_/X _8175_/A VGND VGND VPWR VPWR _5203_/Y sky130_fd_sc_hd__a31oi_4
XFILLER_88_129 VGND VGND VPWR VPWR sky130_fd_sc_hd__fill_2
XFILLER_130_215 VGND VGND VPWR VPWR sky130_fd_sc_hd__decap_3
X_6183_ _6174_/X _6175_/X _6169_/Y _6170_/X VGND VGND VPWR VPWR _6183_/X sky130_fd_sc_hd__a22o_2
XFILLER_130_237 VGND VGND VPWR VPWR sky130_fd_sc_hd__decap_3
X_5134_ _9199_/Q _5134_/B VGND VGND VPWR VPWR _5135_/B sky130_fd_sc_hd__xor2_2
XFILLER_130_259 VGND VGND VPWR VPWR sky130_fd_sc_hd__decap_3
XFILLER_69_365 VGND VGND VPWR VPWR sky130_fd_sc_hd__fill_1
XFILLER_57_505 VGND VGND VPWR VPWR sky130_fd_sc_hd__decap_3
XFILLER_97_685 VGND VGND VPWR VPWR sky130_fd_sc_hd__decap_3
XFILLER_84_302 VGND VGND VPWR VPWR sky130_fd_sc_hd__decap_3
XTAP_TAPCELL_ROW_4_339 VGND VPWR sky130_fd_sc_hd__tapvpwrvgnd_1
XFILLER_57_538 VGND VGND VPWR VPWR sky130_fd_sc_hd__decap_3
X_5065_ _5065_/A VGND VGND VPWR VPWR _5065_/X sky130_fd_sc_hd__buf_4
XFILLER_111_495 VGND VGND VPWR VPWR sky130_fd_sc_hd__decap_3
XFILLER_38_730 VGND VGND VPWR VPWR sky130_fd_sc_hd__decap_3
XFILLER_123_39 VGND VGND VPWR VPWR sky130_fd_sc_hd__decap_3
XFILLER_38_752 VGND VGND VPWR VPWR sky130_fd_sc_hd__decap_3
XFILLER_38_763 VGND VGND VPWR VPWR sky130_fd_sc_hd__decap_3
XTAP_TAPCELL_ROW_88_1472 VGND VPWR sky130_fd_sc_hd__tapvpwrvgnd_1
XFILLER_16_15 VGND VGND VPWR VPWR sky130_fd_sc_hd__decap_3
X_8824_ _8824_/A VGND VGND VPWR VPWR _9256_/D sky130_fd_sc_hd__buf_1
XFILLER_37_284 VGND VGND VPWR VPWR sky130_fd_sc_hd__decap_3
XFILLER_25_446 VGND VGND VPWR VPWR sky130_fd_sc_hd__fill_2
XFILLER_16_59 VGND VGND VPWR VPWR sky130_fd_sc_hd__decap_3
X_8755_ _8755_/A _8755_/B VGND VGND VPWR VPWR _8755_/Y sky130_fd_sc_hd__nand2_2
X_5967_ _5967_/A _5967_/B VGND VGND VPWR VPWR _5967_/Y sky130_fd_sc_hd__xnor2_2
XFILLER_80_585 VGND VGND VPWR VPWR sky130_fd_sc_hd__decap_3
XFILLER_12_107 VGND VGND VPWR VPWR sky130_fd_sc_hd__decap_3
XFILLER_80_596 VGND VGND VPWR VPWR sky130_fd_sc_hd__decap_3
X_7706_ _7692_/A _7703_/X _7704_/Y _7705_/X VGND VGND VPWR VPWR _7706_/X sky130_fd_sc_hd__o211a_2
X_4918_ _4918_/A VGND VGND VPWR VPWR _7480_/C sky130_fd_sc_hd__clkbuf_2
XFILLER_21_630 VGND VGND VPWR VPWR sky130_fd_sc_hd__decap_3
X_8686_ _8686_/A _8706_/A VGND VGND VPWR VPWR _8686_/Y sky130_fd_sc_hd__xnor2_2
Xclkbuf_leaf_32_clk clkload2/A VGND VGND VPWR VPWR _9189_/CLK sky130_fd_sc_hd__clkbuf_8
X_5898_ _7114_/B _7773_/A _5896_/X _5897_/X VGND VGND VPWR VPWR _5899_/B sky130_fd_sc_hd__a31o_2
XTAP_TAPCELL_ROW_51_967 VGND VPWR sky130_fd_sc_hd__tapvpwrvgnd_1
XFILLER_32_25 VGND VGND VPWR VPWR sky130_fd_sc_hd__decap_3
X_7637_ _7636_/B _7636_/C _7636_/A VGND VGND VPWR VPWR _7638_/B sky130_fd_sc_hd__a21oi_2
XFILLER_32_47 VGND VGND VPWR VPWR sky130_fd_sc_hd__decap_3
X_4849_ _9169_/Q hold910/X _4861_/S VGND VGND VPWR VPWR _4849_/X sky130_fd_sc_hd__mux2_2
XFILLER_21_685 VGND VGND VPWR VPWR sky130_fd_sc_hd__decap_3
XFILLER_20_162 VGND VGND VPWR VPWR sky130_fd_sc_hd__decap_3
XFILLER_20_195 VGND VGND VPWR VPWR sky130_fd_sc_hd__fill_1
XFILLER_119_551 VGND VGND VPWR VPWR sky130_fd_sc_hd__decap_3
X_7568_ _7568_/A _7568_/B VGND VGND VPWR VPWR _7623_/A sky130_fd_sc_hd__nand2_2
XFILLER_107_713 VGND VGND VPWR VPWR sky130_fd_sc_hd__fill_1
XFILLER_4_306 VGND VGND VPWR VPWR sky130_fd_sc_hd__fill_2
X_9307_ _9339_/CLK _9307_/D load_slew386/X VGND VGND VPWR VPWR _9307_/Q sky130_fd_sc_hd__dfrtp_2
XFILLER_113_6 VGND VGND VPWR VPWR sky130_fd_sc_hd__decap_3
XFILLER_107_735 VGND VGND VPWR VPWR sky130_fd_sc_hd__decap_3
X_6519_ _6522_/A _6519_/B _6519_/C VGND VGND VPWR VPWR _6523_/B sky130_fd_sc_hd__and3_2
X_7499_ _7387_/A _7382_/B _7496_/X _7498_/X VGND VGND VPWR VPWR _7502_/B sky130_fd_sc_hd__a22o_2
XFILLER_106_234 VGND VGND VPWR VPWR sky130_fd_sc_hd__decap_3
X_9238_ clkload7/A _9238_/D fanout375/X VGND VGND VPWR VPWR _9238_/Q sky130_fd_sc_hd__dfrtp_2
XFILLER_122_727 VGND VGND VPWR VPWR sky130_fd_sc_hd__decap_3
XFILLER_106_289 VGND VGND VPWR VPWR sky130_fd_sc_hd__decap_3
XFILLER_0_523 VGND VGND VPWR VPWR sky130_fd_sc_hd__decap_3
X_9169_ _9293_/CLK _9169_/D fanout381/X VGND VGND VPWR VPWR _9169_/Q sky130_fd_sc_hd__dfrtp_2
XFILLER_0_545 VGND VGND VPWR VPWR sky130_fd_sc_hd__decap_3
XFILLER_87_140 VGND VGND VPWR VPWR sky130_fd_sc_hd__decap_3
XFILLER_0_567 VGND VGND VPWR VPWR sky130_fd_sc_hd__decap_3
XFILLER_130_760 VGND VGND VPWR VPWR sky130_fd_sc_hd__decap_3
XFILLER_88_685 VGND VGND VPWR VPWR sky130_fd_sc_hd__decap_3
XFILLER_57_33 VGND VGND VPWR VPWR sky130_fd_sc_hd__decap_3
XFILLER_0_589 VGND VGND VPWR VPWR sky130_fd_sc_hd__decap_3
XFILLER_102_473 VGND VGND VPWR VPWR sky130_fd_sc_hd__decap_3
XFILLER_48_527 VGND VGND VPWR VPWR sky130_fd_sc_hd__decap_3
XFILLER_87_184 VGND VGND VPWR VPWR sky130_fd_sc_hd__decap_3
XFILLER_75_324 VGND VGND VPWR VPWR sky130_fd_sc_hd__decap_3
XFILLER_29_741 VGND VGND VPWR VPWR sky130_fd_sc_hd__fill_1
XFILLER_29_763 VGND VGND VPWR VPWR sky130_fd_sc_hd__decap_3
XFILLER_63_519 VGND VGND VPWR VPWR sky130_fd_sc_hd__fill_1
XFILLER_28_251 VGND VGND VPWR VPWR sky130_fd_sc_hd__fill_1
XFILLER_90_327 VGND VGND VPWR VPWR sky130_fd_sc_hd__fill_2
XFILLER_56_582 VGND VGND VPWR VPWR sky130_fd_sc_hd__decap_3
XFILLER_71_530 VGND VGND VPWR VPWR sky130_fd_sc_hd__decap_3
XTAP_TAPCELL_ROW_61_1100 VGND VPWR sky130_fd_sc_hd__tapvpwrvgnd_1
XTAP_TAPCELL_ROW_61_1111 VGND VPWR sky130_fd_sc_hd__tapvpwrvgnd_1
Xclkbuf_leaf_23_clk clkload2/A VGND VGND VPWR VPWR _9228_/CLK sky130_fd_sc_hd__clkbuf_8
XFILLER_12_641 VGND VGND VPWR VPWR sky130_fd_sc_hd__decap_3
XFILLER_129_337 VGND VGND VPWR VPWR sky130_fd_sc_hd__decap_3
XFILLER_8_645 VGND VGND VPWR VPWR sky130_fd_sc_hd__decap_3
XFILLER_8_656 VGND VGND VPWR VPWR sky130_fd_sc_hd__decap_3
XFILLER_7_122 VGND VGND VPWR VPWR sky130_fd_sc_hd__decap_3
XFILLER_7_177 VGND VGND VPWR VPWR sky130_fd_sc_hd__decap_3
XTAP_TAPCELL_ROW_113_1808 VGND VPWR sky130_fd_sc_hd__tapvpwrvgnd_1
XTAP_TAPCELL_ROW_59_1073 VGND VPWR sky130_fd_sc_hd__tapvpwrvgnd_1
XTAP_TAPCELL_ROW_59_1084 VGND VPWR sky130_fd_sc_hd__tapvpwrvgnd_1
XFILLER_125_576 VGND VGND VPWR VPWR sky130_fd_sc_hd__decap_3
XTAP_TAPCELL_ROW_72_1251 VGND VPWR sky130_fd_sc_hd__tapvpwrvgnd_1
XFILLER_79_641 VGND VGND VPWR VPWR sky130_fd_sc_hd__decap_3
XFILLER_39_505 VGND VGND VPWR VPWR sky130_fd_sc_hd__decap_3
XFILLER_121_771 VGND VGND VPWR VPWR sky130_fd_sc_hd__decap_3
XFILLER_78_162 VGND VGND VPWR VPWR sky130_fd_sc_hd__fill_1
XFILLER_66_302 VGND VGND VPWR VPWR sky130_fd_sc_hd__decap_3
XFILLER_66_324 VGND VGND VPWR VPWR sky130_fd_sc_hd__decap_3
XFILLER_120_270 VGND VGND VPWR VPWR sky130_fd_sc_hd__decap_3
XFILLER_120_292 VGND VGND VPWR VPWR sky130_fd_sc_hd__decap_3
XFILLER_66_357 VGND VGND VPWR VPWR sky130_fd_sc_hd__decap_3
XFILLER_66_368 VGND VGND VPWR VPWR sky130_fd_sc_hd__decap_3
XFILLER_94_699 VGND VGND VPWR VPWR sky130_fd_sc_hd__fill_1
XFILLER_93_165 VGND VGND VPWR VPWR sky130_fd_sc_hd__decap_3
XFILLER_19_251 VGND VGND VPWR VPWR sky130_fd_sc_hd__decap_3
XFILLER_19_262 VGND VGND VPWR VPWR sky130_fd_sc_hd__decap_3
XFILLER_47_582 VGND VGND VPWR VPWR sky130_fd_sc_hd__decap_3
XFILLER_19_284 VGND VGND VPWR VPWR sky130_fd_sc_hd__decap_3
XFILLER_34_210 VGND VGND VPWR VPWR sky130_fd_sc_hd__decap_3
X_6870_ _6870_/A _7186_/A VGND VGND VPWR VPWR _6872_/A sky130_fd_sc_hd__xnor2_2
XFILLER_62_530 VGND VGND VPWR VPWR sky130_fd_sc_hd__fill_2
XTAP_TAPCELL_ROW_124_1959 VGND VPWR sky130_fd_sc_hd__tapvpwrvgnd_1
X_5821_ _5821_/A VGND VGND VPWR VPWR _5907_/A sky130_fd_sc_hd__inv_2
XFILLER_62_563 VGND VGND VPWR VPWR sky130_fd_sc_hd__decap_3
XFILLER_50_714 VGND VGND VPWR VPWR sky130_fd_sc_hd__decap_3
XFILLER_22_405 VGND VGND VPWR VPWR sky130_fd_sc_hd__decap_3
X_8540_ _8503_/A _8502_/B _8502_/A VGND VGND VPWR VPWR _8540_/X sky130_fd_sc_hd__a21o_2
X_5752_ _5752_/A _5752_/B VGND VGND VPWR VPWR _5973_/A sky130_fd_sc_hd__xnor2_2
Xclkbuf_leaf_14_clk clkbuf_leaf_9_clk/A VGND VGND VPWR VPWR _9344_/CLK sky130_fd_sc_hd__clkbuf_8
X_4703_ _4703_/A VGND VGND VPWR VPWR _9099_/D sky130_fd_sc_hd__buf_1
X_8471_ _8467_/Y _8469_/Y _8470_/X VGND VGND VPWR VPWR _8503_/A sky130_fd_sc_hd__a21oi_2
X_5683_ _5561_/A _5559_/Y _5560_/A VGND VGND VPWR VPWR _5685_/B sky130_fd_sc_hd__a21oi_2
XFILLER_30_471 VGND VGND VPWR VPWR sky130_fd_sc_hd__decap_3
X_7422_ _7951_/A _7422_/B VGND VGND VPWR VPWR _7426_/A sky130_fd_sc_hd__nor2_2
XFILLER_8_71 VGND VGND VPWR VPWR sky130_fd_sc_hd__fill_1
X_4634_ _9067_/Q _4634_/A1 _4650_/S VGND VGND VPWR VPWR _4634_/X sky130_fd_sc_hd__mux2_2
XFILLER_8_82 VGND VGND VPWR VPWR sky130_fd_sc_hd__fill_2
X_4565_ _4565_/A VGND VGND VPWR VPWR _9034_/D sky130_fd_sc_hd__buf_1
X_7353_ _7353_/A _7353_/B _7353_/C VGND VGND VPWR VPWR _7355_/A sky130_fd_sc_hd__nand3_2
XTAP_TAPCELL_ROW_9_409 VGND VPWR sky130_fd_sc_hd__tapvpwrvgnd_1
X_6304_ _6304_/A _7117_/A VGND VGND VPWR VPWR _6583_/A sky130_fd_sc_hd__nor2_2
XFILLER_116_565 VGND VGND VPWR VPWR sky130_fd_sc_hd__fill_1
XFILLER_104_716 VGND VGND VPWR VPWR sky130_fd_sc_hd__decap_3
X_7284_ _7272_/X _7142_/C _7285_/C VGND VGND VPWR VPWR _7287_/A sky130_fd_sc_hd__o21a_2
XFILLER_89_416 VGND VGND VPWR VPWR sky130_fd_sc_hd__decap_3
XFILLER_116_587 VGND VGND VPWR VPWR sky130_fd_sc_hd__fill_1
XFILLER_104_738 VGND VGND VPWR VPWR sky130_fd_sc_hd__fill_2
X_9023_ _9135_/CLK _9023_/D load_slew384/X VGND VGND VPWR VPWR _9023_/Q sky130_fd_sc_hd__dfrtp_2
XPHY_EDGE_ROW_4_Right_4 VGND VGND VPWR VPWR sky130_fd_sc_hd__decap_3
XFILLER_89_438 VGND VGND VPWR VPWR sky130_fd_sc_hd__decap_3
X_6235_ _9030_/Q _6756_/C VGND VGND VPWR VPWR _6235_/Y sky130_fd_sc_hd__nand2_2
XFILLER_89_449 VGND VGND VPWR VPWR sky130_fd_sc_hd__decap_3
XFILLER_103_259 VGND VGND VPWR VPWR sky130_fd_sc_hd__decap_3
X_6166_ _6166_/A _7417_/A VGND VGND VPWR VPWR _6172_/A sky130_fd_sc_hd__nand2_2
X_5117_ _6232_/C _6231_/B _6342_/A _5266_/S VGND VGND VPWR VPWR _5117_/Y sky130_fd_sc_hd__nor4b_4
X_6097_ _5219_/Y _6095_/X _6096_/Y VGND VGND VPWR VPWR _6097_/X sky130_fd_sc_hd__a21o_2
XFILLER_57_335 VGND VGND VPWR VPWR sky130_fd_sc_hd__fill_1
XFILLER_111_281 VGND VGND VPWR VPWR sky130_fd_sc_hd__decap_3
XFILLER_57_346 VGND VGND VPWR VPWR sky130_fd_sc_hd__fill_1
XFILLER_85_666 VGND VGND VPWR VPWR sky130_fd_sc_hd__decap_3
XFILLER_45_508 VGND VGND VPWR VPWR sky130_fd_sc_hd__decap_3
X_5048_ _9197_/Q _5048_/B _5048_/C VGND VGND VPWR VPWR _5048_/X sky130_fd_sc_hd__or3_2
XFILLER_27_47 VGND VGND VPWR VPWR sky130_fd_sc_hd__decap_3
XFILLER_26_722 VGND VGND VPWR VPWR sky130_fd_sc_hd__decap_3
XFILLER_26_744 VGND VGND VPWR VPWR sky130_fd_sc_hd__decap_3
XFILLER_26_766 VGND VGND VPWR VPWR sky130_fd_sc_hd__decap_3
X_8807_ _8807_/A VGND VGND VPWR VPWR _9248_/D sky130_fd_sc_hd__buf_1
XFILLER_41_703 VGND VGND VPWR VPWR sky130_fd_sc_hd__decap_3
XTAP_TAPCELL_ROW_36_761 VGND VPWR sky130_fd_sc_hd__tapvpwrvgnd_1
XTAP_TAPCELL_ROW_36_772 VGND VPWR sky130_fd_sc_hd__tapvpwrvgnd_1
XFILLER_25_276 VGND VGND VPWR VPWR sky130_fd_sc_hd__decap_3
X_6999_ _7056_/A _7056_/B VGND VGND VPWR VPWR _7000_/B sky130_fd_sc_hd__xor2_2
XFILLER_40_213 VGND VGND VPWR VPWR sky130_fd_sc_hd__decap_3
X_8738_ _8755_/A VGND VGND VPWR VPWR _8741_/A sky130_fd_sc_hd__inv_2
XFILLER_41_758 VGND VGND VPWR VPWR sky130_fd_sc_hd__fill_1
XFILLER_43_57 VGND VGND VPWR VPWR sky130_fd_sc_hd__decap_3
XFILLER_40_268 VGND VGND VPWR VPWR sky130_fd_sc_hd__fill_1
X_8669_ _8753_/A _8669_/B VGND VGND VPWR VPWR _8716_/B sky130_fd_sc_hd__xnor2_2
XFILLER_21_471 VGND VGND VPWR VPWR sky130_fd_sc_hd__decap_3
XFILLER_126_307 VGND VGND VPWR VPWR sky130_fd_sc_hd__fill_1
XFILLER_4_103 VGND VGND VPWR VPWR sky130_fd_sc_hd__decap_3
XFILLER_126_329 VGND VGND VPWR VPWR sky130_fd_sc_hd__decap_3
XFILLER_111_3 VGND VGND VPWR VPWR sky130_fd_sc_hd__decap_3
XFILLER_5_659 VGND VGND VPWR VPWR sky130_fd_sc_hd__decap_3
XFILLER_107_576 VGND VGND VPWR VPWR sky130_fd_sc_hd__decap_3
XFILLER_4_18 VGND VGND VPWR VPWR sky130_fd_sc_hd__decap_3
XFILLER_108_50 VGND VGND VPWR VPWR sky130_fd_sc_hd__fill_2
XFILLER_4_29 VGND VGND VPWR VPWR sky130_fd_sc_hd__decap_3
XFILLER_122_513 VGND VGND VPWR VPWR sky130_fd_sc_hd__decap_3
XFILLER_122_557 VGND VGND VPWR VPWR sky130_fd_sc_hd__decap_3
XFILLER_0_331 VGND VGND VPWR VPWR sky130_fd_sc_hd__decap_3
XTAP_TAPCELL_ROW_128_2004 VGND VPWR sky130_fd_sc_hd__tapvpwrvgnd_1
XFILLER_122_579 VGND VGND VPWR VPWR sky130_fd_sc_hd__fill_2
XTAP_TAPCELL_ROW_128_2015 VGND VPWR sky130_fd_sc_hd__tapvpwrvgnd_1
XFILLER_76_611 VGND VGND VPWR VPWR sky130_fd_sc_hd__fill_1
XFILLER_88_471 VGND VGND VPWR VPWR sky130_fd_sc_hd__decap_3
XFILLER_76_633 VGND VGND VPWR VPWR sky130_fd_sc_hd__decap_3
XFILLER_48_324 VGND VGND VPWR VPWR sky130_fd_sc_hd__fill_2
XFILLER_102_292 VGND VGND VPWR VPWR sky130_fd_sc_hd__decap_3
XFILLER_75_143 VGND VGND VPWR VPWR sky130_fd_sc_hd__decap_3
XFILLER_36_508 VGND VGND VPWR VPWR sky130_fd_sc_hd__decap_3
XFILLER_124_71 VGND VGND VPWR VPWR sky130_fd_sc_hd__decap_3
XFILLER_91_603 VGND VGND VPWR VPWR sky130_fd_sc_hd__decap_3
XFILLER_76_677 VGND VGND VPWR VPWR sky130_fd_sc_hd__fill_2
XFILLER_91_636 VGND VGND VPWR VPWR sky130_fd_sc_hd__decap_3
XFILLER_17_722 VGND VGND VPWR VPWR sky130_fd_sc_hd__decap_3
XFILLER_63_349 VGND VGND VPWR VPWR sky130_fd_sc_hd__fill_2
XFILLER_17_744 VGND VGND VPWR VPWR sky130_fd_sc_hd__decap_3
XFILLER_44_530 VGND VGND VPWR VPWR sky130_fd_sc_hd__fill_2
XFILLER_16_232 VGND VGND VPWR VPWR sky130_fd_sc_hd__decap_3
XFILLER_16_265 VGND VGND VPWR VPWR sky130_fd_sc_hd__decap_3
XFILLER_44_585 VGND VGND VPWR VPWR sky130_fd_sc_hd__decap_3
XFILLER_31_213 VGND VGND VPWR VPWR sky130_fd_sc_hd__decap_3
XFILLER_16_287 VGND VGND VPWR VPWR sky130_fd_sc_hd__decap_3
XFILLER_31_268 VGND VGND VPWR VPWR sky130_fd_sc_hd__decap_3
XTAP_TAPCELL_ROW_14_466 VGND VPWR sky130_fd_sc_hd__tapvpwrvgnd_1
XTAP_TAPCELL_ROW_14_477 VGND VPWR sky130_fd_sc_hd__tapvpwrvgnd_1
XFILLER_129_134 VGND VGND VPWR VPWR sky130_fd_sc_hd__decap_3
XFILLER_129_167 VGND VGND VPWR VPWR sky130_fd_sc_hd__fill_1
XFILLER_129_178 VGND VGND VPWR VPWR sky130_fd_sc_hd__decap_3
XFILLER_125_340 VGND VGND VPWR VPWR sky130_fd_sc_hd__decap_3
XFILLER_99_725 VGND VGND VPWR VPWR sky130_fd_sc_hd__decap_3
XFILLER_125_362 VGND VGND VPWR VPWR sky130_fd_sc_hd__decap_3
XFILLER_4_670 VGND VGND VPWR VPWR sky130_fd_sc_hd__decap_3
XFILLER_99_747 VGND VGND VPWR VPWR sky130_fd_sc_hd__fill_1
XFILLER_98_224 VGND VGND VPWR VPWR sky130_fd_sc_hd__decap_3
XFILLER_113_557 VGND VGND VPWR VPWR sky130_fd_sc_hd__decap_3
XFILLER_113_568 VGND VGND VPWR VPWR sky130_fd_sc_hd__decap_3
XFILLER_101_719 VGND VGND VPWR VPWR sky130_fd_sc_hd__decap_3
X_6020_ _6177_/B _7050_/A _6017_/Y _5041_/B _7604_/A VGND VGND VPWR VPWR _6020_/X
+ sky130_fd_sc_hd__a2111o_2
Xclkbuf_leaf_3_clk clkload0/A VGND VGND VPWR VPWR clkload4/A sky130_fd_sc_hd__clkbuf_8
XFILLER_94_430 VGND VGND VPWR VPWR sky130_fd_sc_hd__decap_3
XFILLER_82_614 VGND VGND VPWR VPWR sky130_fd_sc_hd__decap_3
XFILLER_67_688 VGND VGND VPWR VPWR sky130_fd_sc_hd__decap_3
X_7971_ _8066_/B _7969_/X _7970_/X _7794_/A VGND VGND VPWR VPWR _7971_/X sky130_fd_sc_hd__a22o_2
X_6922_ _6920_/X _6662_/X _6921_/X VGND VGND VPWR VPWR _7279_/A sky130_fd_sc_hd__o21ai_4
XFILLER_54_349 VGND VGND VPWR VPWR sky130_fd_sc_hd__decap_3
XTAP_TAPCELL_ROW_85_1431 VGND VPWR sky130_fd_sc_hd__tapvpwrvgnd_1
XFILLER_82_669 VGND VGND VPWR VPWR sky130_fd_sc_hd__decap_3
XFILLER_47_390 VGND VGND VPWR VPWR sky130_fd_sc_hd__fill_2
XFILLER_120_18 VGND VGND VPWR VPWR sky130_fd_sc_hd__decap_3
X_6853_ _6853_/A VGND VGND VPWR VPWR _9211_/D sky130_fd_sc_hd__buf_1
XFILLER_120_29 VGND VGND VPWR VPWR sky130_fd_sc_hd__decap_3
XFILLER_62_371 VGND VGND VPWR VPWR sky130_fd_sc_hd__decap_3
XFILLER_35_585 VGND VGND VPWR VPWR sky130_fd_sc_hd__decap_3
XFILLER_23_725 VGND VGND VPWR VPWR sky130_fd_sc_hd__decap_3
XFILLER_23_747 VGND VGND VPWR VPWR sky130_fd_sc_hd__decap_3
X_5804_ _5804_/A _5804_/B _6817_/A VGND VGND VPWR VPWR _5804_/X sky130_fd_sc_hd__and3_2
XFILLER_22_224 VGND VGND VPWR VPWR sky130_fd_sc_hd__decap_3
XTAP_TAPCELL_ROW_33_731 VGND VPWR sky130_fd_sc_hd__tapvpwrvgnd_1
X_6784_ _6509_/A _6509_/B _6506_/Y _6394_/A VGND VGND VPWR VPWR _6784_/X sky130_fd_sc_hd__a31o_2
XFILLER_50_555 VGND VGND VPWR VPWR sky130_fd_sc_hd__decap_3
XFILLER_22_246 VGND VGND VPWR VPWR sky130_fd_sc_hd__decap_3
X_8523_ _8562_/A wire66/X VGND VGND VPWR VPWR _8523_/Y sky130_fd_sc_hd__nand2_2
XFILLER_10_419 VGND VGND VPWR VPWR sky130_fd_sc_hd__fill_1
X_5735_ _5735_/A _5735_/B _5735_/C _5735_/D VGND VGND VPWR VPWR _5735_/Y sky130_fd_sc_hd__nor4_4
XFILLER_22_279 VGND VGND VPWR VPWR sky130_fd_sc_hd__decap_3
XFILLER_13_27 VGND VGND VPWR VPWR sky130_fd_sc_hd__decap_3
XFILLER_129_27 VGND VGND VPWR VPWR sky130_fd_sc_hd__decap_3
X_8454_ _8454_/A _8454_/B VGND VGND VPWR VPWR _8463_/B sky130_fd_sc_hd__xnor2_2
X_5666_ _5950_/B _5936_/A VGND VGND VPWR VPWR _5668_/A sky130_fd_sc_hd__xor2_2
X_7405_ _7590_/A _7342_/A _7342_/B _7413_/B VGND VGND VPWR VPWR _7405_/X sky130_fd_sc_hd__a31o_2
X_4617_ hold876/X _4617_/A1 _4629_/S VGND VGND VPWR VPWR _4618_/A sky130_fd_sc_hd__mux2_2
X_8385_ _8385_/A _8385_/B VGND VGND VPWR VPWR _8386_/A sky130_fd_sc_hd__nor2_2
X_5597_ _5426_/A _5425_/A _5425_/B VGND VGND VPWR VPWR _5597_/X sky130_fd_sc_hd__o21a_2
XTAP_TAPCELL_ROW_96_1571 VGND VPWR sky130_fd_sc_hd__tapvpwrvgnd_1
XTAP_TAPCELL_ROW_96_1582 VGND VPWR sky130_fd_sc_hd__tapvpwrvgnd_1
X_7336_ _7590_/A _7336_/B VGND VGND VPWR VPWR _7344_/C sky130_fd_sc_hd__xnor2_2
XFILLER_2_607 VGND VGND VPWR VPWR sky130_fd_sc_hd__decap_3
X_4548_ hold926/X _9003_/A0 _4566_/S VGND VGND VPWR VPWR _4549_/A sky130_fd_sc_hd__mux2_2
Xmax_cap150 wire151/X VGND VGND VPWR VPWR _6546_/A2 sky130_fd_sc_hd__clkbuf_2
Xmax_cap161 _5071_/Y VGND VGND VPWR VPWR _6976_/C sky130_fd_sc_hd__buf_4
XFILLER_1_106 VGND VGND VPWR VPWR sky130_fd_sc_hd__decap_3
XFILLER_8_9 VGND VGND VPWR VPWR sky130_fd_sc_hd__decap_3
Xmax_cap183 _6703_/A VGND VGND VPWR VPWR _8242_/A sky130_fd_sc_hd__buf_2
XFILLER_1_128 VGND VGND VPWR VPWR sky130_fd_sc_hd__decap_3
X_7267_ _7263_/B _7259_/X _7265_/Y _7263_/A VGND VGND VPWR VPWR _7267_/X sky130_fd_sc_hd__o22a_2
Xmax_cap194 _5469_/B VGND VGND VPWR VPWR _6336_/B sky130_fd_sc_hd__buf_2
XPHY_EDGE_ROW_8_Left_139 VGND VGND VPWR VPWR sky130_fd_sc_hd__decap_3
X_9006_ _9006_/A VGND VGND VPWR VPWR _9343_/D sky130_fd_sc_hd__buf_1
XFILLER_89_268 VGND VGND VPWR VPWR sky130_fd_sc_hd__fill_2
X_6218_ _6218_/A _6528_/B _6218_/C _6218_/D VGND VGND VPWR VPWR _6220_/B sky130_fd_sc_hd__and4_2
XFILLER_89_279 VGND VGND VPWR VPWR sky130_fd_sc_hd__fill_1
X_7198_ _6886_/A _7877_/A _7196_/B VGND VGND VPWR VPWR _7198_/X sky130_fd_sc_hd__o21a_2
XFILLER_58_633 VGND VGND VPWR VPWR sky130_fd_sc_hd__decap_3
X_6149_ _6149_/A _6149_/B VGND VGND VPWR VPWR _6522_/A sky130_fd_sc_hd__or2_2
Xhold1120 _9036_/Q VGND VGND VPWR VPWR _4602_/A1 sky130_fd_sc_hd__dlygate4sd3_1
XFILLER_57_121 VGND VGND VPWR VPWR sky130_fd_sc_hd__decap_3
XFILLER_85_441 VGND VGND VPWR VPWR sky130_fd_sc_hd__decap_3
Xhold1131 _9273_/Q VGND VGND VPWR VPWR _8892_/A1 sky130_fd_sc_hd__dlygate4sd3_1
XFILLER_85_452 VGND VGND VPWR VPWR sky130_fd_sc_hd__decap_3
XFILLER_57_143 VGND VGND VPWR VPWR sky130_fd_sc_hd__decap_3
Xhold1142 _8974_/X VGND VGND VPWR VPWR _8975_/A sky130_fd_sc_hd__dlygate4sd3_1
XFILLER_58_677 VGND VGND VPWR VPWR sky130_fd_sc_hd__decap_3
Xhold1153 _9319_/Q VGND VGND VPWR VPWR _8988_/A1 sky130_fd_sc_hd__dlygate4sd3_1
XFILLER_85_463 VGND VGND VPWR VPWR sky130_fd_sc_hd__decap_3
Xhold1164 _9101_/Q VGND VGND VPWR VPWR _4740_/A1 sky130_fd_sc_hd__dlygate4sd3_1
XFILLER_85_474 VGND VGND VPWR VPWR sky130_fd_sc_hd__decap_3
XFILLER_45_305 VGND VGND VPWR VPWR sky130_fd_sc_hd__decap_3
Xhold1175 _4648_/X VGND VGND VPWR VPWR _4649_/A sky130_fd_sc_hd__dlygate4sd3_1
XPHY_EDGE_ROW_79_Right_79 VGND VGND VPWR VPWR sky130_fd_sc_hd__decap_3
XFILLER_73_636 VGND VGND VPWR VPWR sky130_fd_sc_hd__decap_3
Xhold1186 _9094_/Q VGND VGND VPWR VPWR _4725_/A1 sky130_fd_sc_hd__dlygate4sd3_1
Xhold1197 _9031_/Q VGND VGND VPWR VPWR _4592_/A1 sky130_fd_sc_hd__dlygate4sd3_1
XFILLER_72_135 VGND VGND VPWR VPWR sky130_fd_sc_hd__decap_3
XFILLER_73_669 VGND VGND VPWR VPWR sky130_fd_sc_hd__decap_3
XFILLER_53_360 VGND VGND VPWR VPWR sky130_fd_sc_hd__decap_3
XFILLER_41_511 VGND VGND VPWR VPWR sky130_fd_sc_hd__decap_3
XFILLER_14_725 VGND VGND VPWR VPWR sky130_fd_sc_hd__decap_3
XFILLER_13_213 VGND VGND VPWR VPWR sky130_fd_sc_hd__decap_3
XFILLER_41_544 VGND VGND VPWR VPWR sky130_fd_sc_hd__decap_3
XFILLER_14_769 VGND VGND VPWR VPWR sky130_fd_sc_hd__decap_3
XFILLER_13_257 VGND VGND VPWR VPWR sky130_fd_sc_hd__decap_3
XTAP_TAPCELL_ROW_11_425 VGND VPWR sky130_fd_sc_hd__tapvpwrvgnd_1
XTAP_TAPCELL_ROW_11_436 VGND VPWR sky130_fd_sc_hd__tapvpwrvgnd_1
XPHY_EDGE_ROW_88_Right_88 VGND VGND VPWR VPWR sky130_fd_sc_hd__decap_3
XFILLER_127_638 VGND VGND VPWR VPWR sky130_fd_sc_hd__decap_3
XFILLER_126_115 VGND VGND VPWR VPWR sky130_fd_sc_hd__decap_3
Xrebuffer550 _7019_/A VGND VGND VPWR VPWR _7108_/B sky130_fd_sc_hd__buf_2
Xrebuffer561 _8058_/Y VGND VGND VPWR VPWR _8063_/A sky130_fd_sc_hd__buf_2
XFILLER_5_423 VGND VGND VPWR VPWR sky130_fd_sc_hd__decap_3
Xrebuffer572 _4921_/B VGND VGND VPWR VPWR _6342_/A sky130_fd_sc_hd__buf_2
Xrebuffer583 _5773_/A VGND VGND VPWR VPWR _5648_/A sky130_fd_sc_hd__buf_2
XFILLER_119_60 VGND VGND VPWR VPWR sky130_fd_sc_hd__decap_3
XFILLER_107_340 VGND VGND VPWR VPWR sky130_fd_sc_hd__fill_1
XFILLER_126_159 VGND VGND VPWR VPWR sky130_fd_sc_hd__decap_3
Xrebuffer594 _5720_/A1 VGND VGND VPWR VPWR _6305_/A sky130_fd_sc_hd__buf_2
XFILLER_119_93 VGND VGND VPWR VPWR sky130_fd_sc_hd__decap_3
XTAP_TAPCELL_ROW_56_1032 VGND VPWR sky130_fd_sc_hd__tapvpwrvgnd_1
XTAP_TAPCELL_ROW_56_1043 VGND VPWR sky130_fd_sc_hd__tapvpwrvgnd_1
XFILLER_122_365 VGND VGND VPWR VPWR sky130_fd_sc_hd__decap_3
XFILLER_1_662 VGND VGND VPWR VPWR sky130_fd_sc_hd__decap_3
XFILLER_1_673 VGND VGND VPWR VPWR sky130_fd_sc_hd__decap_3
XFILLER_0_150 VGND VGND VPWR VPWR sky130_fd_sc_hd__decap_3
XFILLER_110_527 VGND VGND VPWR VPWR sky130_fd_sc_hd__decap_3
XFILLER_88_290 VGND VGND VPWR VPWR sky130_fd_sc_hd__decap_3
XFILLER_48_132 VGND VGND VPWR VPWR sky130_fd_sc_hd__fill_1
XPHY_EDGE_ROW_97_Right_97 VGND VGND VPWR VPWR sky130_fd_sc_hd__decap_3
XFILLER_49_688 VGND VGND VPWR VPWR sky130_fd_sc_hd__fill_1
XFILLER_49_699 VGND VGND VPWR VPWR sky130_fd_sc_hd__decap_3
XFILLER_76_496 VGND VGND VPWR VPWR sky130_fd_sc_hd__decap_3
XFILLER_63_113 VGND VGND VPWR VPWR sky130_fd_sc_hd__decap_3
XTAP_TAPCELL_ROW_19_536 VGND VPWR sky130_fd_sc_hd__tapvpwrvgnd_1
XFILLER_63_179 VGND VGND VPWR VPWR sky130_fd_sc_hd__decap_3
XTAP_TAPCELL_ROW_121_1918 VGND VPWR sky130_fd_sc_hd__tapvpwrvgnd_1
XTAP_TAPCELL_ROW_67_1183 VGND VPWR sky130_fd_sc_hd__tapvpwrvgnd_1
XFILLER_72_691 VGND VGND VPWR VPWR sky130_fd_sc_hd__fill_2
XFILLER_32_522 VGND VGND VPWR VPWR sky130_fd_sc_hd__decap_3
XFILLER_32_533 VGND VGND VPWR VPWR sky130_fd_sc_hd__fill_2
XFILLER_20_728 VGND VGND VPWR VPWR sky130_fd_sc_hd__decap_3
XTAP_TAPCELL_ROW_80_1361 VGND VPWR sky130_fd_sc_hd__tapvpwrvgnd_1
X_5520_ _5538_/A _5520_/B VGND VGND VPWR VPWR _5521_/B sky130_fd_sc_hd__nand2_2
XFILLER_9_762 VGND VGND VPWR VPWR sky130_fd_sc_hd__decap_3
XFILLER_74_3 VGND VGND VPWR VPWR sky130_fd_sc_hd__decap_3
X_5451_ _5451_/A _5451_/B VGND VGND VPWR VPWR _5638_/A sky130_fd_sc_hd__xnor2_2
XFILLER_8_283 VGND VGND VPWR VPWR sky130_fd_sc_hd__decap_3
X_8170_ _8170_/A _8170_/B VGND VGND VPWR VPWR _8170_/Y sky130_fd_sc_hd__nand2_2
XFILLER_99_500 VGND VGND VPWR VPWR sky130_fd_sc_hd__decap_3
XFILLER_126_660 VGND VGND VPWR VPWR sky130_fd_sc_hd__decap_3
X_5382_ _5991_/B1 _5380_/X _5381_/X _5612_/A VGND VGND VPWR VPWR _5386_/C sky130_fd_sc_hd__a22o_2
X_7121_ _6989_/A _6989_/B _7120_/X VGND VGND VPWR VPWR _7124_/A sky130_fd_sc_hd__a21o_2
XFILLER_99_533 VGND VGND VPWR VPWR sky130_fd_sc_hd__decap_3
XFILLER_126_693 VGND VGND VPWR VPWR sky130_fd_sc_hd__decap_3
XFILLER_125_181 VGND VGND VPWR VPWR sky130_fd_sc_hd__decap_3
XFILLER_101_505 VGND VGND VPWR VPWR sky130_fd_sc_hd__decap_3
X_7052_ _8406_/A _7050_/Y _6939_/A _8161_/B VGND VGND VPWR VPWR _7053_/B sky130_fd_sc_hd__a211o_2
XFILLER_115_18 VGND VGND VPWR VPWR sky130_fd_sc_hd__decap_3
X_6003_ _6246_/A _6003_/B _6003_/C VGND VGND VPWR VPWR _6004_/B sky130_fd_sc_hd__or3_2
XFILLER_79_290 VGND VGND VPWR VPWR sky130_fd_sc_hd__fill_2
XFILLER_67_452 VGND VGND VPWR VPWR sky130_fd_sc_hd__decap_3
XFILLER_39_154 VGND VGND VPWR VPWR sky130_fd_sc_hd__fill_1
XTAP_TAPCELL_ROW_38_801 VGND VPWR sky130_fd_sc_hd__tapvpwrvgnd_1
XFILLER_55_636 VGND VGND VPWR VPWR sky130_fd_sc_hd__decap_3
XFILLER_82_433 VGND VGND VPWR VPWR sky130_fd_sc_hd__fill_2
X_7954_ _7954_/A _7954_/B VGND VGND VPWR VPWR _7963_/A sky130_fd_sc_hd__xnor2_2
XFILLER_82_455 VGND VGND VPWR VPWR sky130_fd_sc_hd__decap_3
X_6905_ _6905_/A VGND VGND VPWR VPWR _6905_/Y sky130_fd_sc_hd__inv_2
XFILLER_70_639 VGND VGND VPWR VPWR sky130_fd_sc_hd__decap_3
XFILLER_23_500 VGND VGND VPWR VPWR sky130_fd_sc_hd__decap_3
X_7885_ _8011_/B _7885_/B VGND VGND VPWR VPWR _7885_/Y sky130_fd_sc_hd__nor2_2
XFILLER_24_15 VGND VGND VPWR VPWR sky130_fd_sc_hd__decap_3
XFILLER_23_533 VGND VGND VPWR VPWR sky130_fd_sc_hd__fill_2
XFILLER_35_393 VGND VGND VPWR VPWR sky130_fd_sc_hd__decap_3
X_6836_ _6494_/A _6837_/A2 _6495_/B VGND VGND VPWR VPWR _6836_/X sky130_fd_sc_hd__a21o_2
XFILLER_24_59 VGND VGND VPWR VPWR sky130_fd_sc_hd__decap_3
XFILLER_11_717 VGND VGND VPWR VPWR sky130_fd_sc_hd__decap_3
XFILLER_50_363 VGND VGND VPWR VPWR sky130_fd_sc_hd__fill_1
XFILLER_50_374 VGND VGND VPWR VPWR sky130_fd_sc_hd__decap_3
XFILLER_23_588 VGND VGND VPWR VPWR sky130_fd_sc_hd__decap_3
X_6767_ _6767_/A _6767_/B VGND VGND VPWR VPWR _6768_/B sky130_fd_sc_hd__xnor2_2
XTAP_TAPCELL_ROW_98_1600 VGND VPWR sky130_fd_sc_hd__tapvpwrvgnd_1
XTAP_TAPCELL_ROW_98_1611 VGND VPWR sky130_fd_sc_hd__tapvpwrvgnd_1
X_8506_ _8511_/A _8511_/B VGND VGND VPWR VPWR _8633_/A sky130_fd_sc_hd__xnor2_2
X_5718_ _5718_/A _5718_/B _5718_/C VGND VGND VPWR VPWR _5719_/A sky130_fd_sc_hd__and3_2
XFILLER_6_209 VGND VGND VPWR VPWR sky130_fd_sc_hd__decap_3
X_6698_ _6926_/A _6926_/B _6697_/C VGND VGND VPWR VPWR _6699_/C sky130_fd_sc_hd__a21o_2
XFILLER_109_649 VGND VGND VPWR VPWR sky130_fd_sc_hd__decap_3
XFILLER_108_126 VGND VGND VPWR VPWR sky130_fd_sc_hd__decap_3
X_8437_ wire71/X VGND VGND VPWR VPWR _8739_/B sky130_fd_sc_hd__clkbuf_2
X_5649_ _5649_/A _5649_/B VGND VGND VPWR VPWR _5649_/Y sky130_fd_sc_hd__nand2_2
XFILLER_124_619 VGND VGND VPWR VPWR sky130_fd_sc_hd__decap_3
XFILLER_117_660 VGND VGND VPWR VPWR sky130_fd_sc_hd__decap_3
X_8368_ _8218_/B _8184_/B _8374_/B VGND VGND VPWR VPWR _8368_/X sky130_fd_sc_hd__o21a_2
XFILLER_2_415 VGND VGND VPWR VPWR sky130_fd_sc_hd__decap_3
XFILLER_117_693 VGND VGND VPWR VPWR sky130_fd_sc_hd__decap_3
X_7319_ _7317_/X _7318_/X _7407_/A VGND VGND VPWR VPWR _7319_/X sky130_fd_sc_hd__a21o_2
XFILLER_6_6 VGND VGND VPWR VPWR sky130_fd_sc_hd__decap_3
X_8299_ _8299_/A _8299_/B VGND VGND VPWR VPWR _8299_/Y sky130_fd_sc_hd__nand2_2
XFILLER_49_34 VGND VGND VPWR VPWR sky130_fd_sc_hd__fill_1
XFILLER_104_365 VGND VGND VPWR VPWR sky130_fd_sc_hd__fill_2
XFILLER_78_739 VGND VGND VPWR VPWR sky130_fd_sc_hd__fill_2
XFILLER_49_78 VGND VGND VPWR VPWR sky130_fd_sc_hd__decap_3
XPHY_EDGE_ROW_130_Right_130 VGND VGND VPWR VPWR sky130_fd_sc_hd__decap_3
XFILLER_93_709 VGND VGND VPWR VPWR sky130_fd_sc_hd__decap_3
XFILLER_58_430 VGND VGND VPWR VPWR sky130_fd_sc_hd__decap_3
XFILLER_58_452 VGND VGND VPWR VPWR sky130_fd_sc_hd__decap_3
XFILLER_92_208 VGND VGND VPWR VPWR sky130_fd_sc_hd__decap_3
XFILLER_46_614 VGND VGND VPWR VPWR sky130_fd_sc_hd__decap_3
XFILLER_73_411 VGND VGND VPWR VPWR sky130_fd_sc_hd__fill_1
XFILLER_65_33 VGND VGND VPWR VPWR sky130_fd_sc_hd__fill_2
XFILLER_100_582 VGND VGND VPWR VPWR sky130_fd_sc_hd__decap_3
XFILLER_73_422 VGND VGND VPWR VPWR sky130_fd_sc_hd__decap_3
XFILLER_45_113 VGND VGND VPWR VPWR sky130_fd_sc_hd__decap_3
XFILLER_46_658 VGND VGND VPWR VPWR sky130_fd_sc_hd__decap_3
XFILLER_73_455 VGND VGND VPWR VPWR sky130_fd_sc_hd__decap_3
XFILLER_73_488 VGND VGND VPWR VPWR sky130_fd_sc_hd__decap_3
XFILLER_61_639 VGND VGND VPWR VPWR sky130_fd_sc_hd__decap_3
XFILLER_14_522 VGND VGND VPWR VPWR sky130_fd_sc_hd__decap_3
XFILLER_121_72 VGND VGND VPWR VPWR sky130_fd_sc_hd__decap_3
XFILLER_81_54 VGND VGND VPWR VPWR sky130_fd_sc_hd__fill_2
XFILLER_41_352 VGND VGND VPWR VPWR sky130_fd_sc_hd__decap_3
XFILLER_81_65 VGND VGND VPWR VPWR sky130_fd_sc_hd__decap_3
XFILLER_81_98 VGND VGND VPWR VPWR sky130_fd_sc_hd__decap_3
XFILLER_41_396 VGND VGND VPWR VPWR sky130_fd_sc_hd__fill_2
XFILLER_127_402 VGND VGND VPWR VPWR sky130_fd_sc_hd__fill_2
XFILLER_6_710 VGND VGND VPWR VPWR sky130_fd_sc_hd__decap_3
XFILLER_10_772 VGND VGND VPWR VPWR sky130_fd_sc_hd__decap_3
XFILLER_127_435 VGND VGND VPWR VPWR sky130_fd_sc_hd__decap_3
XFILLER_6_743 VGND VGND VPWR VPWR sky130_fd_sc_hd__decap_3
XFILLER_60_9 VGND VGND VPWR VPWR sky130_fd_sc_hd__decap_3
XFILLER_5_231 VGND VGND VPWR VPWR sky130_fd_sc_hd__decap_3
XTAP_TAPCELL_ROW_118_1880 VGND VPWR sky130_fd_sc_hd__tapvpwrvgnd_1
XFILLER_107_181 VGND VGND VPWR VPWR sky130_fd_sc_hd__decap_3
XFILLER_68_205 VGND VGND VPWR VPWR sky130_fd_sc_hd__decap_3
XFILLER_122_162 VGND VGND VPWR VPWR sky130_fd_sc_hd__decap_3
XFILLER_96_536 VGND VGND VPWR VPWR sky130_fd_sc_hd__fill_2
XFILLER_110_313 VGND VGND VPWR VPWR sky130_fd_sc_hd__fill_2
XFILLER_68_238 VGND VGND VPWR VPWR sky130_fd_sc_hd__fill_1
XFILLER_110_324 VGND VGND VPWR VPWR sky130_fd_sc_hd__decap_3
XFILLER_122_195 VGND VGND VPWR VPWR sky130_fd_sc_hd__fill_1
XFILLER_83_208 VGND VGND VPWR VPWR sky130_fd_sc_hd__decap_3
XFILLER_110_368 VGND VGND VPWR VPWR sky130_fd_sc_hd__decap_3
XFILLER_49_463 VGND VGND VPWR VPWR sky130_fd_sc_hd__decap_3
XFILLER_37_603 VGND VGND VPWR VPWR sky130_fd_sc_hd__decap_3
Xinput7 sample_in[14] VGND VGND VPWR VPWR input7/X sky130_fd_sc_hd__clkdlybuf4s25_1
XTAP_TAPCELL_ROW_69_1212 VGND VPWR sky130_fd_sc_hd__tapvpwrvgnd_1
XFILLER_49_496 VGND VGND VPWR VPWR sky130_fd_sc_hd__decap_3
XFILLER_36_124 VGND VGND VPWR VPWR sky130_fd_sc_hd__decap_3
XFILLER_64_455 VGND VGND VPWR VPWR sky130_fd_sc_hd__decap_3
XFILLER_52_606 VGND VGND VPWR VPWR sky130_fd_sc_hd__decap_3
XFILLER_92_775 VGND VGND VPWR VPWR sky130_fd_sc_hd__fill_2
X_4951_ _6231_/B _5187_/C _5119_/S _5611_/S VGND VGND VPWR VPWR _4998_/A sky130_fd_sc_hd__or4_4
XFILLER_17_393 VGND VGND VPWR VPWR sky130_fd_sc_hd__fill_2
X_7670_ _7670_/A _7670_/B VGND VGND VPWR VPWR _7670_/Y sky130_fd_sc_hd__nand2_2
X_4882_ _4876_/X _4881_/Y _4878_/X hold803/X VGND VGND VPWR VPWR _4882_/X sky130_fd_sc_hd__a2bb2o_2
XFILLER_20_503 VGND VGND VPWR VPWR sky130_fd_sc_hd__fill_1
X_6621_ _8271_/B _6621_/B VGND VGND VPWR VPWR _6625_/A sky130_fd_sc_hd__nand2_2
XFILLER_32_374 VGND VGND VPWR VPWR sky130_fd_sc_hd__fill_1
XFILLER_20_525 VGND VGND VPWR VPWR sky130_fd_sc_hd__decap_3
XFILLER_20_536 VGND VGND VPWR VPWR sky130_fd_sc_hd__fill_1
X_9340_ clkload9/A _9340_/D load_slew368/X VGND VGND VPWR VPWR _9340_/Q sky130_fd_sc_hd__dfrtp_2
X_6552_ _7114_/C _7043_/B VGND VGND VPWR VPWR _6745_/A sky130_fd_sc_hd__nand2_2
XFILLER_118_424 VGND VGND VPWR VPWR sky130_fd_sc_hd__decap_3
X_5503_ _5934_/A _5804_/B _5503_/C VGND VGND VPWR VPWR _5503_/X sky130_fd_sc_hd__or3_2
X_9271_ clkload6/A _9271_/D load_slew376/X VGND VGND VPWR VPWR _9271_/Q sky130_fd_sc_hd__dfrtp_2
X_6483_ _6885_/A _6788_/A _6483_/S VGND VGND VPWR VPWR _6484_/B sky130_fd_sc_hd__mux2_2
XFILLER_106_619 VGND VGND VPWR VPWR sky130_fd_sc_hd__decap_3
X_8222_ _8222_/A _8248_/B VGND VGND VPWR VPWR _8222_/Y sky130_fd_sc_hd__nor2_2
X_5434_ _5434_/A _5434_/B VGND VGND VPWR VPWR _5435_/B sky130_fd_sc_hd__xnor2_2
XTAP_TAPCELL_ROW_93_1541 VGND VPWR sky130_fd_sc_hd__tapvpwrvgnd_1
X_8153_ _8155_/A _8231_/A VGND VGND VPWR VPWR _8153_/Y sky130_fd_sc_hd__nand2_2
X_5365_ _5440_/A _5358_/X _5364_/X VGND VGND VPWR VPWR _5366_/B sky130_fd_sc_hd__o21a_2
XFILLER_114_641 VGND VGND VPWR VPWR sky130_fd_sc_hd__decap_3
XFILLER_99_352 VGND VGND VPWR VPWR sky130_fd_sc_hd__decap_3
X_7104_ _7063_/X _7064_/Y _7102_/X _7103_/Y VGND VGND VPWR VPWR _7106_/B sky130_fd_sc_hd__o211a_4
XFILLER_87_503 VGND VGND VPWR VPWR sky130_fd_sc_hd__fill_1
XFILLER_114_674 VGND VGND VPWR VPWR sky130_fd_sc_hd__decap_3
X_8084_ _9217_/Q _7924_/B _8083_/Y VGND VGND VPWR VPWR _8084_/X sky130_fd_sc_hd__o21a_2
XFILLER_87_525 VGND VGND VPWR VPWR sky130_fd_sc_hd__decap_3
X_5296_ _6010_/A VGND VGND VPWR VPWR _8080_/A sky130_fd_sc_hd__clkbuf_2
XFILLER_99_396 VGND VGND VPWR VPWR sky130_fd_sc_hd__decap_3
XFILLER_101_324 VGND VGND VPWR VPWR sky130_fd_sc_hd__decap_3
XFILLER_19_15 VGND VGND VPWR VPWR sky130_fd_sc_hd__decap_3
X_7035_ _7038_/A _7038_/B VGND VGND VPWR VPWR _7035_/Y sky130_fd_sc_hd__nor2_2
XFILLER_87_558 VGND VGND VPWR VPWR sky130_fd_sc_hd__fill_2
XFILLER_101_346 VGND VGND VPWR VPWR sky130_fd_sc_hd__decap_3
XFILLER_101_368 VGND VGND VPWR VPWR sky130_fd_sc_hd__fill_1
XPHY_EDGE_ROW_98_Left_229 VGND VGND VPWR VPWR sky130_fd_sc_hd__decap_3
XFILLER_83_720 VGND VGND VPWR VPWR sky130_fd_sc_hd__decap_3
XFILLER_55_411 VGND VGND VPWR VPWR sky130_fd_sc_hd__fill_2
XFILLER_27_113 VGND VGND VPWR VPWR sky130_fd_sc_hd__fill_1
XFILLER_67_293 VGND VGND VPWR VPWR sky130_fd_sc_hd__decap_3
X_8986_ hold839/X _8986_/A1 _8988_/S VGND VGND VPWR VPWR _8987_/A sky130_fd_sc_hd__mux2_2
XFILLER_55_477 VGND VGND VPWR VPWR sky130_fd_sc_hd__decap_3
X_7937_ wire84/X _7775_/A _7764_/B _7777_/A _7936_/Y VGND VGND VPWR VPWR _7937_/X
+ sky130_fd_sc_hd__a311o_2
XFILLER_70_414 VGND VGND VPWR VPWR sky130_fd_sc_hd__decap_3
XFILLER_35_47 VGND VGND VPWR VPWR sky130_fd_sc_hd__fill_2
XFILLER_70_436 VGND VGND VPWR VPWR sky130_fd_sc_hd__fill_2
X_7868_ _7869_/A _7534_/A _7866_/Y _7869_/B VGND VGND VPWR VPWR _7868_/X sky130_fd_sc_hd__a31o_2
XFILLER_70_469 VGND VGND VPWR VPWR sky130_fd_sc_hd__decap_3
XTAP_TAPCELL_ROW_41_829 VGND VPWR sky130_fd_sc_hd__tapvpwrvgnd_1
X_6819_ _7179_/A _7176_/A _7178_/B VGND VGND VPWR VPWR _6819_/X sky130_fd_sc_hd__a21o_2
X_7799_ _7799_/A _8161_/B _8240_/B VGND VGND VPWR VPWR _7799_/X sky130_fd_sc_hd__or3_2
XFILLER_109_402 VGND VGND VPWR VPWR sky130_fd_sc_hd__fill_2
XFILLER_51_57 VGND VGND VPWR VPWR sky130_fd_sc_hd__decap_3
XTAP_TAPCELL_ROW_21_564 VGND VPWR sky130_fd_sc_hd__tapvpwrvgnd_1
XFILLER_109_435 VGND VGND VPWR VPWR sky130_fd_sc_hd__decap_3
XFILLER_3_724 VGND VGND VPWR VPWR sky130_fd_sc_hd__decap_3
XFILLER_124_438 VGND VGND VPWR VPWR sky130_fd_sc_hd__decap_3
XFILLER_3_735 VGND VGND VPWR VPWR sky130_fd_sc_hd__decap_3
XFILLER_117_490 VGND VGND VPWR VPWR sky130_fd_sc_hd__decap_3
XFILLER_4_3 VGND VGND VPWR VPWR sky130_fd_sc_hd__decap_3
XFILLER_3_768 VGND VGND VPWR VPWR sky130_fd_sc_hd__decap_3
XTAP_TAPCELL_ROW_53_1002 VGND VPWR sky130_fd_sc_hd__tapvpwrvgnd_1
XFILLER_2_245 VGND VGND VPWR VPWR sky130_fd_sc_hd__decap_3
XFILLER_2_256 VGND VGND VPWR VPWR sky130_fd_sc_hd__decap_3
XFILLER_104_151 VGND VGND VPWR VPWR sky130_fd_sc_hd__fill_1
XFILLER_105_685 VGND VGND VPWR VPWR sky130_fd_sc_hd__decap_3
XFILLER_116_50 VGND VGND VPWR VPWR sky130_fd_sc_hd__decap_3
XFILLER_76_32 VGND VGND VPWR VPWR sky130_fd_sc_hd__decap_3
XFILLER_116_83 VGND VGND VPWR VPWR sky130_fd_sc_hd__fill_1
XFILLER_116_94 VGND VGND VPWR VPWR sky130_fd_sc_hd__decap_3
XFILLER_93_517 VGND VGND VPWR VPWR sky130_fd_sc_hd__decap_3
XFILLER_76_65 VGND VGND VPWR VPWR sky130_fd_sc_hd__decap_3
XFILLER_65_219 VGND VGND VPWR VPWR sky130_fd_sc_hd__decap_3
XFILLER_59_772 VGND VGND VPWR VPWR sky130_fd_sc_hd__decap_3
XFILLER_46_400 VGND VGND VPWR VPWR sky130_fd_sc_hd__decap_3
XFILLER_74_742 VGND VGND VPWR VPWR sky130_fd_sc_hd__decap_3
XFILLER_18_124 VGND VGND VPWR VPWR sky130_fd_sc_hd__decap_3
XFILLER_46_466 VGND VGND VPWR VPWR sky130_fd_sc_hd__decap_3
XFILLER_34_606 VGND VGND VPWR VPWR sky130_fd_sc_hd__decap_3
XFILLER_46_477 VGND VGND VPWR VPWR sky130_fd_sc_hd__decap_3
XTAP_TAPCELL_ROW_29_675 VGND VPWR sky130_fd_sc_hd__tapvpwrvgnd_1
XFILLER_92_53 VGND VGND VPWR VPWR sky130_fd_sc_hd__decap_3
XFILLER_61_425 VGND VGND VPWR VPWR sky130_fd_sc_hd__fill_2
XFILLER_34_639 VGND VGND VPWR VPWR sky130_fd_sc_hd__decap_3
XFILLER_33_116 VGND VGND VPWR VPWR sky130_fd_sc_hd__decap_3
XFILLER_27_691 VGND VGND VPWR VPWR sky130_fd_sc_hd__decap_3
XFILLER_61_458 VGND VGND VPWR VPWR sky130_fd_sc_hd__decap_3
XTAP_TAPCELL_ROW_64_1142 VGND VPWR sky130_fd_sc_hd__tapvpwrvgnd_1
XFILLER_14_341 VGND VGND VPWR VPWR sky130_fd_sc_hd__decap_3
XFILLER_42_683 VGND VGND VPWR VPWR sky130_fd_sc_hd__decap_3
XFILLER_42_694 VGND VGND VPWR VPWR sky130_fd_sc_hd__decap_3
XFILLER_25_91 VGND VGND VPWR VPWR sky130_fd_sc_hd__decap_3
XFILLER_128_722 VGND VGND VPWR VPWR sky130_fd_sc_hd__decap_3
XFILLER_128_755 VGND VGND VPWR VPWR sky130_fd_sc_hd__fill_1
XFILLER_128_766 VGND VGND VPWR VPWR sky130_fd_sc_hd__decap_3
XFILLER_127_243 VGND VGND VPWR VPWR sky130_fd_sc_hd__decap_3
XFILLER_41_90 VGND VGND VPWR VPWR sky130_fd_sc_hd__fill_2
XFILLER_115_416 VGND VGND VPWR VPWR sky130_fd_sc_hd__decap_3
XFILLER_6_573 VGND VGND VPWR VPWR sky130_fd_sc_hd__fill_2
XFILLER_127_287 VGND VGND VPWR VPWR sky130_fd_sc_hd__decap_3
XFILLER_115_438 VGND VGND VPWR VPWR sky130_fd_sc_hd__decap_3
XFILLER_108_490 VGND VGND VPWR VPWR sky130_fd_sc_hd__fill_2
XFILLER_69_503 VGND VGND VPWR VPWR sky130_fd_sc_hd__fill_1
XFILLER_130_419 VGND VGND VPWR VPWR sky130_fd_sc_hd__fill_1
X_5150_ _9198_/Q _5167_/B _7317_/A _9197_/Q VGND VGND VPWR VPWR _5150_/X sky130_fd_sc_hd__o211a_2
XTAP_TAPCELL_ROW_75_1293 VGND VPWR sky130_fd_sc_hd__tapvpwrvgnd_1
XFILLER_69_514 VGND VGND VPWR VPWR sky130_fd_sc_hd__decap_3
XFILLER_111_600 VGND VGND VPWR VPWR sky130_fd_sc_hd__decap_3
XFILLER_37_3 VGND VGND VPWR VPWR sky130_fd_sc_hd__decap_3
X_5081_ _5081_/A _5081_/B VGND VGND VPWR VPWR _5081_/Y sky130_fd_sc_hd__xnor2_2
XFILLER_69_569 VGND VGND VPWR VPWR sky130_fd_sc_hd__decap_3
XFILLER_84_506 VGND VGND VPWR VPWR sky130_fd_sc_hd__decap_3
XFILLER_2_62 VGND VGND VPWR VPWR sky130_fd_sc_hd__decap_3
XFILLER_84_539 VGND VGND VPWR VPWR sky130_fd_sc_hd__fill_2
XFILLER_110_176 VGND VGND VPWR VPWR sky130_fd_sc_hd__decap_3
X_8840_ _8840_/A VGND VGND VPWR VPWR _9264_/D sky130_fd_sc_hd__buf_1
XFILLER_64_241 VGND VGND VPWR VPWR sky130_fd_sc_hd__fill_2
XFILLER_80_701 VGND VGND VPWR VPWR sky130_fd_sc_hd__decap_3
XFILLER_65_775 VGND VGND VPWR VPWR sky130_fd_sc_hd__fill_2
XFILLER_37_477 VGND VGND VPWR VPWR sky130_fd_sc_hd__fill_1
XFILLER_92_583 VGND VGND VPWR VPWR sky130_fd_sc_hd__decap_3
X_8771_ _8771_/A _8771_/B _8771_/C VGND VGND VPWR VPWR _8772_/C sky130_fd_sc_hd__nand3_2
X_5983_ _5633_/A _5980_/X _5982_/X VGND VGND VPWR VPWR _6007_/A sky130_fd_sc_hd__o21ba_2
X_7722_ _7722_/A _7722_/B VGND VGND VPWR VPWR _7736_/A sky130_fd_sc_hd__xnor2_2
XFILLER_52_458 VGND VGND VPWR VPWR sky130_fd_sc_hd__decap_3
X_4934_ _4934_/A VGND VGND VPWR VPWR _5990_/A sky130_fd_sc_hd__buf_4
XFILLER_33_661 VGND VGND VPWR VPWR sky130_fd_sc_hd__decap_3
XFILLER_33_683 VGND VGND VPWR VPWR sky130_fd_sc_hd__decap_3
X_7653_ _7554_/A _7553_/B _7553_/A VGND VGND VPWR VPWR _7653_/X sky130_fd_sc_hd__a21o_2
X_4865_ hold993/X _9160_/Q _8799_/S VGND VGND VPWR VPWR _4865_/X sky130_fd_sc_hd__mux2_2
XFILLER_32_171 VGND VGND VPWR VPWR sky130_fd_sc_hd__decap_3
X_6604_ _9128_/Q _6607_/B _6604_/C VGND VGND VPWR VPWR _6604_/X sky130_fd_sc_hd__and3_2
X_7584_ _7591_/A _8050_/A _7590_/C wire84/X VGND VGND VPWR VPWR _7584_/X sky130_fd_sc_hd__a211o_2
XFILLER_119_711 VGND VGND VPWR VPWR sky130_fd_sc_hd__decap_3
X_4796_ _9144_/Q hold918/X _4798_/S VGND VGND VPWR VPWR _4796_/X sky130_fd_sc_hd__mux2_2
X_9323_ _9339_/CLK _9323_/D load_slew386/X VGND VGND VPWR VPWR _9323_/Q sky130_fd_sc_hd__dfrtp_2
XFILLER_119_744 VGND VGND VPWR VPWR sky130_fd_sc_hd__decap_3
X_6535_ _6535_/A _6542_/A VGND VGND VPWR VPWR _6537_/B sky130_fd_sc_hd__nand2_2
XFILLER_21_27 VGND VGND VPWR VPWR sky130_fd_sc_hd__decap_3
XFILLER_118_232 VGND VGND VPWR VPWR sky130_fd_sc_hd__decap_3
X_9254_ clkload7/A _9254_/D load_slew376/X VGND VGND VPWR VPWR _9254_/Q sky130_fd_sc_hd__dfrtp_2
X_6466_ _6464_/X _6465_/X _6467_/B VGND VGND VPWR VPWR _6466_/X sky130_fd_sc_hd__mux2_2
XFILLER_106_427 VGND VGND VPWR VPWR sky130_fd_sc_hd__decap_3
XFILLER_108_9 VGND VGND VPWR VPWR sky130_fd_sc_hd__decap_3
X_8205_ _8277_/A _8205_/B VGND VGND VPWR VPWR _8205_/Y sky130_fd_sc_hd__xnor2_2
X_5417_ _5417_/A _5416_/Y VGND VGND VPWR VPWR _5418_/B sky130_fd_sc_hd__or2b_2
X_9185_ _9189_/CLK _9185_/D load_slew414/X VGND VGND VPWR VPWR _9185_/Q sky130_fd_sc_hd__dfrtp_2
X_6397_ _6095_/A _6805_/A _6095_/B _5326_/X _6116_/B VGND VGND VPWR VPWR _6397_/X
+ sky130_fd_sc_hd__a221o_2
XFILLER_0_716 VGND VGND VPWR VPWR sky130_fd_sc_hd__decap_3
X_8136_ _8078_/A _8131_/B _8135_/X VGND VGND VPWR VPWR _8187_/A sky130_fd_sc_hd__o21ai_2
X_5348_ _5050_/A _8780_/D _5348_/S VGND VGND VPWR VPWR _5348_/X sky130_fd_sc_hd__mux2_2
XFILLER_0_738 VGND VGND VPWR VPWR sky130_fd_sc_hd__decap_3
XFILLER_87_333 VGND VGND VPWR VPWR sky130_fd_sc_hd__decap_3
X_8067_ _5350_/B _7472_/Y _7794_/Y _8240_/B _8175_/A VGND VGND VPWR VPWR _8068_/B
+ sky130_fd_sc_hd__a311o_2
X_5279_ _5279_/A _6942_/A _7590_/A VGND VGND VPWR VPWR _5280_/B sky130_fd_sc_hd__and3_2
X_7018_ _7010_/Y _7018_/A2 _7017_/X VGND VGND VPWR VPWR _7019_/A sky130_fd_sc_hd__o21a_4
XFILLER_75_528 VGND VGND VPWR VPWR sky130_fd_sc_hd__decap_3
XFILLER_102_699 VGND VGND VPWR VPWR sky130_fd_sc_hd__fill_1
XFILLER_28_411 VGND VGND VPWR VPWR sky130_fd_sc_hd__decap_3
XFILLER_46_24 VGND VGND VPWR VPWR sky130_fd_sc_hd__decap_3
XFILLER_28_433 VGND VGND VPWR VPWR sky130_fd_sc_hd__fill_2
XFILLER_46_57 VGND VGND VPWR VPWR sky130_fd_sc_hd__decap_3
XFILLER_83_561 VGND VGND VPWR VPWR sky130_fd_sc_hd__decap_3
XFILLER_71_701 VGND VGND VPWR VPWR sky130_fd_sc_hd__fill_1
XFILLER_56_775 VGND VGND VPWR VPWR sky130_fd_sc_hd__fill_2
XFILLER_46_79 VGND VGND VPWR VPWR sky130_fd_sc_hd__decap_3
XFILLER_28_477 VGND VGND VPWR VPWR sky130_fd_sc_hd__decap_3
Xmax_cap58 _8447_/X VGND VGND VPWR VPWR _8656_/A sky130_fd_sc_hd__clkbuf_2
Xmax_cap69 _8486_/A VGND VGND VPWR VPWR _8332_/A sky130_fd_sc_hd__clkbuf_2
XFILLER_70_200 VGND VGND VPWR VPWR sky130_fd_sc_hd__decap_3
XFILLER_102_41 VGND VGND VPWR VPWR sky130_fd_sc_hd__fill_1
X_8969_ _8969_/A VGND VGND VPWR VPWR _8988_/S sky130_fd_sc_hd__clkbuf_2
XFILLER_43_436 VGND VGND VPWR VPWR sky130_fd_sc_hd__decap_3
XTAP_TAPCELL_ROW_26_634 VGND VPWR sky130_fd_sc_hd__tapvpwrvgnd_1
XFILLER_43_458 VGND VGND VPWR VPWR sky130_fd_sc_hd__decap_3
XFILLER_102_63 VGND VGND VPWR VPWR sky130_fd_sc_hd__decap_3
XFILLER_102_85 VGND VGND VPWR VPWR sky130_fd_sc_hd__decap_3
XTAP_TAPCELL_ROW_100_1629 VGND VPWR sky130_fd_sc_hd__tapvpwrvgnd_1
XFILLER_51_480 VGND VGND VPWR VPWR sky130_fd_sc_hd__decap_3
XFILLER_11_355 VGND VGND VPWR VPWR sky130_fd_sc_hd__decap_3
XFILLER_7_18 VGND VGND VPWR VPWR sky130_fd_sc_hd__decap_3
Xwire224 wire224/A VGND VGND VPWR VPWR result_out[4] sky130_fd_sc_hd__buf_4
XFILLER_109_276 VGND VGND VPWR VPWR sky130_fd_sc_hd__decap_3
XFILLER_125_725 VGND VGND VPWR VPWR sky130_fd_sc_hd__decap_3
XFILLER_125_747 VGND VGND VPWR VPWR sky130_fd_sc_hd__decap_3
XFILLER_124_224 VGND VGND VPWR VPWR sky130_fd_sc_hd__decap_3
XFILLER_11_60 VGND VGND VPWR VPWR sky130_fd_sc_hd__decap_3
XFILLER_127_60 VGND VGND VPWR VPWR sky130_fd_sc_hd__decap_3
XFILLER_124_268 VGND VGND VPWR VPWR sky130_fd_sc_hd__decap_3
XFILLER_97_119 VGND VGND VPWR VPWR sky130_fd_sc_hd__decap_3
XFILLER_124_279 VGND VGND VPWR VPWR sky130_fd_sc_hd__fill_1
XFILLER_112_419 VGND VGND VPWR VPWR sky130_fd_sc_hd__fill_1
XFILLER_127_93 VGND VGND VPWR VPWR sky130_fd_sc_hd__decap_3
XFILLER_105_482 VGND VGND VPWR VPWR sky130_fd_sc_hd__decap_3
XFILLER_78_322 VGND VGND VPWR VPWR sky130_fd_sc_hd__decap_3
XFILLER_3_598 VGND VGND VPWR VPWR sky130_fd_sc_hd__decap_3
XFILLER_120_430 VGND VGND VPWR VPWR sky130_fd_sc_hd__decap_3
XFILLER_78_344 VGND VGND VPWR VPWR sky130_fd_sc_hd__decap_3
XFILLER_78_355 VGND VGND VPWR VPWR sky130_fd_sc_hd__decap_3
XFILLER_23_9 VGND VGND VPWR VPWR sky130_fd_sc_hd__decap_3
XFILLER_87_97 VGND VGND VPWR VPWR sky130_fd_sc_hd__decap_3
XFILLER_66_506 VGND VGND VPWR VPWR sky130_fd_sc_hd__fill_1
XFILLER_78_377 VGND VGND VPWR VPWR sky130_fd_sc_hd__decap_3
XFILLER_120_463 VGND VGND VPWR VPWR sky130_fd_sc_hd__fill_2
XFILLER_66_539 VGND VGND VPWR VPWR sky130_fd_sc_hd__decap_3
XFILLER_59_591 VGND VGND VPWR VPWR sky130_fd_sc_hd__decap_3
XFILLER_47_753 VGND VGND VPWR VPWR sky130_fd_sc_hd__fill_1
XFILLER_19_455 VGND VGND VPWR VPWR sky130_fd_sc_hd__decap_3
XFILLER_62_701 VGND VGND VPWR VPWR sky130_fd_sc_hd__decap_3
XFILLER_47_775 VGND VGND VPWR VPWR sky130_fd_sc_hd__fill_2
XFILLER_61_200 VGND VGND VPWR VPWR sky130_fd_sc_hd__decap_3
XFILLER_19_488 VGND VGND VPWR VPWR sky130_fd_sc_hd__decap_3
XFILLER_62_734 VGND VGND VPWR VPWR sky130_fd_sc_hd__fill_2
XFILLER_46_285 VGND VGND VPWR VPWR sky130_fd_sc_hd__decap_3
XFILLER_21_119 VGND VGND VPWR VPWR sky130_fd_sc_hd__decap_3
XFILLER_15_694 VGND VGND VPWR VPWR sky130_fd_sc_hd__decap_3
XFILLER_42_480 VGND VGND VPWR VPWR sky130_fd_sc_hd__decap_3
X_4650_ _9075_/Q hold876/X _4650_/S VGND VGND VPWR VPWR _4650_/X sky130_fd_sc_hd__mux2_2
Xinput10 sample_in[2] VGND VGND VPWR VPWR input10/X sky130_fd_sc_hd__buf_4
X_4581_ _9042_/Q hold926/X _4587_/S VGND VGND VPWR VPWR _4581_/X sky130_fd_sc_hd__mux2_2
XFILLER_128_541 VGND VGND VPWR VPWR sky130_fd_sc_hd__decap_3
X_6320_ _6209_/X _6318_/Y _6319_/X VGND VGND VPWR VPWR _6321_/B sky130_fd_sc_hd__o21ai_4
XTAP_TAPCELL_ROW_77_1322 VGND VPWR sky130_fd_sc_hd__tapvpwrvgnd_1
Xhold805 _9213_/Q VGND VGND VPWR VPWR hold805/X sky130_fd_sc_hd__dlygate4sd3_1
XFILLER_128_585 VGND VGND VPWR VPWR sky130_fd_sc_hd__decap_3
Xhold816 _9210_/Q VGND VGND VPWR VPWR hold816/X sky130_fd_sc_hd__dlygate4sd3_1
Xhold827 _9021_/Q VGND VGND VPWR VPWR hold827/X sky130_fd_sc_hd__dlygate4sd3_1
Xhold838 _4573_/X VGND VGND VPWR VPWR _4574_/A sky130_fd_sc_hd__dlygate4sd3_1
Xhold849 _8900_/X VGND VGND VPWR VPWR _8901_/A sky130_fd_sc_hd__dlygate4sd3_1
XFILLER_116_769 VGND VGND VPWR VPWR sky130_fd_sc_hd__fill_2
XTAP_TAPCELL_ROW_90_1500 VGND VPWR sky130_fd_sc_hd__tapvpwrvgnd_1
X_5202_ _6304_/A _7569_/A VGND VGND VPWR VPWR _5305_/A sky130_fd_sc_hd__or2_2
XFILLER_115_279 VGND VGND VPWR VPWR sky130_fd_sc_hd__fill_1
X_6182_ _6171_/X _6176_/X _6185_/B1 VGND VGND VPWR VPWR _6326_/B sky130_fd_sc_hd__o21ai_2
XFILLER_130_249 VGND VGND VPWR VPWR sky130_fd_sc_hd__decap_3
X_5133_ _6942_/A _5344_/A VGND VGND VPWR VPWR _5134_/B sky130_fd_sc_hd__nand2_2
XFILLER_97_653 VGND VGND VPWR VPWR sky130_fd_sc_hd__decap_3
XFILLER_96_141 VGND VGND VPWR VPWR sky130_fd_sc_hd__decap_3
XTAP_TAPCELL_ROW_4_329 VGND VPWR sky130_fd_sc_hd__tapvpwrvgnd_1
XFILLER_57_517 VGND VGND VPWR VPWR sky130_fd_sc_hd__decap_3
XFILLER_123_18 VGND VGND VPWR VPWR sky130_fd_sc_hd__decap_3
X_5064_ _5175_/B _5457_/B VGND VGND VPWR VPWR _5065_/A sky130_fd_sc_hd__and2_2
XFILLER_38_775 VGND VGND VPWR VPWR sky130_fd_sc_hd__fill_2
XFILLER_65_561 VGND VGND VPWR VPWR sky130_fd_sc_hd__decap_3
XTAP_TAPCELL_ROW_88_1473 VGND VPWR sky130_fd_sc_hd__tapvpwrvgnd_1
XFILLER_65_583 VGND VGND VPWR VPWR sky130_fd_sc_hd__decap_3
XFILLER_52_200 VGND VGND VPWR VPWR sky130_fd_sc_hd__fill_2
X_8823_ _9256_/Q hold916/X _8837_/S VGND VGND VPWR VPWR _8823_/X sky130_fd_sc_hd__mux2_2
XFILLER_80_520 VGND VGND VPWR VPWR sky130_fd_sc_hd__decap_3
XFILLER_16_27 VGND VGND VPWR VPWR sky130_fd_sc_hd__fill_1
XFILLER_16_38 VGND VGND VPWR VPWR sky130_fd_sc_hd__decap_3
XFILLER_80_542 VGND VGND VPWR VPWR sky130_fd_sc_hd__fill_2
X_8754_ _9230_/Q _8758_/A _8753_/A _8753_/Y VGND VGND VPWR VPWR _8754_/X sky130_fd_sc_hd__o31a_2
XFILLER_25_469 VGND VGND VPWR VPWR sky130_fd_sc_hd__decap_3
X_5966_ _5966_/A _5965_/X VGND VGND VPWR VPWR _5967_/B sky130_fd_sc_hd__or2b_2
XFILLER_80_564 VGND VGND VPWR VPWR sky130_fd_sc_hd__decap_3
XFILLER_40_406 VGND VGND VPWR VPWR sky130_fd_sc_hd__decap_3
X_7705_ _8011_/C _7705_/B VGND VGND VPWR VPWR _7705_/X sky130_fd_sc_hd__or2_2
XFILLER_12_119 VGND VGND VPWR VPWR sky130_fd_sc_hd__decap_3
X_4917_ _5197_/A _5106_/A1 _4914_/Y _4916_/X _6302_/A VGND VGND VPWR VPWR _4918_/A
+ sky130_fd_sc_hd__a311oi_4
X_8685_ _8714_/A _8685_/B VGND VGND VPWR VPWR _8686_/A sky130_fd_sc_hd__xor2_2
XFILLER_21_620 VGND VGND VPWR VPWR sky130_fd_sc_hd__decap_3
X_5897_ _7114_/C _6685_/A _5897_/C _5897_/D VGND VGND VPWR VPWR _5897_/X sky130_fd_sc_hd__and4_2
XFILLER_33_491 VGND VGND VPWR VPWR sky130_fd_sc_hd__decap_3
XFILLER_21_642 VGND VGND VPWR VPWR sky130_fd_sc_hd__decap_3
XTAP_TAPCELL_ROW_51_968 VGND VPWR sky130_fd_sc_hd__tapvpwrvgnd_1
X_7636_ _7636_/A _7636_/B _7636_/C VGND VGND VPWR VPWR _7638_/A sky130_fd_sc_hd__and3_2
X_4848_ _4848_/A VGND VGND VPWR VPWR _9168_/D sky130_fd_sc_hd__buf_1
XFILLER_20_141 VGND VGND VPWR VPWR sky130_fd_sc_hd__decap_3
XFILLER_32_59 VGND VGND VPWR VPWR sky130_fd_sc_hd__decap_3
XFILLER_21_697 VGND VGND VPWR VPWR sky130_fd_sc_hd__fill_1
XFILLER_20_174 VGND VGND VPWR VPWR sky130_fd_sc_hd__decap_3
XFILLER_119_530 VGND VGND VPWR VPWR sky130_fd_sc_hd__decap_3
X_7567_ _7624_/A _7624_/C VGND VGND VPWR VPWR _7568_/B sky130_fd_sc_hd__nand2_2
X_4779_ _4842_/A VGND VGND VPWR VPWR _4798_/S sky130_fd_sc_hd__clkbuf_2
X_9306_ _9338_/CLK _9306_/D fanout369/X VGND VGND VPWR VPWR _9306_/Q sky130_fd_sc_hd__dfrtp_2
XFILLER_119_574 VGND VGND VPWR VPWR sky130_fd_sc_hd__decap_3
X_6518_ _6519_/B _6519_/C VGND VGND VPWR VPWR _6518_/Y sky130_fd_sc_hd__nor2_2
XFILLER_4_318 VGND VGND VPWR VPWR sky130_fd_sc_hd__fill_1
X_7498_ _7496_/A _7496_/B _7385_/A VGND VGND VPWR VPWR _7498_/X sky130_fd_sc_hd__a21o_2
XFILLER_106_6 VGND VGND VPWR VPWR sky130_fd_sc_hd__decap_3
X_9237_ _9333_/CLK _9237_/D wire417/X VGND VGND VPWR VPWR _9237_/Q sky130_fd_sc_hd__dfrtp_2
X_6449_ _6449_/A _6106_/B VGND VGND VPWR VPWR _6449_/X sky130_fd_sc_hd__or2b_2
XFILLER_122_739 VGND VGND VPWR VPWR sky130_fd_sc_hd__decap_3
XFILLER_121_205 VGND VGND VPWR VPWR sky130_fd_sc_hd__decap_3
X_9168_ _9168_/CLK _9168_/D fanout381/X VGND VGND VPWR VPWR _9168_/Q sky130_fd_sc_hd__dfrtp_2
XFILLER_121_238 VGND VGND VPWR VPWR sky130_fd_sc_hd__decap_3
XFILLER_102_430 VGND VGND VPWR VPWR sky130_fd_sc_hd__decap_3
X_8119_ _8119_/A _8121_/A VGND VGND VPWR VPWR _8119_/Y sky130_fd_sc_hd__nor2_2
XFILLER_0_557 VGND VGND VPWR VPWR sky130_fd_sc_hd__decap_3
XFILLER_57_12 VGND VGND VPWR VPWR sky130_fd_sc_hd__decap_3
XFILLER_130_750 VGND VGND VPWR VPWR sky130_fd_sc_hd__decap_3
XFILLER_102_452 VGND VGND VPWR VPWR sky130_fd_sc_hd__decap_3
X_9099_ _9236_/CLK _9099_/D fanout398/X VGND VGND VPWR VPWR _9099_/Q sky130_fd_sc_hd__dfrtp_2
XFILLER_130_772 VGND VGND VPWR VPWR sky130_fd_sc_hd__decap_3
XFILLER_75_314 VGND VGND VPWR VPWR sky130_fd_sc_hd__fill_1
XFILLER_57_45 VGND VGND VPWR VPWR sky130_fd_sc_hd__decap_3
XFILLER_48_539 VGND VGND VPWR VPWR sky130_fd_sc_hd__decap_3
XFILLER_102_496 VGND VGND VPWR VPWR sky130_fd_sc_hd__decap_3
XFILLER_75_358 VGND VGND VPWR VPWR sky130_fd_sc_hd__decap_3
XFILLER_28_230 VGND VGND VPWR VPWR sky130_fd_sc_hd__decap_3
XFILLER_56_550 VGND VGND VPWR VPWR sky130_fd_sc_hd__fill_1
XFILLER_56_561 VGND VGND VPWR VPWR sky130_fd_sc_hd__decap_3
XFILLER_44_701 VGND VGND VPWR VPWR sky130_fd_sc_hd__decap_3
XFILLER_29_775 VGND VGND VPWR VPWR sky130_fd_sc_hd__fill_2
XFILLER_113_51 VGND VGND VPWR VPWR sky130_fd_sc_hd__decap_3
XFILLER_71_542 VGND VGND VPWR VPWR sky130_fd_sc_hd__decap_3
XFILLER_71_564 VGND VGND VPWR VPWR sky130_fd_sc_hd__decap_3
XFILLER_43_277 VGND VGND VPWR VPWR sky130_fd_sc_hd__decap_3
XTAP_TAPCELL_ROW_61_1101 VGND VPWR sky130_fd_sc_hd__tapvpwrvgnd_1
XFILLER_71_597 VGND VGND VPWR VPWR sky130_fd_sc_hd__decap_3
XFILLER_31_439 VGND VGND VPWR VPWR sky130_fd_sc_hd__fill_2
XFILLER_43_299 VGND VGND VPWR VPWR sky130_fd_sc_hd__decap_3
XFILLER_24_480 VGND VGND VPWR VPWR sky130_fd_sc_hd__decap_3
XFILLER_24_491 VGND VGND VPWR VPWR sky130_fd_sc_hd__decap_3
XFILLER_12_664 VGND VGND VPWR VPWR sky130_fd_sc_hd__decap_3
XFILLER_8_668 VGND VGND VPWR VPWR sky130_fd_sc_hd__decap_3
XFILLER_22_70 VGND VGND VPWR VPWR sky130_fd_sc_hd__decap_3
XFILLER_7_167 VGND VGND VPWR VPWR sky130_fd_sc_hd__fill_1
XTAP_TAPCELL_ROW_113_1809 VGND VPWR sky130_fd_sc_hd__tapvpwrvgnd_1
XFILLER_125_544 VGND VGND VPWR VPWR sky130_fd_sc_hd__decap_3
XTAP_TAPCELL_ROW_59_1074 VGND VPWR sky130_fd_sc_hd__tapvpwrvgnd_1
XFILLER_3_340 VGND VGND VPWR VPWR sky130_fd_sc_hd__decap_3
XFILLER_98_417 VGND VGND VPWR VPWR sky130_fd_sc_hd__decap_3
XFILLER_98_85 VGND VGND VPWR VPWR sky130_fd_sc_hd__decap_3
XFILLER_3_384 VGND VGND VPWR VPWR sky130_fd_sc_hd__decap_3
XTAP_TAPCELL_ROW_72_1252 VGND VPWR sky130_fd_sc_hd__tapvpwrvgnd_1
XFILLER_105_290 VGND VGND VPWR VPWR sky130_fd_sc_hd__decap_3
XFILLER_78_141 VGND VGND VPWR VPWR sky130_fd_sc_hd__decap_3
XFILLER_121_750 VGND VGND VPWR VPWR sky130_fd_sc_hd__decap_3
XFILLER_94_601 VGND VGND VPWR VPWR sky130_fd_sc_hd__decap_3
XFILLER_79_686 VGND VGND VPWR VPWR sky130_fd_sc_hd__decap_3
XFILLER_21_6 VGND VGND VPWR VPWR sky130_fd_sc_hd__decap_3
XFILLER_78_174 VGND VGND VPWR VPWR sky130_fd_sc_hd__fill_1
XFILLER_39_539 VGND VGND VPWR VPWR sky130_fd_sc_hd__fill_2
XFILLER_66_336 VGND VGND VPWR VPWR sky130_fd_sc_hd__decap_3
XFILLER_94_667 VGND VGND VPWR VPWR sky130_fd_sc_hd__decap_3
XFILLER_47_561 VGND VGND VPWR VPWR sky130_fd_sc_hd__decap_3
XFILLER_34_200 VGND VGND VPWR VPWR sky130_fd_sc_hd__fill_1
XFILLER_19_274 VGND VGND VPWR VPWR sky130_fd_sc_hd__decap_3
XFILLER_35_745 VGND VGND VPWR VPWR sky130_fd_sc_hd__decap_3
XFILLER_19_296 VGND VGND VPWR VPWR sky130_fd_sc_hd__decap_3
XTAP_TAPCELL_ROW_124_1949 VGND VPWR sky130_fd_sc_hd__tapvpwrvgnd_1
X_5820_ _5973_/A _5820_/B _5820_/C VGND VGND VPWR VPWR _5821_/A sky130_fd_sc_hd__or3_2
XFILLER_50_726 VGND VGND VPWR VPWR sky130_fd_sc_hd__decap_3
XFILLER_22_417 VGND VGND VPWR VPWR sky130_fd_sc_hd__decap_3
X_5751_ _9205_/Q _5751_/B VGND VGND VPWR VPWR _5752_/B sky130_fd_sc_hd__xnor2_2
XFILLER_50_748 VGND VGND VPWR VPWR sky130_fd_sc_hd__decap_3
X_4702_ hold860/X _4702_/A1 _4714_/S VGND VGND VPWR VPWR _4703_/A sky130_fd_sc_hd__mux2_2
X_8470_ _8467_/Y _8469_/Y _8435_/A VGND VGND VPWR VPWR _8470_/X sky130_fd_sc_hd__o21a_2
X_5682_ _5682_/A _5682_/B VGND VGND VPWR VPWR _5685_/A sky130_fd_sc_hd__xnor2_2
XFILLER_30_461 VGND VGND VPWR VPWR sky130_fd_sc_hd__fill_2
XFILLER_8_50 VGND VGND VPWR VPWR sky130_fd_sc_hd__decap_3
X_7421_ _7421_/A _7590_/C _7421_/C _7421_/D VGND VGND VPWR VPWR _7436_/C sky130_fd_sc_hd__and4_4
XFILLER_30_483 VGND VGND VPWR VPWR sky130_fd_sc_hd__decap_3
X_4633_ _4633_/A VGND VGND VPWR VPWR _9066_/D sky130_fd_sc_hd__buf_1
XFILLER_128_360 VGND VGND VPWR VPWR sky130_fd_sc_hd__decap_3
XFILLER_116_500 VGND VGND VPWR VPWR sky130_fd_sc_hd__decap_3
X_7352_ _7468_/C _7469_/B _7469_/C VGND VGND VPWR VPWR _7353_/C sky130_fd_sc_hd__nand3_2
XFILLER_118_18 VGND VGND VPWR VPWR sky130_fd_sc_hd__decap_3
X_4564_ _9034_/Q hold908/X _4566_/S VGND VGND VPWR VPWR _4564_/X sky130_fd_sc_hd__mux2_2
XFILLER_128_371 VGND VGND VPWR VPWR sky130_fd_sc_hd__decap_3
XFILLER_118_29 VGND VGND VPWR VPWR sky130_fd_sc_hd__decap_3
XFILLER_116_533 VGND VGND VPWR VPWR sky130_fd_sc_hd__decap_3
X_6303_ _7083_/A _6717_/B VGND VGND VPWR VPWR _7117_/A sky130_fd_sc_hd__nand2_2
X_7283_ _6651_/A _6780_/B _6905_/Y _6524_/X _6517_/X VGND VGND VPWR VPWR _7283_/X
+ sky130_fd_sc_hd__o2111a_2
X_9022_ _9338_/CLK _9022_/D wire372/X VGND VGND VPWR VPWR _9022_/Q sky130_fd_sc_hd__dfrtp_2
XFILLER_89_428 VGND VGND VPWR VPWR sky130_fd_sc_hd__fill_2
X_6234_ _9314_/Q _6758_/C _5738_/S VGND VGND VPWR VPWR _6234_/Y sky130_fd_sc_hd__a21oi_2
X_6165_ _6174_/A _6174_/B _6011_/A VGND VGND VPWR VPWR _6292_/B sky130_fd_sc_hd__a21oi_2
XFILLER_85_612 VGND VGND VPWR VPWR sky130_fd_sc_hd__decap_3
X_5116_ _9069_/Q _5456_/B _5115_/X _9085_/Q VGND VGND VPWR VPWR _5123_/B sky130_fd_sc_hd__a22o_2
XFILLER_111_260 VGND VGND VPWR VPWR sky130_fd_sc_hd__decap_3
XFILLER_97_494 VGND VGND VPWR VPWR sky130_fd_sc_hd__decap_3
X_6096_ _6096_/A _6096_/B VGND VGND VPWR VPWR _6096_/Y sky130_fd_sc_hd__nor2_2
XFILLER_85_645 VGND VGND VPWR VPWR sky130_fd_sc_hd__decap_3
XFILLER_111_293 VGND VGND VPWR VPWR sky130_fd_sc_hd__decap_3
X_5047_ _5048_/B _5048_/C _9197_/Q VGND VGND VPWR VPWR _5047_/Y sky130_fd_sc_hd__o21ai_2
XFILLER_27_26 VGND VGND VPWR VPWR sky130_fd_sc_hd__decap_3
XFILLER_85_689 VGND VGND VPWR VPWR sky130_fd_sc_hd__decap_3
XFILLER_84_166 VGND VGND VPWR VPWR sky130_fd_sc_hd__decap_3
XFILLER_38_561 VGND VGND VPWR VPWR sky130_fd_sc_hd__decap_3
XFILLER_26_701 VGND VGND VPWR VPWR sky130_fd_sc_hd__fill_2
XFILLER_84_199 VGND VGND VPWR VPWR sky130_fd_sc_hd__decap_3
XFILLER_53_520 VGND VGND VPWR VPWR sky130_fd_sc_hd__decap_3
XFILLER_25_211 VGND VGND VPWR VPWR sky130_fd_sc_hd__decap_3
X_8806_ _8839_/A1 _8806_/A1 _8812_/S VGND VGND VPWR VPWR _8807_/A sky130_fd_sc_hd__mux2_2
XFILLER_53_564 VGND VGND VPWR VPWR sky130_fd_sc_hd__decap_3
XTAP_TAPCELL_ROW_36_762 VGND VPWR sky130_fd_sc_hd__tapvpwrvgnd_1
XFILLER_41_715 VGND VGND VPWR VPWR sky130_fd_sc_hd__decap_3
XFILLER_13_406 VGND VGND VPWR VPWR sky130_fd_sc_hd__fill_2
X_6998_ _6998_/A _6998_/B VGND VGND VPWR VPWR _7056_/B sky130_fd_sc_hd__xnor2_2
XTAP_TAPCELL_ROW_36_773 VGND VPWR sky130_fd_sc_hd__tapvpwrvgnd_1
XFILLER_53_586 VGND VGND VPWR VPWR sky130_fd_sc_hd__decap_3
XFILLER_40_203 VGND VGND VPWR VPWR sky130_fd_sc_hd__decap_3
XFILLER_43_25 VGND VGND VPWR VPWR sky130_fd_sc_hd__decap_3
X_5949_ _5949_/A _5949_/B VGND VGND VPWR VPWR _5949_/Y sky130_fd_sc_hd__nand2_2
X_8737_ _8737_/A _8737_/B VGND VGND VPWR VPWR _8770_/A sky130_fd_sc_hd__and2_2
XFILLER_80_394 VGND VGND VPWR VPWR sky130_fd_sc_hd__decap_3
XFILLER_43_47 VGND VGND VPWR VPWR sky130_fd_sc_hd__decap_3
XFILLER_40_225 VGND VGND VPWR VPWR sky130_fd_sc_hd__decap_3
X_8668_ _8729_/S _8668_/B VGND VGND VPWR VPWR _8669_/B sky130_fd_sc_hd__xnor2_2
XFILLER_21_483 VGND VGND VPWR VPWR sky130_fd_sc_hd__fill_2
X_7619_ _7619_/A _7619_/B VGND VGND VPWR VPWR _7754_/A sky130_fd_sc_hd__xor2_2
X_8599_ _9226_/Q _9225_/Q _8398_/B _8598_/X wire61/X VGND VGND VPWR VPWR _8599_/X
+ sky130_fd_sc_hd__a32o_2
XFILLER_126_319 VGND VGND VPWR VPWR sky130_fd_sc_hd__decap_3
XFILLER_107_500 VGND VGND VPWR VPWR sky130_fd_sc_hd__decap_3
XFILLER_107_511 VGND VGND VPWR VPWR sky130_fd_sc_hd__decap_3
XFILLER_119_371 VGND VGND VPWR VPWR sky130_fd_sc_hd__decap_3
XFILLER_119_382 VGND VGND VPWR VPWR sky130_fd_sc_hd__fill_2
XFILLER_4_126 VGND VGND VPWR VPWR sky130_fd_sc_hd__decap_3
XFILLER_119_393 VGND VGND VPWR VPWR sky130_fd_sc_hd__fill_2
XFILLER_104_3 VGND VGND VPWR VPWR sky130_fd_sc_hd__decap_3
XFILLER_107_555 VGND VGND VPWR VPWR sky130_fd_sc_hd__decap_3
XFILLER_4_148 VGND VGND VPWR VPWR sky130_fd_sc_hd__fill_2
XFILLER_107_588 VGND VGND VPWR VPWR sky130_fd_sc_hd__decap_3
XFILLER_108_73 VGND VGND VPWR VPWR sky130_fd_sc_hd__fill_2
XFILLER_122_536 VGND VGND VPWR VPWR sky130_fd_sc_hd__decap_3
XFILLER_0_343 VGND VGND VPWR VPWR sky130_fd_sc_hd__decap_3
XTAP_TAPCELL_ROW_128_2005 VGND VPWR sky130_fd_sc_hd__tapvpwrvgnd_1
XTAP_TAPCELL_ROW_128_2016 VGND VPWR sky130_fd_sc_hd__tapvpwrvgnd_1
XFILLER_0_365 VGND VGND VPWR VPWR sky130_fd_sc_hd__decap_3
XFILLER_68_88 VGND VGND VPWR VPWR sky130_fd_sc_hd__decap_3
XFILLER_76_645 VGND VGND VPWR VPWR sky130_fd_sc_hd__decap_3
XFILLER_124_50 VGND VGND VPWR VPWR sky130_fd_sc_hd__decap_3
XFILLER_76_667 VGND VGND VPWR VPWR sky130_fd_sc_hd__decap_3
XFILLER_124_83 VGND VGND VPWR VPWR sky130_fd_sc_hd__fill_1
XFILLER_91_615 VGND VGND VPWR VPWR sky130_fd_sc_hd__fill_1
XFILLER_75_166 VGND VGND VPWR VPWR sky130_fd_sc_hd__fill_2
XFILLER_29_561 VGND VGND VPWR VPWR sky130_fd_sc_hd__decap_3
XFILLER_17_701 VGND VGND VPWR VPWR sky130_fd_sc_hd__decap_3
XFILLER_124_94 VGND VGND VPWR VPWR sky130_fd_sc_hd__decap_3
XFILLER_90_103 VGND VGND VPWR VPWR sky130_fd_sc_hd__decap_3
XFILLER_16_200 VGND VGND VPWR VPWR sky130_fd_sc_hd__fill_2
XFILLER_90_125 VGND VGND VPWR VPWR sky130_fd_sc_hd__decap_3
XFILLER_16_211 VGND VGND VPWR VPWR sky130_fd_sc_hd__decap_3
XFILLER_56_391 VGND VGND VPWR VPWR sky130_fd_sc_hd__fill_2
XFILLER_44_542 VGND VGND VPWR VPWR sky130_fd_sc_hd__decap_3
XFILLER_17_756 VGND VGND VPWR VPWR sky130_fd_sc_hd__decap_3
XFILLER_17_70 VGND VGND VPWR VPWR sky130_fd_sc_hd__decap_3
XFILLER_16_244 VGND VGND VPWR VPWR sky130_fd_sc_hd__decap_3
XFILLER_44_564 VGND VGND VPWR VPWR sky130_fd_sc_hd__fill_2
XFILLER_32_715 VGND VGND VPWR VPWR sky130_fd_sc_hd__decap_3
XFILLER_32_726 VGND VGND VPWR VPWR sky130_fd_sc_hd__decap_3
XFILLER_90_9 VGND VGND VPWR VPWR sky130_fd_sc_hd__decap_3
XFILLER_129_102 VGND VGND VPWR VPWR sky130_fd_sc_hd__decap_3
XTAP_TAPCELL_ROW_14_467 VGND VPWR sky130_fd_sc_hd__tapvpwrvgnd_1
XFILLER_129_113 VGND VGND VPWR VPWR sky130_fd_sc_hd__decap_3
XFILLER_8_410 VGND VGND VPWR VPWR sky130_fd_sc_hd__fill_2
XFILLER_8_432 VGND VGND VPWR VPWR sky130_fd_sc_hd__fill_2
XFILLER_129_146 VGND VGND VPWR VPWR sky130_fd_sc_hd__decap_3
XFILLER_117_319 VGND VGND VPWR VPWR sky130_fd_sc_hd__decap_3
XFILLER_69_6 VGND VGND VPWR VPWR sky130_fd_sc_hd__decap_3
XFILLER_99_704 VGND VGND VPWR VPWR sky130_fd_sc_hd__fill_2
XFILLER_125_374 VGND VGND VPWR VPWR sky130_fd_sc_hd__decap_3
XFILLER_113_514 VGND VGND VPWR VPWR sky130_fd_sc_hd__decap_3
XFILLER_125_385 VGND VGND VPWR VPWR sky130_fd_sc_hd__decap_3
XFILLER_4_682 VGND VGND VPWR VPWR sky130_fd_sc_hd__decap_3
XFILLER_100_208 VGND VGND VPWR VPWR sky130_fd_sc_hd__decap_3
XFILLER_79_472 VGND VGND VPWR VPWR sky130_fd_sc_hd__decap_3
XFILLER_100_219 VGND VGND VPWR VPWR sky130_fd_sc_hd__decap_3
XFILLER_66_100 VGND VGND VPWR VPWR sky130_fd_sc_hd__decap_3
XFILLER_94_442 VGND VGND VPWR VPWR sky130_fd_sc_hd__decap_3
X_7970_ _8174_/A _6758_/B _4978_/Y VGND VGND VPWR VPWR _7970_/X sky130_fd_sc_hd__a21o_2
XFILLER_94_464 VGND VGND VPWR VPWR sky130_fd_sc_hd__decap_3
XFILLER_54_306 VGND VGND VPWR VPWR sky130_fd_sc_hd__fill_2
XFILLER_94_486 VGND VGND VPWR VPWR sky130_fd_sc_hd__decap_3
XFILLER_54_317 VGND VGND VPWR VPWR sky130_fd_sc_hd__decap_3
X_6921_ _6920_/A _6920_/B _6662_/X _6664_/B _6664_/C VGND VGND VPWR VPWR _6921_/X
+ sky130_fd_sc_hd__a32o_2
XFILLER_82_648 VGND VGND VPWR VPWR sky130_fd_sc_hd__decap_3
XTAP_TAPCELL_ROW_85_1432 VGND VPWR sky130_fd_sc_hd__tapvpwrvgnd_1
XFILLER_35_553 VGND VGND VPWR VPWR sky130_fd_sc_hd__decap_3
X_6852_ _6781_/X _6851_/X _7219_/S VGND VGND VPWR VPWR _6853_/A sky130_fd_sc_hd__mux2_2
XFILLER_81_169 VGND VGND VPWR VPWR sky130_fd_sc_hd__fill_2
XFILLER_62_361 VGND VGND VPWR VPWR sky130_fd_sc_hd__decap_3
X_5803_ _5803_/A _5930_/C _5803_/C VGND VGND VPWR VPWR _5803_/X sky130_fd_sc_hd__and3_2
XFILLER_90_692 VGND VGND VPWR VPWR sky130_fd_sc_hd__decap_3
XFILLER_62_383 VGND VGND VPWR VPWR sky130_fd_sc_hd__decap_3
XFILLER_35_597 VGND VGND VPWR VPWR sky130_fd_sc_hd__decap_3
XTAP_TAPCELL_ROW_33_721 VGND VPWR sky130_fd_sc_hd__tapvpwrvgnd_1
X_6783_ _6456_/A _6783_/A2 _6782_/X VGND VGND VPWR VPWR _6785_/A sky130_fd_sc_hd__o21ai_4
XTAP_TAPCELL_ROW_33_732 VGND VPWR sky130_fd_sc_hd__tapvpwrvgnd_1
XFILLER_23_759 VGND VGND VPWR VPWR sky130_fd_sc_hd__decap_3
X_8522_ _9223_/Q _8493_/A wire66/X _8562_/A VGND VGND VPWR VPWR _8522_/X sky130_fd_sc_hd__o211a_2
X_5734_ _9311_/Q _6758_/B _6758_/C _5066_/X _9155_/Q VGND VGND VPWR VPWR _5735_/C
+ sky130_fd_sc_hd__a32o_2
XFILLER_50_578 VGND VGND VPWR VPWR sky130_fd_sc_hd__decap_3
XFILLER_13_39 VGND VGND VPWR VPWR sky130_fd_sc_hd__fill_2
X_8453_ _8453_/A _8453_/B VGND VGND VPWR VPWR _8454_/B sky130_fd_sc_hd__nand2_2
X_5665_ _5034_/A _5663_/Y _5664_/Y _5034_/B VGND VGND VPWR VPWR _5671_/A sky130_fd_sc_hd__a22o_2
XFILLER_30_280 VGND VGND VPWR VPWR sky130_fd_sc_hd__decap_3
XFILLER_129_39 VGND VGND VPWR VPWR sky130_fd_sc_hd__decap_3
X_7404_ _7764_/A _7404_/B VGND VGND VPWR VPWR _7413_/B sky130_fd_sc_hd__nor2_2
X_4616_ _4616_/A VGND VGND VPWR VPWR _9058_/D sky130_fd_sc_hd__buf_1
X_8384_ _8385_/A _8384_/B VGND VGND VPWR VPWR _8459_/A sky130_fd_sc_hd__nand2_2
X_5596_ _5727_/A _5596_/B VGND VGND VPWR VPWR _5605_/B sky130_fd_sc_hd__xnor2_2
XFILLER_129_691 VGND VGND VPWR VPWR sky130_fd_sc_hd__decap_3
XPHY_EDGE_ROW_111_Right_111 VGND VGND VPWR VPWR sky130_fd_sc_hd__decap_3
X_7335_ _7099_/B _7317_/B _7313_/X VGND VGND VPWR VPWR _7336_/B sky130_fd_sc_hd__a21oi_2
XTAP_TAPCELL_ROW_96_1572 VGND VPWR sky130_fd_sc_hd__tapvpwrvgnd_1
X_4547_ _9015_/S VGND VGND VPWR VPWR _4566_/S sky130_fd_sc_hd__clkbuf_2
XTAP_TAPCELL_ROW_96_1583 VGND VPWR sky130_fd_sc_hd__tapvpwrvgnd_1
Xmax_cap140 _6741_/B VGND VGND VPWR VPWR _6616_/B sky130_fd_sc_hd__buf_2
XFILLER_2_619 VGND VGND VPWR VPWR sky130_fd_sc_hd__decap_3
Xmax_cap162 _5014_/A VGND VGND VPWR VPWR _6687_/B1 sky130_fd_sc_hd__clkbuf_2
Xmax_cap173 _6944_/A VGND VGND VPWR VPWR _6246_/A sky130_fd_sc_hd__clkbuf_2
X_7266_ _7263_/A _7265_/Y _7262_/X _7215_/A VGND VGND VPWR VPWR _7266_/X sky130_fd_sc_hd__o2bb2a_2
XFILLER_89_225 VGND VGND VPWR VPWR sky130_fd_sc_hd__decap_3
XFILLER_104_536 VGND VGND VPWR VPWR sky130_fd_sc_hd__decap_3
Xmax_cap184 _6703_/A VGND VGND VPWR VPWR _6305_/B sky130_fd_sc_hd__buf_2
Xmax_cap195 _8028_/A VGND VGND VPWR VPWR _7667_/A sky130_fd_sc_hd__buf_2
XFILLER_89_247 VGND VGND VPWR VPWR sky130_fd_sc_hd__decap_3
X_9005_ _9005_/A0 _9005_/A1 _9009_/S VGND VGND VPWR VPWR _9006_/A sky130_fd_sc_hd__mux2_2
X_6217_ _6216_/B _6216_/C _6369_/B VGND VGND VPWR VPWR _6218_/D sky130_fd_sc_hd__a21bo_2
X_7197_ _7681_/A _8031_/A _7196_/X _6886_/A VGND VGND VPWR VPWR _7197_/X sky130_fd_sc_hd__o2bb2a_2
XFILLER_58_612 VGND VGND VPWR VPWR sky130_fd_sc_hd__decap_3
XFILLER_38_25 VGND VGND VPWR VPWR sky130_fd_sc_hd__decap_3
X_6148_ _6055_/X _6056_/X _6008_/B VGND VGND VPWR VPWR _6149_/B sky130_fd_sc_hd__a21oi_2
XFILLER_100_731 VGND VGND VPWR VPWR sky130_fd_sc_hd__decap_3
Xhold1110 _9282_/Q VGND VGND VPWR VPWR _8877_/A0 sky130_fd_sc_hd__dlygate4sd3_1
XFILLER_58_645 VGND VGND VPWR VPWR sky130_fd_sc_hd__decap_3
Xhold1121 _4602_/X VGND VGND VPWR VPWR _4603_/A sky130_fd_sc_hd__dlygate4sd3_1
XFILLER_38_58 VGND VGND VPWR VPWR sky130_fd_sc_hd__decap_3
Xload_slew390 fanout389/X VGND VGND VPWR VPWR load_slew390/X sky130_fd_sc_hd__buf_4
Xhold1132 _9137_/Q VGND VGND VPWR VPWR _4815_/A1 sky130_fd_sc_hd__dlygate4sd3_1
Xhold1143 _9089_/Q VGND VGND VPWR VPWR _4681_/A0 sky130_fd_sc_hd__dlygate4sd3_1
XFILLER_57_155 VGND VGND VPWR VPWR sky130_fd_sc_hd__decap_3
X_6079_ _6395_/A _7676_/C _6076_/A VGND VGND VPWR VPWR _6079_/Y sky130_fd_sc_hd__a21oi_2
Xhold1154 _8988_/X VGND VGND VPWR VPWR _8989_/A sky130_fd_sc_hd__dlygate4sd3_1
XFILLER_73_615 VGND VGND VPWR VPWR sky130_fd_sc_hd__fill_1
Xhold1165 _9068_/Q VGND VGND VPWR VPWR _4670_/A1 sky130_fd_sc_hd__dlygate4sd3_1
Xhold1176 _9267_/Q VGND VGND VPWR VPWR _8846_/A0 sky130_fd_sc_hd__dlygate4sd3_1
XFILLER_85_486 VGND VGND VPWR VPWR sky130_fd_sc_hd__decap_3
Xhold1187 _4725_/X VGND VGND VPWR VPWR _4726_/A sky130_fd_sc_hd__dlygate4sd3_1
XFILLER_72_114 VGND VGND VPWR VPWR sky130_fd_sc_hd__decap_3
XFILLER_73_648 VGND VGND VPWR VPWR sky130_fd_sc_hd__decap_3
Xhold1198 _9079_/Q VGND VGND VPWR VPWR _4693_/A1 sky130_fd_sc_hd__dlygate4sd3_1
XFILLER_38_380 VGND VGND VPWR VPWR sky130_fd_sc_hd__decap_3
XFILLER_26_520 VGND VGND VPWR VPWR sky130_fd_sc_hd__decap_3
XFILLER_26_542 VGND VGND VPWR VPWR sky130_fd_sc_hd__decap_3
XFILLER_54_35 VGND VGND VPWR VPWR sky130_fd_sc_hd__decap_3
XFILLER_60_309 VGND VGND VPWR VPWR sky130_fd_sc_hd__decap_3
XFILLER_14_704 VGND VGND VPWR VPWR sky130_fd_sc_hd__decap_3
XFILLER_81_681 VGND VGND VPWR VPWR sky130_fd_sc_hd__fill_1
XFILLER_53_372 VGND VGND VPWR VPWR sky130_fd_sc_hd__decap_3
XFILLER_41_523 VGND VGND VPWR VPWR sky130_fd_sc_hd__decap_3
XFILLER_14_737 VGND VGND VPWR VPWR sky130_fd_sc_hd__decap_3
XFILLER_80_180 VGND VGND VPWR VPWR sky130_fd_sc_hd__fill_2
XFILLER_80_191 VGND VGND VPWR VPWR sky130_fd_sc_hd__decap_3
XFILLER_13_236 VGND VGND VPWR VPWR sky130_fd_sc_hd__fill_1
XFILLER_41_556 VGND VGND VPWR VPWR sky130_fd_sc_hd__decap_3
XFILLER_110_41 VGND VGND VPWR VPWR sky130_fd_sc_hd__decap_3
XFILLER_9_207 VGND VGND VPWR VPWR sky130_fd_sc_hd__decap_3
XFILLER_110_96 VGND VGND VPWR VPWR sky130_fd_sc_hd__decap_3
XTAP_TAPCELL_ROW_11_426 VGND VPWR sky130_fd_sc_hd__tapvpwrvgnd_1
XFILLER_127_617 VGND VGND VPWR VPWR sky130_fd_sc_hd__decap_3
Xrebuffer540 _8295_/S VGND VGND VPWR VPWR _8299_/A sky130_fd_sc_hd__buf_2
Xrebuffer551 _6384_/B1 VGND VGND VPWR VPWR _6516_/A_N sky130_fd_sc_hd__buf_2
XFILLER_5_413 VGND VGND VPWR VPWR sky130_fd_sc_hd__fill_2
XFILLER_126_127 VGND VGND VPWR VPWR sky130_fd_sc_hd__decap_3
Xrebuffer562 _8275_/B VGND VGND VPWR VPWR _8304_/A_N sky130_fd_sc_hd__buf_2
Xrebuffer573 _4930_/B_N VGND VGND VPWR VPWR _4921_/B sky130_fd_sc_hd__buf_2
Xrebuffer584 _5119_/S VGND VGND VPWR VPWR _5180_/S sky130_fd_sc_hd__buf_2
XFILLER_5_446 VGND VGND VPWR VPWR sky130_fd_sc_hd__fill_2
XFILLER_119_72 VGND VGND VPWR VPWR sky130_fd_sc_hd__decap_3
Xrebuffer595 _6385_/A VGND VGND VPWR VPWR _6384_/B1 sky130_fd_sc_hd__buf_2
XFILLER_5_457 VGND VGND VPWR VPWR sky130_fd_sc_hd__decap_3
XFILLER_107_363 VGND VGND VPWR VPWR sky130_fd_sc_hd__decap_3
XFILLER_5_479 VGND VGND VPWR VPWR sky130_fd_sc_hd__decap_3
XTAP_TAPCELL_ROW_56_1033 VGND VPWR sky130_fd_sc_hd__tapvpwrvgnd_1
XFILLER_107_385 VGND VGND VPWR VPWR sky130_fd_sc_hd__decap_3
XTAP_TAPCELL_ROW_56_1044 VGND VPWR sky130_fd_sc_hd__tapvpwrvgnd_1
XFILLER_122_322 VGND VGND VPWR VPWR sky130_fd_sc_hd__decap_3
XPHY_EDGE_ROW_118_Left_249 VGND VGND VPWR VPWR sky130_fd_sc_hd__decap_3
XFILLER_1_641 VGND VGND VPWR VPWR sky130_fd_sc_hd__decap_3
XFILLER_96_729 VGND VGND VPWR VPWR sky130_fd_sc_hd__fill_2
XFILLER_122_377 VGND VGND VPWR VPWR sky130_fd_sc_hd__fill_1
XFILLER_95_217 VGND VGND VPWR VPWR sky130_fd_sc_hd__decap_3
XFILLER_0_162 VGND VGND VPWR VPWR sky130_fd_sc_hd__decap_3
XFILLER_1_685 VGND VGND VPWR VPWR sky130_fd_sc_hd__decap_3
XFILLER_122_388 VGND VGND VPWR VPWR sky130_fd_sc_hd__decap_3
XFILLER_48_100 VGND VGND VPWR VPWR sky130_fd_sc_hd__decap_3
XFILLER_49_645 VGND VGND VPWR VPWR sky130_fd_sc_hd__decap_3
XFILLER_0_195 VGND VGND VPWR VPWR sky130_fd_sc_hd__fill_1
XFILLER_76_475 VGND VGND VPWR VPWR sky130_fd_sc_hd__fill_1
XFILLER_64_615 VGND VGND VPWR VPWR sky130_fd_sc_hd__decap_3
XFILLER_48_177 VGND VGND VPWR VPWR sky130_fd_sc_hd__decap_3
XFILLER_91_423 VGND VGND VPWR VPWR sky130_fd_sc_hd__decap_3
XFILLER_64_648 VGND VGND VPWR VPWR sky130_fd_sc_hd__decap_3
XFILLER_28_80 VGND VGND VPWR VPWR sky130_fd_sc_hd__decap_3
XTAP_TAPCELL_ROW_19_537 VGND VPWR sky130_fd_sc_hd__tapvpwrvgnd_1
XFILLER_29_380 VGND VGND VPWR VPWR sky130_fd_sc_hd__decap_3
XFILLER_63_147 VGND VGND VPWR VPWR sky130_fd_sc_hd__decap_3
XFILLER_63_169 VGND VGND VPWR VPWR sky130_fd_sc_hd__fill_2
XFILLER_17_564 VGND VGND VPWR VPWR sky130_fd_sc_hd__decap_3
XTAP_TAPCELL_ROW_121_1919 VGND VPWR sky130_fd_sc_hd__tapvpwrvgnd_1
XFILLER_72_670 VGND VGND VPWR VPWR sky130_fd_sc_hd__decap_3
XTAP_TAPCELL_ROW_67_1184 VGND VPWR sky130_fd_sc_hd__tapvpwrvgnd_1
XPHY_EDGE_ROW_127_Left_258 VGND VGND VPWR VPWR sky130_fd_sc_hd__decap_3
XFILLER_20_707 VGND VGND VPWR VPWR sky130_fd_sc_hd__decap_3
XFILLER_32_589 VGND VGND VPWR VPWR sky130_fd_sc_hd__decap_3
XTAP_TAPCELL_ROW_80_1362 VGND VPWR sky130_fd_sc_hd__tapvpwrvgnd_1
XFILLER_9_741 VGND VGND VPWR VPWR sky130_fd_sc_hd__decap_3
XFILLER_9_774 VGND VGND VPWR VPWR sky130_fd_sc_hd__decap_3
XFILLER_8_251 VGND VGND VPWR VPWR sky130_fd_sc_hd__fill_1
XFILLER_8_262 VGND VGND VPWR VPWR sky130_fd_sc_hd__decap_3
XFILLER_117_105 VGND VGND VPWR VPWR sky130_fd_sc_hd__decap_3
X_5450_ _5450_/A _5450_/B VGND VGND VPWR VPWR _5451_/B sky130_fd_sc_hd__xor2_2
XFILLER_117_116 VGND VGND VPWR VPWR sky130_fd_sc_hd__fill_2
XFILLER_8_295 VGND VGND VPWR VPWR sky130_fd_sc_hd__fill_1
X_5381_ _9324_/Q _9120_/Q _5384_/A VGND VGND VPWR VPWR _5381_/X sky130_fd_sc_hd__mux2_2
XFILLER_126_672 VGND VGND VPWR VPWR sky130_fd_sc_hd__decap_3
X_7120_ _6989_/A _6989_/B _6990_/B VGND VGND VPWR VPWR _7120_/X sky130_fd_sc_hd__o21a_2
XFILLER_99_523 VGND VGND VPWR VPWR sky130_fd_sc_hd__decap_3
XFILLER_5_51 VGND VGND VPWR VPWR sky130_fd_sc_hd__decap_3
XFILLER_113_311 VGND VGND VPWR VPWR sky130_fd_sc_hd__decap_3
XFILLER_99_545 VGND VGND VPWR VPWR sky130_fd_sc_hd__decap_3
XFILLER_4_490 VGND VGND VPWR VPWR sky130_fd_sc_hd__decap_3
XFILLER_125_193 VGND VGND VPWR VPWR sky130_fd_sc_hd__decap_3
X_7051_ _6939_/A _6617_/A _8406_/A _7050_/Y VGND VGND VPWR VPWR _7051_/X sky130_fd_sc_hd__o211a_2
XFILLER_87_729 VGND VGND VPWR VPWR sky130_fd_sc_hd__decap_3
XFILLER_101_528 VGND VGND VPWR VPWR sky130_fd_sc_hd__decap_3
X_6002_ _9206_/Q _6249_/A _8315_/A VGND VGND VPWR VPWR _6003_/C sky130_fd_sc_hd__a21oi_2
XFILLER_113_399 VGND VGND VPWR VPWR sky130_fd_sc_hd__decap_3
XFILLER_67_431 VGND VGND VPWR VPWR sky130_fd_sc_hd__decap_3
XFILLER_27_328 VGND VGND VPWR VPWR sky130_fd_sc_hd__decap_3
X_7953_ _7953_/A _8070_/C VGND VGND VPWR VPWR _7954_/B sky130_fd_sc_hd__xnor2_2
XFILLER_55_659 VGND VGND VPWR VPWR sky130_fd_sc_hd__decap_3
XFILLER_82_467 VGND VGND VPWR VPWR sky130_fd_sc_hd__decap_3
X_6904_ hold809/X _6903_/X _7560_/S VGND VGND VPWR VPWR _6904_/X sky130_fd_sc_hd__mux2_2
XFILLER_42_309 VGND VGND VPWR VPWR sky130_fd_sc_hd__decap_3
X_7884_ _7884_/A _7884_/B VGND VGND VPWR VPWR _8009_/B sky130_fd_sc_hd__nand2_2
X_6835_ _6835_/A _6835_/B VGND VGND VPWR VPWR _6900_/A sky130_fd_sc_hd__xnor2_2
XFILLER_62_180 VGND VGND VPWR VPWR sky130_fd_sc_hd__decap_3
XFILLER_24_27 VGND VGND VPWR VPWR sky130_fd_sc_hd__fill_1
XFILLER_23_545 VGND VGND VPWR VPWR sky130_fd_sc_hd__decap_3
XFILLER_24_38 VGND VGND VPWR VPWR sky130_fd_sc_hd__decap_3
XFILLER_23_567 VGND VGND VPWR VPWR sky130_fd_sc_hd__decap_3
X_6766_ _6934_/B _6766_/B VGND VGND VPWR VPWR _6767_/B sky130_fd_sc_hd__xnor2_2
XFILLER_11_729 VGND VGND VPWR VPWR sky130_fd_sc_hd__decap_3
XFILLER_50_386 VGND VGND VPWR VPWR sky130_fd_sc_hd__decap_3
XTAP_TAPCELL_ROW_98_1601 VGND VPWR sky130_fd_sc_hd__tapvpwrvgnd_1
XFILLER_10_228 VGND VGND VPWR VPWR sky130_fd_sc_hd__fill_1
X_5717_ _5444_/Y _7794_/B _5737_/B VGND VGND VPWR VPWR _5718_/C sky130_fd_sc_hd__o21ai_2
X_8505_ _8454_/A _8453_/A _8504_/Y VGND VGND VPWR VPWR _8511_/B sky130_fd_sc_hd__a21o_2
XFILLER_109_617 VGND VGND VPWR VPWR sky130_fd_sc_hd__decap_3
X_6697_ _6926_/A _6926_/B _6697_/C VGND VGND VPWR VPWR _6699_/B sky130_fd_sc_hd__nand3_4
X_5648_ _5648_/A _5648_/B VGND VGND VPWR VPWR _5649_/B sky130_fd_sc_hd__xnor2_2
X_8436_ wire66/X VGND VGND VPWR VPWR _8560_/B sky130_fd_sc_hd__clkbuf_1
X_8367_ _8367_/A _8367_/B VGND VGND VPWR VPWR _8374_/B sky130_fd_sc_hd__xnor2_2
X_5579_ _5443_/A _5050_/A _5446_/A VGND VGND VPWR VPWR _5579_/Y sky130_fd_sc_hd__a21oi_2
XFILLER_123_108 VGND VGND VPWR VPWR sky130_fd_sc_hd__decap_3
XFILLER_123_119 VGND VGND VPWR VPWR sky130_fd_sc_hd__decap_3
XFILLER_117_683 VGND VGND VPWR VPWR sky130_fd_sc_hd__decap_3
X_7318_ _7088_/A _7088_/B _7313_/X VGND VGND VPWR VPWR _7318_/X sky130_fd_sc_hd__a21bo_2
X_8298_ _8299_/A _8278_/X _8283_/B VGND VGND VPWR VPWR _8298_/Y sky130_fd_sc_hd__o21ai_2
X_7249_ _7243_/A _7243_/B input16/X _7532_/B1 _7728_/A VGND VGND VPWR VPWR _7249_/X
+ sky130_fd_sc_hd__o2111a_2
XFILLER_77_206 VGND VGND VPWR VPWR sky130_fd_sc_hd__decap_3
XFILLER_49_57 VGND VGND VPWR VPWR sky130_fd_sc_hd__decap_3
XFILLER_104_388 VGND VGND VPWR VPWR sky130_fd_sc_hd__decap_3
XFILLER_86_751 VGND VGND VPWR VPWR sky130_fd_sc_hd__decap_3
XFILLER_58_442 VGND VGND VPWR VPWR sky130_fd_sc_hd__decap_3
XFILLER_86_773 VGND VGND VPWR VPWR sky130_fd_sc_hd__decap_3
XFILLER_85_261 VGND VGND VPWR VPWR sky130_fd_sc_hd__fill_1
XFILLER_46_626 VGND VGND VPWR VPWR sky130_fd_sc_hd__decap_3
XFILLER_105_85 VGND VGND VPWR VPWR sky130_fd_sc_hd__decap_3
XFILLER_18_328 VGND VGND VPWR VPWR sky130_fd_sc_hd__decap_3
XFILLER_85_294 VGND VGND VPWR VPWR sky130_fd_sc_hd__fill_2
XFILLER_73_434 VGND VGND VPWR VPWR sky130_fd_sc_hd__fill_1
XFILLER_46_648 VGND VGND VPWR VPWR sky130_fd_sc_hd__decap_3
XFILLER_45_125 VGND VGND VPWR VPWR sky130_fd_sc_hd__decap_3
XFILLER_45_136 VGND VGND VPWR VPWR sky130_fd_sc_hd__fill_1
XTAP_TAPCELL_ROW_107_1730 VGND VPWR sky130_fd_sc_hd__tapvpwrvgnd_1
XFILLER_73_467 VGND VGND VPWR VPWR sky130_fd_sc_hd__decap_3
XFILLER_61_607 VGND VGND VPWR VPWR sky130_fd_sc_hd__decap_3
XFILLER_45_169 VGND VGND VPWR VPWR sky130_fd_sc_hd__decap_3
XFILLER_26_350 VGND VGND VPWR VPWR sky130_fd_sc_hd__decap_3
XFILLER_54_670 VGND VGND VPWR VPWR sky130_fd_sc_hd__decap_3
XFILLER_121_51 VGND VGND VPWR VPWR sky130_fd_sc_hd__decap_3
XFILLER_26_383 VGND VGND VPWR VPWR sky130_fd_sc_hd__decap_3
XFILLER_60_139 VGND VGND VPWR VPWR sky130_fd_sc_hd__fill_1
XFILLER_41_331 VGND VGND VPWR VPWR sky130_fd_sc_hd__decap_3
XFILLER_14_545 VGND VGND VPWR VPWR sky130_fd_sc_hd__decap_3
XFILLER_121_84 VGND VGND VPWR VPWR sky130_fd_sc_hd__decap_3
XFILLER_10_740 VGND VGND VPWR VPWR sky130_fd_sc_hd__decap_3
XFILLER_6_722 VGND VGND VPWR VPWR sky130_fd_sc_hd__decap_3
XFILLER_127_447 VGND VGND VPWR VPWR sky130_fd_sc_hd__fill_1
XFILLER_6_755 VGND VGND VPWR VPWR sky130_fd_sc_hd__fill_1
XTAP_TAPCELL_ROW_118_1870 VGND VPWR sky130_fd_sc_hd__tapvpwrvgnd_1
XFILLER_6_766 VGND VGND VPWR VPWR sky130_fd_sc_hd__decap_3
XFILLER_5_243 VGND VGND VPWR VPWR sky130_fd_sc_hd__decap_3
XFILLER_108_672 VGND VGND VPWR VPWR sky130_fd_sc_hd__decap_3
XTAP_TAPCELL_ROW_118_1881 VGND VPWR sky130_fd_sc_hd__tapvpwrvgnd_1
XFILLER_5_287 VGND VGND VPWR VPWR sky130_fd_sc_hd__decap_3
XFILLER_30_81 VGND VGND VPWR VPWR sky130_fd_sc_hd__decap_3
XFILLER_122_130 VGND VGND VPWR VPWR sky130_fd_sc_hd__decap_3
XFILLER_123_664 VGND VGND VPWR VPWR sky130_fd_sc_hd__decap_3
XFILLER_122_141 VGND VGND VPWR VPWR sky130_fd_sc_hd__decap_3
XFILLER_96_515 VGND VGND VPWR VPWR sky130_fd_sc_hd__fill_2
XFILLER_1_460 VGND VGND VPWR VPWR sky130_fd_sc_hd__decap_3
XFILLER_123_697 VGND VGND VPWR VPWR sky130_fd_sc_hd__fill_2
XFILLER_68_228 VGND VGND VPWR VPWR sky130_fd_sc_hd__fill_2
XFILLER_122_174 VGND VGND VPWR VPWR sky130_fd_sc_hd__decap_3
XFILLER_1_482 VGND VGND VPWR VPWR sky130_fd_sc_hd__fill_2
XFILLER_96_559 VGND VGND VPWR VPWR sky130_fd_sc_hd__decap_3
XFILLER_110_336 VGND VGND VPWR VPWR sky130_fd_sc_hd__decap_3
XFILLER_110_347 VGND VGND VPWR VPWR sky130_fd_sc_hd__decap_3
XFILLER_77_751 VGND VGND VPWR VPWR sky130_fd_sc_hd__decap_3
XFILLER_39_90 VGND VGND VPWR VPWR sky130_fd_sc_hd__decap_3
Xinput8 sample_in[15] VGND VGND VPWR VPWR input8/X sky130_fd_sc_hd__clkdlybuf4s25_1
XFILLER_49_475 VGND VGND VPWR VPWR sky130_fd_sc_hd__decap_3
XFILLER_37_615 VGND VGND VPWR VPWR sky130_fd_sc_hd__fill_1
XTAP_TAPCELL_ROW_69_1213 VGND VPWR sky130_fd_sc_hd__tapvpwrvgnd_1
XFILLER_36_103 VGND VGND VPWR VPWR sky130_fd_sc_hd__fill_2
XFILLER_37_637 VGND VGND VPWR VPWR sky130_fd_sc_hd__decap_3
XFILLER_91_220 VGND VGND VPWR VPWR sky130_fd_sc_hd__decap_3
XFILLER_24_309 VGND VGND VPWR VPWR sky130_fd_sc_hd__decap_3
X_4950_ _8175_/A VGND VGND VPWR VPWR _8780_/A sky130_fd_sc_hd__inv_2
XFILLER_17_350 VGND VGND VPWR VPWR sky130_fd_sc_hd__fill_1
XFILLER_64_489 VGND VGND VPWR VPWR sky130_fd_sc_hd__decap_3
XFILLER_44_180 VGND VGND VPWR VPWR sky130_fd_sc_hd__decap_3
X_4881_ _9212_/Q _4899_/B VGND VGND VPWR VPWR _4881_/Y sky130_fd_sc_hd__nor2_2
XFILLER_60_651 VGND VGND VPWR VPWR sky130_fd_sc_hd__decap_3
X_6620_ _8066_/B _6620_/B VGND VGND VPWR VPWR _6621_/B sky130_fd_sc_hd__xnor2_2
XTAP_TAPCELL_ROW_43_860 VGND VPWR sky130_fd_sc_hd__tapvpwrvgnd_1
XFILLER_60_673 VGND VGND VPWR VPWR sky130_fd_sc_hd__fill_1
XFILLER_60_695 VGND VGND VPWR VPWR sky130_fd_sc_hd__decap_3
X_6551_ _5201_/A _7604_/A _6549_/X _6550_/X VGND VGND VPWR VPWR _6692_/A sky130_fd_sc_hd__o31a_4
XFILLER_20_548 VGND VGND VPWR VPWR sky130_fd_sc_hd__decap_3
X_5502_ _5950_/A _5656_/A VGND VGND VPWR VPWR _5503_/C sky130_fd_sc_hd__nor2_2
XFILLER_9_571 VGND VGND VPWR VPWR sky130_fd_sc_hd__fill_1
X_9270_ _9343_/CLK _9270_/D load_slew401/X VGND VGND VPWR VPWR _9270_/Q sky130_fd_sc_hd__dfrtp_2
X_6482_ _6482_/A _7877_/A VGND VGND VPWR VPWR _6793_/B sky130_fd_sc_hd__xnor2_2
XFILLER_118_436 VGND VGND VPWR VPWR sky130_fd_sc_hd__decap_3
X_8221_ _8217_/Y _8219_/X _8220_/X VGND VGND VPWR VPWR _8276_/B sky130_fd_sc_hd__o21a_2
X_5433_ _5433_/A _5433_/B VGND VGND VPWR VPWR _5434_/B sky130_fd_sc_hd__xor2_2
XFILLER_10_18 VGND VGND VPWR VPWR sky130_fd_sc_hd__decap_3
XFILLER_105_119 VGND VGND VPWR VPWR sky130_fd_sc_hd__decap_3
XFILLER_10_29 VGND VGND VPWR VPWR sky130_fd_sc_hd__decap_3
XTAP_TAPCELL_ROW_93_1531 VGND VPWR sky130_fd_sc_hd__tapvpwrvgnd_1
XTAP_TAPCELL_ROW_93_1542 VGND VPWR sky130_fd_sc_hd__tapvpwrvgnd_1
X_8152_ _8150_/X _8151_/X _8233_/B2 VGND VGND VPWR VPWR _8152_/X sky130_fd_sc_hd__o21a_2
X_5364_ _5360_/Y _5440_/A _5363_/Y _7407_/A VGND VGND VPWR VPWR _5364_/X sky130_fd_sc_hd__o2bb2a_2
XFILLER_126_18 VGND VGND VPWR VPWR sky130_fd_sc_hd__decap_3
XFILLER_126_29 VGND VGND VPWR VPWR sky130_fd_sc_hd__decap_3
X_7103_ _7103_/A _7103_/B _7103_/C VGND VGND VPWR VPWR _7103_/Y sky130_fd_sc_hd__nand3_2
X_8083_ _8271_/A _8083_/B VGND VGND VPWR VPWR _8083_/Y sky130_fd_sc_hd__nand2_2
XFILLER_114_686 VGND VGND VPWR VPWR sky130_fd_sc_hd__decap_3
XFILLER_87_537 VGND VGND VPWR VPWR sky130_fd_sc_hd__decap_3
X_7034_ _7034_/A _6978_/X VGND VGND VPWR VPWR _7038_/B sky130_fd_sc_hd__or2b_2
XFILLER_68_740 VGND VGND VPWR VPWR sky130_fd_sc_hd__fill_1
XFILLER_19_27 VGND VGND VPWR VPWR sky130_fd_sc_hd__decap_3
XFILLER_28_604 VGND VGND VPWR VPWR sky130_fd_sc_hd__decap_3
XFILLER_95_581 VGND VGND VPWR VPWR sky130_fd_sc_hd__decap_3
X_8985_ _8985_/A VGND VGND VPWR VPWR _9333_/D sky130_fd_sc_hd__buf_1
X_7936_ _8050_/A _7936_/B VGND VGND VPWR VPWR _7936_/Y sky130_fd_sc_hd__nor2_2
XFILLER_55_489 VGND VGND VPWR VPWR sky130_fd_sc_hd__fill_2
XFILLER_42_106 VGND VGND VPWR VPWR sky130_fd_sc_hd__decap_3
X_7867_ _7867_/A _8018_/A VGND VGND VPWR VPWR _7869_/B sky130_fd_sc_hd__nor2_2
XFILLER_51_651 VGND VGND VPWR VPWR sky130_fd_sc_hd__decap_3
XFILLER_51_673 VGND VGND VPWR VPWR sky130_fd_sc_hd__fill_1
X_6818_ _7676_/C _5537_/B _5674_/B VGND VGND VPWR VPWR _7176_/A sky130_fd_sc_hd__o21ai_2
XFILLER_50_150 VGND VGND VPWR VPWR sky130_fd_sc_hd__decap_3
XTAP_TAPCELL_ROW_102_1660 VGND VPWR sky130_fd_sc_hd__tapvpwrvgnd_1
X_7798_ _7609_/A _7608_/B _7797_/Y VGND VGND VPWR VPWR _7809_/A sky130_fd_sc_hd__o21ba_2
Xwire406 wire406/A VGND VGND VPWR VPWR wire406/X sky130_fd_sc_hd__clkbuf_4
Xwire417 wire417/A VGND VGND VPWR VPWR wire417/X sky130_fd_sc_hd__clkbuf_4
XFILLER_7_508 VGND VGND VPWR VPWR sky130_fd_sc_hd__fill_1
X_6749_ _9129_/Q wire172/X _5457_/X _9301_/Q VGND VGND VPWR VPWR _6749_/X sky130_fd_sc_hd__a22o_2
XFILLER_51_69 VGND VGND VPWR VPWR sky130_fd_sc_hd__fill_2
XTAP_TAPCELL_ROW_21_565 VGND VPWR sky130_fd_sc_hd__tapvpwrvgnd_1
XFILLER_109_447 VGND VGND VPWR VPWR sky130_fd_sc_hd__fill_1
XFILLER_109_458 VGND VGND VPWR VPWR sky130_fd_sc_hd__decap_3
X_8419_ _8418_/B _8421_/B _8418_/Y VGND VGND VPWR VPWR _8420_/B sky130_fd_sc_hd__o21a_2
XFILLER_3_703 VGND VGND VPWR VPWR sky130_fd_sc_hd__decap_3
XFILLER_3_747 VGND VGND VPWR VPWR sky130_fd_sc_hd__decap_3
XFILLER_105_653 VGND VGND VPWR VPWR sky130_fd_sc_hd__fill_2
XFILLER_104_130 VGND VGND VPWR VPWR sky130_fd_sc_hd__fill_2
XTAP_TAPCELL_ROW_53_1003 VGND VPWR sky130_fd_sc_hd__tapvpwrvgnd_1
XFILLER_105_697 VGND VGND VPWR VPWR sky130_fd_sc_hd__decap_3
XFILLER_120_634 VGND VGND VPWR VPWR sky130_fd_sc_hd__decap_3
XFILLER_116_62 VGND VGND VPWR VPWR sky130_fd_sc_hd__decap_3
XFILLER_78_548 VGND VGND VPWR VPWR sky130_fd_sc_hd__decap_3
XFILLER_120_645 VGND VGND VPWR VPWR sky130_fd_sc_hd__decap_3
XFILLER_19_604 VGND VGND VPWR VPWR sky130_fd_sc_hd__decap_3
XFILLER_58_250 VGND VGND VPWR VPWR sky130_fd_sc_hd__fill_2
XFILLER_86_570 VGND VGND VPWR VPWR sky130_fd_sc_hd__decap_3
XFILLER_76_77 VGND VGND VPWR VPWR sky130_fd_sc_hd__decap_3
XFILLER_74_710 VGND VGND VPWR VPWR sky130_fd_sc_hd__decap_3
XFILLER_19_626 VGND VGND VPWR VPWR sky130_fd_sc_hd__decap_3
XFILLER_76_88 VGND VGND VPWR VPWR sky130_fd_sc_hd__fill_1
XFILLER_46_412 VGND VGND VPWR VPWR sky130_fd_sc_hd__fill_1
XFILLER_86_592 VGND VGND VPWR VPWR sky130_fd_sc_hd__decap_3
XFILLER_18_147 VGND VGND VPWR VPWR sky130_fd_sc_hd__decap_3
XFILLER_73_253 VGND VGND VPWR VPWR sky130_fd_sc_hd__decap_3
XFILLER_34_618 VGND VGND VPWR VPWR sky130_fd_sc_hd__decap_3
XTAP_TAPCELL_ROW_29_676 VGND VPWR sky130_fd_sc_hd__tapvpwrvgnd_1
XFILLER_46_489 VGND VGND VPWR VPWR sky130_fd_sc_hd__decap_3
XTAP_TAPCELL_ROW_1_290 VGND VPWR sky130_fd_sc_hd__tapvpwrvgnd_1
XFILLER_33_128 VGND VGND VPWR VPWR sky130_fd_sc_hd__decap_3
XTAP_TAPCELL_ROW_64_1143 VGND VPWR sky130_fd_sc_hd__tapvpwrvgnd_1
XFILLER_42_651 VGND VGND VPWR VPWR sky130_fd_sc_hd__decap_3
XFILLER_42_662 VGND VGND VPWR VPWR sky130_fd_sc_hd__decap_3
XFILLER_25_70 VGND VGND VPWR VPWR sky130_fd_sc_hd__fill_2
XFILLER_128_701 VGND VGND VPWR VPWR sky130_fd_sc_hd__decap_3
XFILLER_128_734 VGND VGND VPWR VPWR sky130_fd_sc_hd__decap_3
XFILLER_127_211 VGND VGND VPWR VPWR sky130_fd_sc_hd__decap_3
XFILLER_6_530 VGND VGND VPWR VPWR sky130_fd_sc_hd__fill_2
XFILLER_6_552 VGND VGND VPWR VPWR sky130_fd_sc_hd__decap_3
XFILLER_51_6 VGND VGND VPWR VPWR sky130_fd_sc_hd__fill_2
XFILLER_123_461 VGND VGND VPWR VPWR sky130_fd_sc_hd__decap_3
XTAP_TAPCELL_ROW_75_1294 VGND VPWR sky130_fd_sc_hd__tapvpwrvgnd_1
XFILLER_69_526 VGND VGND VPWR VPWR sky130_fd_sc_hd__fill_1
XFILLER_96_323 VGND VGND VPWR VPWR sky130_fd_sc_hd__fill_1
XFILLER_69_537 VGND VGND VPWR VPWR sky130_fd_sc_hd__decap_3
XFILLER_111_623 VGND VGND VPWR VPWR sky130_fd_sc_hd__decap_3
XFILLER_111_634 VGND VGND VPWR VPWR sky130_fd_sc_hd__decap_3
X_5080_ _5080_/A _5160_/A VGND VGND VPWR VPWR _5081_/B sky130_fd_sc_hd__xor2_2
XFILLER_2_41 VGND VGND VPWR VPWR sky130_fd_sc_hd__decap_3
XFILLER_110_144 VGND VGND VPWR VPWR sky130_fd_sc_hd__decap_3
XFILLER_65_710 VGND VGND VPWR VPWR sky130_fd_sc_hd__fill_2
XFILLER_37_401 VGND VGND VPWR VPWR sky130_fd_sc_hd__decap_3
XFILLER_2_74 VGND VGND VPWR VPWR sky130_fd_sc_hd__decap_3
XFILLER_2_85 VGND VGND VPWR VPWR sky130_fd_sc_hd__decap_3
XTAP_TAPCELL_ROW_48_930 VGND VPWR sky130_fd_sc_hd__tapvpwrvgnd_1
XFILLER_92_540 VGND VGND VPWR VPWR sky130_fd_sc_hd__decap_3
XFILLER_65_754 VGND VGND VPWR VPWR sky130_fd_sc_hd__decap_3
XFILLER_64_253 VGND VGND VPWR VPWR sky130_fd_sc_hd__fill_2
XFILLER_80_713 VGND VGND VPWR VPWR sky130_fd_sc_hd__decap_3
X_5982_ _7480_/C _8231_/A _5899_/B _9206_/Q VGND VGND VPWR VPWR _5982_/X sky130_fd_sc_hd__o211a_2
X_8770_ _8770_/A _8770_/B _8770_/C VGND VGND VPWR VPWR _8771_/C sky130_fd_sc_hd__and3_2
XFILLER_92_595 VGND VGND VPWR VPWR sky130_fd_sc_hd__fill_2
XFILLER_80_735 VGND VGND VPWR VPWR sky130_fd_sc_hd__decap_3
XFILLER_80_757 VGND VGND VPWR VPWR sky130_fd_sc_hd__fill_1
XFILLER_18_692 VGND VGND VPWR VPWR sky130_fd_sc_hd__decap_3
X_4933_ _6232_/C _6231_/B VGND VGND VPWR VPWR _4934_/A sky130_fd_sc_hd__and2b_2
X_7721_ _7721_/A _7721_/B VGND VGND VPWR VPWR _7722_/B sky130_fd_sc_hd__xnor2_2
X_4864_ _8969_/A VGND VGND VPWR VPWR _8799_/S sky130_fd_sc_hd__clkbuf_2
X_7652_ _7558_/A _7512_/Y _7557_/A VGND VGND VPWR VPWR _7652_/Y sky130_fd_sc_hd__a21oi_2
XFILLER_60_470 VGND VGND VPWR VPWR sky130_fd_sc_hd__decap_3
XFILLER_20_312 VGND VGND VPWR VPWR sky130_fd_sc_hd__decap_3
X_6603_ _9316_/Q _6603_/B _6607_/C VGND VGND VPWR VPWR _6603_/X sky130_fd_sc_hd__and3_2
X_7583_ _7816_/A _7583_/B VGND VGND VPWR VPWR _7622_/A sky130_fd_sc_hd__xnor2_2
X_4795_ _4795_/A VGND VGND VPWR VPWR _9143_/D sky130_fd_sc_hd__buf_1
XFILLER_119_723 VGND VGND VPWR VPWR sky130_fd_sc_hd__decap_3
XFILLER_118_200 VGND VGND VPWR VPWR sky130_fd_sc_hd__fill_2
X_6534_ _6534_/A _6534_/B VGND VGND VPWR VPWR _6534_/Y sky130_fd_sc_hd__nand2_2
X_9322_ _9338_/CLK _9322_/D fanout369/X VGND VGND VPWR VPWR _9322_/Q sky130_fd_sc_hd__dfrtp_2
XFILLER_119_756 VGND VGND VPWR VPWR sky130_fd_sc_hd__decap_3
XFILLER_9_390 VGND VGND VPWR VPWR sky130_fd_sc_hd__fill_2
XFILLER_106_406 VGND VGND VPWR VPWR sky130_fd_sc_hd__decap_3
X_6465_ _6788_/A _6412_/A _6470_/A VGND VGND VPWR VPWR _6465_/X sky130_fd_sc_hd__mux2_2
X_9253_ clkload4/A _9253_/D load_slew376/X VGND VGND VPWR VPWR _9253_/Q sky130_fd_sc_hd__dfrtp_2
XFILLER_106_439 VGND VGND VPWR VPWR sky130_fd_sc_hd__decap_3
X_5416_ _5416_/A _5416_/B VGND VGND VPWR VPWR _5416_/Y sky130_fd_sc_hd__nand2_2
X_8204_ _8204_/A _8204_/B VGND VGND VPWR VPWR _8205_/B sky130_fd_sc_hd__xnor2_2
X_9184_ _9189_/CLK _9184_/D fanout413/X VGND VGND VPWR VPWR _9184_/Q sky130_fd_sc_hd__dfrtp_2
X_6396_ _6395_/Y _6805_/A _6095_/B _5231_/Y VGND VGND VPWR VPWR _6396_/X sky130_fd_sc_hd__a2bb2o_2
X_8135_ _8078_/A _8131_/B _8078_/B VGND VGND VPWR VPWR _8135_/X sky130_fd_sc_hd__a21o_2
XFILLER_102_601 VGND VGND VPWR VPWR sky130_fd_sc_hd__decap_3
X_5347_ _5347_/A _5347_/B VGND VGND VPWR VPWR _5366_/A sky130_fd_sc_hd__xnor2_2
XFILLER_99_161 VGND VGND VPWR VPWR sky130_fd_sc_hd__decap_3
XFILLER_114_483 VGND VGND VPWR VPWR sky130_fd_sc_hd__decap_3
XFILLER_102_645 VGND VGND VPWR VPWR sky130_fd_sc_hd__decap_3
X_8066_ _8066_/A _8066_/B VGND VGND VPWR VPWR _8170_/B sky130_fd_sc_hd__nor2_2
XFILLER_101_122 VGND VGND VPWR VPWR sky130_fd_sc_hd__decap_3
X_5278_ _6765_/A _7590_/A _5279_/A VGND VGND VPWR VPWR _5280_/A sky130_fd_sc_hd__a21oi_2
X_7017_ _7010_/Y _7014_/Y _7015_/Y _7016_/X VGND VGND VPWR VPWR _7017_/X sky130_fd_sc_hd__a211o_4
XFILLER_47_209 VGND VGND VPWR VPWR sky130_fd_sc_hd__decap_3
XFILLER_101_166 VGND VGND VPWR VPWR sky130_fd_sc_hd__fill_2
XFILLER_101_177 VGND VGND VPWR VPWR sky130_fd_sc_hd__decap_3
XFILLER_56_732 VGND VGND VPWR VPWR sky130_fd_sc_hd__decap_3
XFILLER_28_456 VGND VGND VPWR VPWR sky130_fd_sc_hd__decap_3
XFILLER_83_551 VGND VGND VPWR VPWR sky130_fd_sc_hd__decap_3
XFILLER_43_404 VGND VGND VPWR VPWR sky130_fd_sc_hd__decap_3
Xmax_cap59 _8516_/Y VGND VGND VPWR VPWR _8737_/A sky130_fd_sc_hd__clkbuf_2
XFILLER_83_584 VGND VGND VPWR VPWR sky130_fd_sc_hd__decap_3
XFILLER_71_724 VGND VGND VPWR VPWR sky130_fd_sc_hd__decap_3
X_8968_ _8968_/A VGND VGND VPWR VPWR _9325_/D sky130_fd_sc_hd__buf_1
XFILLER_55_297 VGND VGND VPWR VPWR sky130_fd_sc_hd__decap_3
XTAP_TAPCELL_ROW_26_635 VGND VPWR sky130_fd_sc_hd__tapvpwrvgnd_1
XFILLER_15_139 VGND VGND VPWR VPWR sky130_fd_sc_hd__decap_3
X_7919_ wire61/A _7907_/X _7912_/X _9215_/Q _7918_/X VGND VGND VPWR VPWR _8111_/A
+ sky130_fd_sc_hd__o221a_2
XFILLER_102_75 VGND VGND VPWR VPWR sky130_fd_sc_hd__fill_1
X_8899_ _8899_/A VGND VGND VPWR VPWR _9292_/D sky130_fd_sc_hd__buf_1
XFILLER_62_24 VGND VGND VPWR VPWR sky130_fd_sc_hd__decap_3
XFILLER_24_651 VGND VGND VPWR VPWR sky130_fd_sc_hd__decap_3
XFILLER_11_312 VGND VGND VPWR VPWR sky130_fd_sc_hd__decap_3
XFILLER_23_183 VGND VGND VPWR VPWR sky130_fd_sc_hd__fill_2
Xwire225 wire225/A VGND VGND VPWR VPWR result_out[3] sky130_fd_sc_hd__buf_4
XFILLER_109_211 VGND VGND VPWR VPWR sky130_fd_sc_hd__decap_3
XFILLER_109_222 VGND VGND VPWR VPWR sky130_fd_sc_hd__fill_2
XFILLER_125_704 VGND VGND VPWR VPWR sky130_fd_sc_hd__decap_3
XFILLER_124_203 VGND VGND VPWR VPWR sky130_fd_sc_hd__decap_3
XTAP_TAPCELL_ROW_115_1840 VGND VPWR sky130_fd_sc_hd__tapvpwrvgnd_1
XFILLER_125_759 VGND VGND VPWR VPWR sky130_fd_sc_hd__decap_3
XFILLER_124_236 VGND VGND VPWR VPWR sky130_fd_sc_hd__decap_3
XFILLER_11_72 VGND VGND VPWR VPWR sky130_fd_sc_hd__decap_3
XFILLER_3_544 VGND VGND VPWR VPWR sky130_fd_sc_hd__decap_3
XFILLER_87_10 VGND VGND VPWR VPWR sky130_fd_sc_hd__decap_3
XFILLER_127_72 VGND VGND VPWR VPWR sky130_fd_sc_hd__decap_3
XFILLER_78_312 VGND VGND VPWR VPWR sky130_fd_sc_hd__fill_1
XFILLER_78_334 VGND VGND VPWR VPWR sky130_fd_sc_hd__decap_3
XFILLER_120_442 VGND VGND VPWR VPWR sky130_fd_sc_hd__fill_2
XTAP_TAPCELL_ROW_6_360 VGND VPWR sky130_fd_sc_hd__tapvpwrvgnd_1
XFILLER_66_518 VGND VGND VPWR VPWR sky130_fd_sc_hd__decap_3
XFILLER_59_570 VGND VGND VPWR VPWR sky130_fd_sc_hd__decap_3
Xfanout391 fanout391/A VGND VGND VPWR VPWR fanout391/X sky130_fd_sc_hd__clkdlybuf4s25_1
XFILLER_47_721 VGND VGND VPWR VPWR sky130_fd_sc_hd__decap_3
XFILLER_16_9 VGND VGND VPWR VPWR sky130_fd_sc_hd__decap_3
XFILLER_120_497 VGND VGND VPWR VPWR sky130_fd_sc_hd__fill_1
XFILLER_93_337 VGND VGND VPWR VPWR sky130_fd_sc_hd__fill_2
XFILLER_19_434 VGND VGND VPWR VPWR sky130_fd_sc_hd__fill_1
XFILLER_74_551 VGND VGND VPWR VPWR sky130_fd_sc_hd__fill_1
XFILLER_46_253 VGND VGND VPWR VPWR sky130_fd_sc_hd__decap_3
XFILLER_74_595 VGND VGND VPWR VPWR sky130_fd_sc_hd__decap_3
XFILLER_61_212 VGND VGND VPWR VPWR sky130_fd_sc_hd__fill_1
XTAP_TAPCELL_ROW_126_1980 VGND VPWR sky130_fd_sc_hd__tapvpwrvgnd_1
XFILLER_62_746 VGND VGND VPWR VPWR sky130_fd_sc_hd__decap_3
XFILLER_46_297 VGND VGND VPWR VPWR sky130_fd_sc_hd__fill_2
XFILLER_62_757 VGND VGND VPWR VPWR sky130_fd_sc_hd__decap_3
XFILLER_36_80 VGND VGND VPWR VPWR sky130_fd_sc_hd__decap_3
XFILLER_34_448 VGND VGND VPWR VPWR sky130_fd_sc_hd__decap_3
XFILLER_36_91 VGND VGND VPWR VPWR sky130_fd_sc_hd__decap_3
XFILLER_21_109 VGND VGND VPWR VPWR sky130_fd_sc_hd__decap_3
XFILLER_15_673 VGND VGND VPWR VPWR sky130_fd_sc_hd__decap_3
XFILLER_14_150 VGND VGND VPWR VPWR sky130_fd_sc_hd__decap_3
XFILLER_99_6 VGND VGND VPWR VPWR sky130_fd_sc_hd__decap_3
XFILLER_42_470 VGND VGND VPWR VPWR sky130_fd_sc_hd__decap_3
XFILLER_14_194 VGND VGND VPWR VPWR sky130_fd_sc_hd__fill_2
Xinput11 sample_in[3] VGND VGND VPWR VPWR input11/X sky130_fd_sc_hd__clkbuf_2
X_4580_ _4580_/A VGND VGND VPWR VPWR _9041_/D sky130_fd_sc_hd__buf_1
XFILLER_30_698 VGND VGND VPWR VPWR sky130_fd_sc_hd__fill_2
XTAP_TAPCELL_ROW_77_1323 VGND VPWR sky130_fd_sc_hd__tapvpwrvgnd_1
XFILLER_128_564 VGND VGND VPWR VPWR sky130_fd_sc_hd__decap_3
Xhold806 _9185_/Q VGND VGND VPWR VPWR hold806/X sky130_fd_sc_hd__dlygate4sd3_1
XFILLER_116_726 VGND VGND VPWR VPWR sky130_fd_sc_hd__decap_3
Xhold817 _9191_/Q VGND VGND VPWR VPWR hold817/X sky130_fd_sc_hd__dlygate4sd3_1
XFILLER_115_214 VGND VGND VPWR VPWR sky130_fd_sc_hd__fill_1
Xhold828 _4571_/X VGND VGND VPWR VPWR _4572_/A sky130_fd_sc_hd__dlygate4sd3_1
X_6250_ _6250_/A _6250_/B VGND VGND VPWR VPWR _8231_/B sky130_fd_sc_hd__and2_2
Xhold839 _9334_/Q VGND VGND VPWR VPWR hold839/X sky130_fd_sc_hd__dlygate4sd3_1
XFILLER_115_225 VGND VGND VPWR VPWR sky130_fd_sc_hd__decap_3
XFILLER_103_409 VGND VGND VPWR VPWR sky130_fd_sc_hd__fill_1
X_5201_ _5201_/A VGND VGND VPWR VPWR _7569_/A sky130_fd_sc_hd__clkbuf_2
XTAP_TAPCELL_ROW_90_1501 VGND VPWR sky130_fd_sc_hd__tapvpwrvgnd_1
X_6181_ _6181_/A _6181_/B VGND VGND VPWR VPWR _6293_/B sky130_fd_sc_hd__xnor2_4
XFILLER_130_206 VGND VGND VPWR VPWR sky130_fd_sc_hd__decap_3
XFILLER_130_228 VGND VGND VPWR VPWR sky130_fd_sc_hd__decap_3
X_5132_ _7099_/C VGND VGND VPWR VPWR _7591_/A sky130_fd_sc_hd__clkbuf_1
XFILLER_69_334 VGND VGND VPWR VPWR sky130_fd_sc_hd__fill_2
XFILLER_111_442 VGND VGND VPWR VPWR sky130_fd_sc_hd__fill_1
XFILLER_97_676 VGND VGND VPWR VPWR sky130_fd_sc_hd__decap_3
XFILLER_29_209 VGND VGND VPWR VPWR sky130_fd_sc_hd__fill_1
X_5063_ _9164_/Q _5063_/A2 _5062_/X _9256_/Q VGND VGND VPWR VPWR _5071_/A sky130_fd_sc_hd__a22o_2
XFILLER_57_529 VGND VGND VPWR VPWR sky130_fd_sc_hd__decap_3
XFILLER_38_710 VGND VGND VPWR VPWR sky130_fd_sc_hd__fill_1
XFILLER_111_486 VGND VGND VPWR VPWR sky130_fd_sc_hd__decap_3
XFILLER_96_197 VGND VGND VPWR VPWR sky130_fd_sc_hd__decap_3
XFILLER_65_540 VGND VGND VPWR VPWR sky130_fd_sc_hd__decap_3
XTAP_TAPCELL_ROW_88_1463 VGND VPWR sky130_fd_sc_hd__tapvpwrvgnd_1
XFILLER_25_404 VGND VGND VPWR VPWR sky130_fd_sc_hd__decap_3
X_8822_ _8969_/A VGND VGND VPWR VPWR _8837_/S sky130_fd_sc_hd__clkbuf_1
XTAP_TAPCELL_ROW_88_1474 VGND VPWR sky130_fd_sc_hd__tapvpwrvgnd_1
XFILLER_65_573 VGND VGND VPWR VPWR sky130_fd_sc_hd__decap_3
XFILLER_65_595 VGND VGND VPWR VPWR sky130_fd_sc_hd__decap_3
XFILLER_25_437 VGND VGND VPWR VPWR sky130_fd_sc_hd__decap_3
XFILLER_53_757 VGND VGND VPWR VPWR sky130_fd_sc_hd__decap_3
XFILLER_52_234 VGND VGND VPWR VPWR sky130_fd_sc_hd__decap_3
X_8753_ _8753_/A _8753_/B VGND VGND VPWR VPWR _8753_/Y sky130_fd_sc_hd__nand2_2
XFILLER_25_459 VGND VGND VPWR VPWR sky130_fd_sc_hd__decap_3
X_5965_ _5965_/A _5965_/B VGND VGND VPWR VPWR _5965_/X sky130_fd_sc_hd__or2_2
XFILLER_80_576 VGND VGND VPWR VPWR sky130_fd_sc_hd__decap_3
X_7704_ _8011_/C _7705_/B VGND VGND VPWR VPWR _7704_/Y sky130_fd_sc_hd__nand2_2
X_4916_ _4916_/A _4916_/B VGND VGND VPWR VPWR _4916_/X sky130_fd_sc_hd__and2_2
X_5896_ _6685_/A _5897_/C _5897_/D _5345_/A VGND VGND VPWR VPWR _5896_/X sky130_fd_sc_hd__a22o_2
X_8684_ _8707_/B _8684_/B VGND VGND VPWR VPWR _8685_/B sky130_fd_sc_hd__nand2_2
XTAP_TAPCELL_ROW_51_969 VGND VPWR sky130_fd_sc_hd__tapvpwrvgnd_1
XFILLER_20_120 VGND VGND VPWR VPWR sky130_fd_sc_hd__fill_1
X_7635_ _7635_/A _7635_/B VGND VGND VPWR VPWR _7636_/A sky130_fd_sc_hd__and2_2
X_4847_ _4847_/A0 _4847_/A1 _4861_/S VGND VGND VPWR VPWR _4848_/A sky130_fd_sc_hd__mux2_2
XFILLER_32_38 VGND VGND VPWR VPWR sky130_fd_sc_hd__decap_3
XFILLER_21_676 VGND VGND VPWR VPWR sky130_fd_sc_hd__decap_3
XFILLER_20_153 VGND VGND VPWR VPWR sky130_fd_sc_hd__decap_3
X_4778_ _4778_/A VGND VGND VPWR VPWR _9135_/D sky130_fd_sc_hd__buf_1
X_7566_ _7566_/A1 _7563_/X _7283_/X _7564_/X _7565_/Y VGND VGND VPWR VPWR _7566_/Y
+ sky130_fd_sc_hd__o221ai_4
XFILLER_120_9 VGND VGND VPWR VPWR sky130_fd_sc_hd__decap_3
XFILLER_119_542 VGND VGND VPWR VPWR sky130_fd_sc_hd__decap_3
XFILLER_20_186 VGND VGND VPWR VPWR sky130_fd_sc_hd__decap_3
XFILLER_20_197 VGND VGND VPWR VPWR sky130_fd_sc_hd__decap_3
X_9305_ clkload5/A _9305_/D wire372/X VGND VGND VPWR VPWR _9305_/Q sky130_fd_sc_hd__dfrtp_2
X_6517_ _6514_/X _6269_/A _5816_/X _6517_/B1 _6265_/A VGND VGND VPWR VPWR _6517_/X
+ sky130_fd_sc_hd__o32a_4
XFILLER_107_726 VGND VGND VPWR VPWR sky130_fd_sc_hd__fill_2
X_7497_ _7387_/A _7496_/X _7380_/B _7385_/A VGND VGND VPWR VPWR _7502_/A sky130_fd_sc_hd__a211o_2
XFILLER_119_597 VGND VGND VPWR VPWR sky130_fd_sc_hd__decap_3
XFILLER_106_225 VGND VGND VPWR VPWR sky130_fd_sc_hd__decap_3
X_9236_ _9236_/CLK _9236_/D fanout398/X VGND VGND VPWR VPWR _9236_/Q sky130_fd_sc_hd__dfrtp_2
X_6448_ _6886_/B VGND VGND VPWR VPWR _6450_/B sky130_fd_sc_hd__clkbuf_1
XFILLER_122_718 VGND VGND VPWR VPWR sky130_fd_sc_hd__decap_3
XFILLER_0_503 VGND VGND VPWR VPWR sky130_fd_sc_hd__fill_1
X_6379_ _6260_/C _6260_/B _6377_/Y _6378_/Y VGND VGND VPWR VPWR _6382_/A sky130_fd_sc_hd__a31oi_2
X_9167_ _9339_/CLK _9167_/D load_slew393/X VGND VGND VPWR VPWR _9167_/Q sky130_fd_sc_hd__dfrtp_2
XFILLER_121_217 VGND VGND VPWR VPWR sky130_fd_sc_hd__decap_3
XFILLER_0_514 VGND VGND VPWR VPWR sky130_fd_sc_hd__decap_3
XFILLER_0_536 VGND VGND VPWR VPWR sky130_fd_sc_hd__decap_3
X_8118_ _8118_/A VGND VGND VPWR VPWR _9219_/D sky130_fd_sc_hd__buf_1
XFILLER_114_280 VGND VGND VPWR VPWR sky130_fd_sc_hd__decap_3
XFILLER_87_131 VGND VGND VPWR VPWR sky130_fd_sc_hd__decap_3
X_9098_ _9334_/CLK _9098_/D load_slew401/X VGND VGND VPWR VPWR _9098_/Q sky130_fd_sc_hd__dfrtp_2
XFILLER_88_665 VGND VGND VPWR VPWR sky130_fd_sc_hd__fill_1
XFILLER_57_24 VGND VGND VPWR VPWR sky130_fd_sc_hd__decap_3
XFILLER_102_464 VGND VGND VPWR VPWR sky130_fd_sc_hd__decap_3
XFILLER_48_518 VGND VGND VPWR VPWR sky130_fd_sc_hd__decap_3
XTAP_TAPCELL_ROW_110_1770 VGND VPWR sky130_fd_sc_hd__tapvpwrvgnd_1
X_8049_ _8155_/A _8154_/A VGND VGND VPWR VPWR _8049_/Y sky130_fd_sc_hd__xnor2_2
XFILLER_102_486 VGND VGND VPWR VPWR sky130_fd_sc_hd__decap_3
XFILLER_57_57 VGND VGND VPWR VPWR sky130_fd_sc_hd__decap_3
XFILLER_29_732 VGND VGND VPWR VPWR sky130_fd_sc_hd__decap_3
XFILLER_113_30 VGND VGND VPWR VPWR sky130_fd_sc_hd__decap_3
XFILLER_28_242 VGND VGND VPWR VPWR sky130_fd_sc_hd__decap_3
XFILLER_28_253 VGND VGND VPWR VPWR sky130_fd_sc_hd__decap_3
XFILLER_90_318 VGND VGND VPWR VPWR sky130_fd_sc_hd__decap_3
XFILLER_113_63 VGND VGND VPWR VPWR sky130_fd_sc_hd__decap_3
XFILLER_16_415 VGND VGND VPWR VPWR sky130_fd_sc_hd__decap_3
XFILLER_56_595 VGND VGND VPWR VPWR sky130_fd_sc_hd__decap_3
XFILLER_113_96 VGND VGND VPWR VPWR sky130_fd_sc_hd__fill_1
XFILLER_44_757 VGND VGND VPWR VPWR sky130_fd_sc_hd__decap_3
XFILLER_43_256 VGND VGND VPWR VPWR sky130_fd_sc_hd__decap_3
XTAP_TAPCELL_ROW_61_1102 VGND VPWR sky130_fd_sc_hd__tapvpwrvgnd_1
XPHY_EDGE_ROW_125_Right_125 VGND VGND VPWR VPWR sky130_fd_sc_hd__decap_3
XFILLER_12_621 VGND VGND VPWR VPWR sky130_fd_sc_hd__decap_3
XFILLER_12_632 VGND VGND VPWR VPWR sky130_fd_sc_hd__decap_3
XFILLER_8_603 VGND VGND VPWR VPWR sky130_fd_sc_hd__decap_3
XFILLER_11_164 VGND VGND VPWR VPWR sky130_fd_sc_hd__decap_3
XFILLER_12_698 VGND VGND VPWR VPWR sky130_fd_sc_hd__fill_2
XFILLER_22_82 VGND VGND VPWR VPWR sky130_fd_sc_hd__fill_2
XTAP_TAPCELL_ROW_59_1075 VGND VPWR sky130_fd_sc_hd__tapvpwrvgnd_1
XFILLER_3_330 VGND VGND VPWR VPWR sky130_fd_sc_hd__decap_3
XFILLER_125_556 VGND VGND VPWR VPWR sky130_fd_sc_hd__decap_3
XFILLER_125_567 VGND VGND VPWR VPWR sky130_fd_sc_hd__decap_3
XFILLER_3_352 VGND VGND VPWR VPWR sky130_fd_sc_hd__decap_3
XFILLER_113_729 VGND VGND VPWR VPWR sky130_fd_sc_hd__fill_1
XFILLER_98_97 VGND VGND VPWR VPWR sky130_fd_sc_hd__decap_3
XFILLER_79_632 VGND VGND VPWR VPWR sky130_fd_sc_hd__decap_3
XTAP_TAPCELL_ROW_72_1253 VGND VPWR sky130_fd_sc_hd__tapvpwrvgnd_1
XFILLER_3_396 VGND VGND VPWR VPWR sky130_fd_sc_hd__decap_3
XFILLER_79_665 VGND VGND VPWR VPWR sky130_fd_sc_hd__decap_3
XFILLER_121_762 VGND VGND VPWR VPWR sky130_fd_sc_hd__decap_3
XFILLER_94_613 VGND VGND VPWR VPWR sky130_fd_sc_hd__decap_3
XFILLER_79_698 VGND VGND VPWR VPWR sky130_fd_sc_hd__decap_3
XFILLER_94_635 VGND VGND VPWR VPWR sky130_fd_sc_hd__fill_2
XFILLER_78_197 VGND VGND VPWR VPWR sky130_fd_sc_hd__fill_1
XFILLER_14_6 VGND VGND VPWR VPWR sky130_fd_sc_hd__decap_3
XFILLER_93_134 VGND VGND VPWR VPWR sky130_fd_sc_hd__decap_3
XFILLER_66_348 VGND VGND VPWR VPWR sky130_fd_sc_hd__decap_3
XFILLER_94_679 VGND VGND VPWR VPWR sky130_fd_sc_hd__decap_3
XFILLER_47_573 VGND VGND VPWR VPWR sky130_fd_sc_hd__decap_3
XFILLER_62_521 VGND VGND VPWR VPWR sky130_fd_sc_hd__decap_3
XFILLER_35_735 VGND VGND VPWR VPWR sky130_fd_sc_hd__fill_2
XFILLER_62_543 VGND VGND VPWR VPWR sky130_fd_sc_hd__fill_1
XFILLER_62_554 VGND VGND VPWR VPWR sky130_fd_sc_hd__decap_3
XFILLER_50_705 VGND VGND VPWR VPWR sky130_fd_sc_hd__decap_3
XFILLER_34_256 VGND VGND VPWR VPWR sky130_fd_sc_hd__decap_3
XFILLER_34_278 VGND VGND VPWR VPWR sky130_fd_sc_hd__decap_3
X_5750_ _5748_/Y _5749_/X _6246_/A VGND VGND VPWR VPWR _5751_/B sky130_fd_sc_hd__a21oi_2
XFILLER_97_3 VGND VGND VPWR VPWR sky130_fd_sc_hd__decap_3
XFILLER_15_492 VGND VGND VPWR VPWR sky130_fd_sc_hd__decap_3
X_4701_ _4701_/A VGND VGND VPWR VPWR _9098_/D sky130_fd_sc_hd__buf_1
X_5681_ _5681_/A _5780_/B VGND VGND VPWR VPWR _5682_/B sky130_fd_sc_hd__xnor2_2
XFILLER_30_440 VGND VGND VPWR VPWR sky130_fd_sc_hd__decap_3
X_4632_ hold946/X _4632_/A1 _4650_/S VGND VGND VPWR VPWR _4633_/A sky130_fd_sc_hd__mux2_2
X_7420_ _7421_/C _7421_/A _7421_/D _7590_/C VGND VGND VPWR VPWR _7436_/A sky130_fd_sc_hd__a31oi_4
XFILLER_8_62 VGND VGND VPWR VPWR sky130_fd_sc_hd__decap_3
XFILLER_30_495 VGND VGND VPWR VPWR sky130_fd_sc_hd__decap_3
XFILLER_8_95 VGND VGND VPWR VPWR sky130_fd_sc_hd__decap_3
X_4563_ _4563_/A VGND VGND VPWR VPWR _9033_/D sky130_fd_sc_hd__buf_1
X_7351_ _7469_/B _7469_/C _7468_/C VGND VGND VPWR VPWR _7353_/B sky130_fd_sc_hd__a21o_2
XFILLER_116_523 VGND VGND VPWR VPWR sky130_fd_sc_hd__decap_3
XFILLER_7_680 VGND VGND VPWR VPWR sky130_fd_sc_hd__decap_3
X_6302_ _6302_/A _6302_/B _8779_/B VGND VGND VPWR VPWR _7083_/A sky130_fd_sc_hd__or3_2
X_7282_ _7281_/X _6651_/B _6905_/A VGND VGND VPWR VPWR _7564_/B sky130_fd_sc_hd__a21oi_4
XFILLER_116_556 VGND VGND VPWR VPWR sky130_fd_sc_hd__decap_3
X_6233_ _6231_/X _6232_/X _6027_/B VGND VGND VPWR VPWR _6233_/Y sky130_fd_sc_hd__o21ai_2
X_9021_ clkload5/A _9021_/D wire372/X VGND VGND VPWR VPWR _9021_/Q sky130_fd_sc_hd__dfrtp_2
XFILLER_116_589 VGND VGND VPWR VPWR sky130_fd_sc_hd__decap_3
XFILLER_103_239 VGND VGND VPWR VPWR sky130_fd_sc_hd__fill_1
X_6164_ _6174_/A _6174_/B VGND VGND VPWR VPWR _6292_/A sky130_fd_sc_hd__nor2_2
X_5115_ _5879_/B _5624_/B VGND VGND VPWR VPWR _5115_/X sky130_fd_sc_hd__and2_2
X_6095_ _6095_/A _6095_/B VGND VGND VPWR VPWR _6095_/X sky130_fd_sc_hd__or2_2
XFILLER_85_635 VGND VGND VPWR VPWR sky130_fd_sc_hd__fill_1
XFILLER_111_272 VGND VGND VPWR VPWR sky130_fd_sc_hd__decap_3
XFILLER_85_657 VGND VGND VPWR VPWR sky130_fd_sc_hd__decap_3
X_5046_ _9196_/Q _7317_/A VGND VGND VPWR VPWR _5048_/C sky130_fd_sc_hd__xnor2_2
XFILLER_26_713 VGND VGND VPWR VPWR sky130_fd_sc_hd__decap_3
XFILLER_38_573 VGND VGND VPWR VPWR sky130_fd_sc_hd__fill_2
XFILLER_25_223 VGND VGND VPWR VPWR sky130_fd_sc_hd__fill_1
XFILLER_26_757 VGND VGND VPWR VPWR sky130_fd_sc_hd__decap_3
X_8805_ _8805_/A VGND VGND VPWR VPWR _9247_/D sky130_fd_sc_hd__buf_1
XFILLER_25_245 VGND VGND VPWR VPWR sky130_fd_sc_hd__decap_3
X_6997_ _6997_/A _6997_/B VGND VGND VPWR VPWR _6998_/B sky130_fd_sc_hd__xnor2_2
XTAP_TAPCELL_ROW_36_763 VGND VPWR sky130_fd_sc_hd__tapvpwrvgnd_1
XTAP_TAPCELL_ROW_36_774 VGND VPWR sky130_fd_sc_hd__tapvpwrvgnd_1
XFILLER_41_727 VGND VGND VPWR VPWR sky130_fd_sc_hd__fill_1
XFILLER_80_373 VGND VGND VPWR VPWR sky130_fd_sc_hd__decap_3
X_8736_ _9228_/Q _8729_/X _8735_/X VGND VGND VPWR VPWR _8768_/A sky130_fd_sc_hd__o21a_2
XFILLER_13_429 VGND VGND VPWR VPWR sky130_fd_sc_hd__decap_3
X_5948_ _6103_/S _5948_/B VGND VGND VPWR VPWR _5952_/A sky130_fd_sc_hd__xnor2_4
XFILLER_41_749 VGND VGND VPWR VPWR sky130_fd_sc_hd__decap_3
XFILLER_40_237 VGND VGND VPWR VPWR sky130_fd_sc_hd__decap_3
XFILLER_40_259 VGND VGND VPWR VPWR sky130_fd_sc_hd__decap_3
X_8667_ _8700_/B _8667_/B VGND VGND VPWR VPWR _8668_/B sky130_fd_sc_hd__nand2_2
X_5879_ _9156_/Q _5879_/B _5879_/C VGND VGND VPWR VPWR _5879_/X sky130_fd_sc_hd__and3_2
XFILLER_21_462 VGND VGND VPWR VPWR sky130_fd_sc_hd__decap_3
X_7618_ _8239_/A _7618_/B _7617_/X VGND VGND VPWR VPWR _7619_/B sky130_fd_sc_hd__or3b_2
X_8598_ _8581_/Y _8560_/A wire71/X VGND VGND VPWR VPWR _8598_/X sky130_fd_sc_hd__a21o_2
XFILLER_126_309 VGND VGND VPWR VPWR sky130_fd_sc_hd__decap_3
X_7549_ _7549_/A _7549_/B VGND VGND VPWR VPWR _7550_/B sky130_fd_sc_hd__xnor2_2
XFILLER_4_138 VGND VGND VPWR VPWR sky130_fd_sc_hd__fill_2
XFILLER_107_567 VGND VGND VPWR VPWR sky130_fd_sc_hd__decap_3
XFILLER_108_41 VGND VGND VPWR VPWR sky130_fd_sc_hd__decap_3
XFILLER_122_504 VGND VGND VPWR VPWR sky130_fd_sc_hd__decap_3
X_9219_ _9219_/CLK _9219_/D fanout413/X VGND VGND VPWR VPWR _9219_/Q sky130_fd_sc_hd__dfrtp_2
XFILLER_122_526 VGND VGND VPWR VPWR sky130_fd_sc_hd__decap_3
XFILLER_108_85 VGND VGND VPWR VPWR sky130_fd_sc_hd__fill_1
XFILLER_122_548 VGND VGND VPWR VPWR sky130_fd_sc_hd__decap_3
XFILLER_0_322 VGND VGND VPWR VPWR sky130_fd_sc_hd__decap_3
XTAP_TAPCELL_ROW_128_2006 VGND VPWR sky130_fd_sc_hd__tapvpwrvgnd_1
XFILLER_0_377 VGND VGND VPWR VPWR sky130_fd_sc_hd__decap_3
XFILLER_130_570 VGND VGND VPWR VPWR sky130_fd_sc_hd__decap_3
XFILLER_0_388 VGND VGND VPWR VPWR sky130_fd_sc_hd__fill_1
XFILLER_0_399 VGND VGND VPWR VPWR sky130_fd_sc_hd__decap_3
XFILLER_102_283 VGND VGND VPWR VPWR sky130_fd_sc_hd__fill_1
XFILLER_130_592 VGND VGND VPWR VPWR sky130_fd_sc_hd__decap_3
XFILLER_48_348 VGND VGND VPWR VPWR sky130_fd_sc_hd__fill_2
XFILLER_75_134 VGND VGND VPWR VPWR sky130_fd_sc_hd__decap_3
XFILLER_124_62 VGND VGND VPWR VPWR sky130_fd_sc_hd__decap_3
XFILLER_91_627 VGND VGND VPWR VPWR sky130_fd_sc_hd__decap_3
XFILLER_17_713 VGND VGND VPWR VPWR sky130_fd_sc_hd__decap_3
XFILLER_90_115 VGND VGND VPWR VPWR sky130_fd_sc_hd__decap_3
XFILLER_17_735 VGND VGND VPWR VPWR sky130_fd_sc_hd__decap_3
XFILLER_44_521 VGND VGND VPWR VPWR sky130_fd_sc_hd__decap_3
XFILLER_84_99 VGND VGND VPWR VPWR sky130_fd_sc_hd__fill_1
XFILLER_16_223 VGND VGND VPWR VPWR sky130_fd_sc_hd__decap_3
XFILLER_17_768 VGND VGND VPWR VPWR sky130_fd_sc_hd__decap_3
XFILLER_16_256 VGND VGND VPWR VPWR sky130_fd_sc_hd__decap_3
XFILLER_16_278 VGND VGND VPWR VPWR sky130_fd_sc_hd__fill_1
XFILLER_32_738 VGND VGND VPWR VPWR sky130_fd_sc_hd__decap_3
XFILLER_31_248 VGND VGND VPWR VPWR sky130_fd_sc_hd__decap_3
XTAP_TAPCELL_ROW_14_468 VGND VPWR sky130_fd_sc_hd__tapvpwrvgnd_1
XFILLER_129_125 VGND VGND VPWR VPWR sky130_fd_sc_hd__decap_3
XFILLER_129_158 VGND VGND VPWR VPWR sky130_fd_sc_hd__decap_3
XPHY_EDGE_ROW_49_Left_180 VGND VGND VPWR VPWR sky130_fd_sc_hd__decap_3
XFILLER_8_466 VGND VGND VPWR VPWR sky130_fd_sc_hd__decap_3
XFILLER_129_169 VGND VGND VPWR VPWR sky130_fd_sc_hd__decap_3
XFILLER_99_716 VGND VGND VPWR VPWR sky130_fd_sc_hd__decap_3
XFILLER_4_661 VGND VGND VPWR VPWR sky130_fd_sc_hd__decap_3
XFILLER_4_694 VGND VGND VPWR VPWR sky130_fd_sc_hd__decap_3
XFILLER_39_315 VGND VGND VPWR VPWR sky130_fd_sc_hd__decap_3
XFILLER_94_421 VGND VGND VPWR VPWR sky130_fd_sc_hd__fill_2
XFILLER_12_3 VGND VGND VPWR VPWR sky130_fd_sc_hd__decap_3
X_6920_ _6920_/A _6920_/B VGND VGND VPWR VPWR _6920_/X sky130_fd_sc_hd__and2_2
XFILLER_94_498 VGND VGND VPWR VPWR sky130_fd_sc_hd__decap_3
XFILLER_82_638 VGND VGND VPWR VPWR sky130_fd_sc_hd__decap_3
XFILLER_35_510 VGND VGND VPWR VPWR sky130_fd_sc_hd__decap_3
XFILLER_47_381 VGND VGND VPWR VPWR sky130_fd_sc_hd__decap_3
XTAP_TAPCELL_ROW_85_1433 VGND VPWR sky130_fd_sc_hd__tapvpwrvgnd_1
XFILLER_81_159 VGND VGND VPWR VPWR sky130_fd_sc_hd__fill_1
X_6851_ hold808/X _6850_/Y _7560_/S VGND VGND VPWR VPWR _6851_/X sky130_fd_sc_hd__mux2_2
XFILLER_90_671 VGND VGND VPWR VPWR sky130_fd_sc_hd__decap_3
XFILLER_35_576 VGND VGND VPWR VPWR sky130_fd_sc_hd__decap_3
XFILLER_23_716 VGND VGND VPWR VPWR sky130_fd_sc_hd__decap_3
XFILLER_50_513 VGND VGND VPWR VPWR sky130_fd_sc_hd__decap_3
X_5802_ _5801_/B _5656_/Y _5659_/Y _5801_/Y VGND VGND VPWR VPWR _5802_/X sky130_fd_sc_hd__a22o_2
XFILLER_23_738 VGND VGND VPWR VPWR sky130_fd_sc_hd__decap_3
X_6782_ _6509_/B _6506_/Y _6509_/A VGND VGND VPWR VPWR _6782_/X sky130_fd_sc_hd__a21o_2
XTAP_TAPCELL_ROW_33_722 VGND VPWR sky130_fd_sc_hd__tapvpwrvgnd_1
XFILLER_62_395 VGND VGND VPWR VPWR sky130_fd_sc_hd__fill_1
XTAP_TAPCELL_ROW_33_733 VGND VPWR sky130_fd_sc_hd__tapvpwrvgnd_1
XFILLER_50_546 VGND VGND VPWR VPWR sky130_fd_sc_hd__decap_3
X_8521_ _8443_/B _8520_/X _8521_/S VGND VGND VPWR VPWR _8521_/X sky130_fd_sc_hd__mux2_2
X_5733_ _9279_/Q _5065_/X wire172/X _9123_/Q VGND VGND VPWR VPWR _5735_/D sky130_fd_sc_hd__a22o_2
XFILLER_31_760 VGND VGND VPWR VPWR sky130_fd_sc_hd__decap_3
XFILLER_13_18 VGND VGND VPWR VPWR sky130_fd_sc_hd__decap_3
X_8452_ _8504_/A _8504_/B VGND VGND VPWR VPWR _8453_/B sky130_fd_sc_hd__or2_2
XFILLER_129_18 VGND VGND VPWR VPWR sky130_fd_sc_hd__decap_3
X_5664_ _5664_/A _5664_/B VGND VGND VPWR VPWR _5664_/Y sky130_fd_sc_hd__xnor2_2
XFILLER_30_292 VGND VGND VPWR VPWR sky130_fd_sc_hd__decap_3
X_7403_ _7342_/A _7342_/B _7402_/Y _7407_/A VGND VGND VPWR VPWR _7403_/X sky130_fd_sc_hd__a31o_2
X_4615_ _9058_/Q _4615_/A1 _4629_/S VGND VGND VPWR VPWR _4615_/X sky130_fd_sc_hd__mux2_2
X_5595_ _5727_/B _5595_/B VGND VGND VPWR VPWR _5596_/B sky130_fd_sc_hd__xnor2_2
X_8383_ _8383_/A _8383_/B VGND VGND VPWR VPWR _8385_/B sky130_fd_sc_hd__xor2_2
XFILLER_128_180 VGND VGND VPWR VPWR sky130_fd_sc_hd__decap_3
X_4546_ _8990_/A VGND VGND VPWR VPWR _4631_/A sky130_fd_sc_hd__clkbuf_1
X_7334_ _7333_/B _7333_/C _7443_/A VGND VGND VPWR VPWR _7346_/B sky130_fd_sc_hd__a21o_2
XTAP_TAPCELL_ROW_96_1573 VGND VPWR sky130_fd_sc_hd__tapvpwrvgnd_1
XTAP_TAPCELL_ROW_96_1584 VGND VPWR sky130_fd_sc_hd__tapvpwrvgnd_1
XFILLER_104_515 VGND VGND VPWR VPWR sky130_fd_sc_hd__decap_3
Xmax_cap163 _4968_/S VGND VGND VPWR VPWR _8117_/S sky130_fd_sc_hd__buf_6
X_7265_ _7215_/A _7264_/X _7262_/X VGND VGND VPWR VPWR _7265_/Y sky130_fd_sc_hd__o21ai_2
Xmax_cap174 _4918_/A VGND VGND VPWR VPWR _6944_/A sky130_fd_sc_hd__clkbuf_2
XFILLER_1_119 VGND VGND VPWR VPWR sky130_fd_sc_hd__decap_3
Xmax_cap185 _5442_/B VGND VGND VPWR VPWR _6336_/C sky130_fd_sc_hd__buf_6
Xmax_cap196 _7715_/B VGND VGND VPWR VPWR _8018_/A sky130_fd_sc_hd__clkbuf_2
X_9004_ _9004_/A VGND VGND VPWR VPWR _9342_/D sky130_fd_sc_hd__buf_1
XFILLER_104_559 VGND VGND VPWR VPWR sky130_fd_sc_hd__decap_3
X_6216_ _6369_/B _6216_/B _6216_/C VGND VGND VPWR VPWR _6218_/C sky130_fd_sc_hd__nand3b_2
XFILLER_89_259 VGND VGND VPWR VPWR sky130_fd_sc_hd__decap_3
X_7196_ _8031_/A _7196_/B VGND VGND VPWR VPWR _7196_/X sky130_fd_sc_hd__and2b_2
X_6147_ _6061_/C _6144_/X _6146_/X VGND VGND VPWR VPWR _6266_/A sky130_fd_sc_hd__o21ai_2
Xhold1100 _9076_/Q VGND VGND VPWR VPWR _4687_/A1 sky130_fd_sc_hd__dlygate4sd3_1
XFILLER_97_281 VGND VGND VPWR VPWR sky130_fd_sc_hd__decap_3
Xhold1111 _9306_/Q VGND VGND VPWR VPWR _8961_/A1 sky130_fd_sc_hd__dlygate4sd3_1
XFILLER_112_592 VGND VGND VPWR VPWR sky130_fd_sc_hd__decap_3
Xload_slew380 fanout379/X VGND VGND VPWR VPWR load_slew380/X sky130_fd_sc_hd__buf_4
Xhold1122 _9033_/Q VGND VGND VPWR VPWR _4596_/A1 sky130_fd_sc_hd__dlygate4sd3_1
Xhold1133 _9290_/Q VGND VGND VPWR VPWR _8928_/A1 sky130_fd_sc_hd__dlygate4sd3_1
XFILLER_58_668 VGND VGND VPWR VPWR sky130_fd_sc_hd__decap_3
X_6078_ _6083_/B _6075_/X _6076_/X _6077_/X VGND VGND VPWR VPWR _6078_/X sky130_fd_sc_hd__a31o_2
Xhold1144 _4681_/X VGND VGND VPWR VPWR _4682_/A sky130_fd_sc_hd__dlygate4sd3_1
Xhold1155 _9279_/Q VGND VGND VPWR VPWR _8904_/A1 sky130_fd_sc_hd__dlygate4sd3_1
Xhold1166 _9265_/Q VGND VGND VPWR VPWR _8875_/A1 sky130_fd_sc_hd__dlygate4sd3_1
XFILLER_73_627 VGND VGND VPWR VPWR sky130_fd_sc_hd__decap_3
X_5029_ _5530_/S _5028_/X _5029_/S VGND VGND VPWR VPWR _5029_/X sky130_fd_sc_hd__mux2_2
Xhold1177 _8846_/X VGND VGND VPWR VPWR _8847_/A sky130_fd_sc_hd__dlygate4sd3_1
XFILLER_72_104 VGND VGND VPWR VPWR sky130_fd_sc_hd__fill_2
Xhold1188 _9111_/Q VGND VGND VPWR VPWR _4761_/A1 sky130_fd_sc_hd__dlygate4sd3_1
Xhold1199 _9223_/Q VGND VGND VPWR VPWR _8460_/A sky130_fd_sc_hd__dlygate4sd3_1
XFILLER_53_340 VGND VGND VPWR VPWR sky130_fd_sc_hd__decap_3
XFILLER_14_716 VGND VGND VPWR VPWR sky130_fd_sc_hd__decap_3
XFILLER_81_671 VGND VGND VPWR VPWR sky130_fd_sc_hd__fill_1
XFILLER_41_535 VGND VGND VPWR VPWR sky130_fd_sc_hd__decap_3
XFILLER_14_749 VGND VGND VPWR VPWR sky130_fd_sc_hd__decap_3
X_8719_ _8706_/C _8714_/Y _8717_/X _8718_/X VGND VGND VPWR VPWR _8771_/B sky130_fd_sc_hd__o211a_2
XFILLER_9_219 VGND VGND VPWR VPWR sky130_fd_sc_hd__decap_3
XFILLER_41_579 VGND VGND VPWR VPWR sky130_fd_sc_hd__decap_3
XFILLER_70_24 VGND VGND VPWR VPWR sky130_fd_sc_hd__decap_3
XFILLER_22_760 VGND VGND VPWR VPWR sky130_fd_sc_hd__decap_3
XTAP_TAPCELL_ROW_11_427 VGND VPWR sky130_fd_sc_hd__tapvpwrvgnd_1
XFILLER_21_281 VGND VGND VPWR VPWR sky130_fd_sc_hd__decap_3
XFILLER_127_607 VGND VGND VPWR VPWR sky130_fd_sc_hd__decap_3
Xrebuffer530 _5904_/B VGND VGND VPWR VPWR _6064_/A1 sky130_fd_sc_hd__buf_4
XFILLER_127_629 VGND VGND VPWR VPWR sky130_fd_sc_hd__decap_3
XFILLER_126_106 VGND VGND VPWR VPWR sky130_fd_sc_hd__decap_3
Xrebuffer541 _6298_/B2 VGND VGND VPWR VPWR _6297_/D sky130_fd_sc_hd__buf_2
Xrebuffer552 _6370_/B VGND VGND VPWR VPWR _6528_/A sky130_fd_sc_hd__buf_2
Xrebuffer563 _5605_/Y VGND VGND VPWR VPWR _5606_/A sky130_fd_sc_hd__buf_2
Xrebuffer574 _4930_/B_N VGND VGND VPWR VPWR _4926_/A sky130_fd_sc_hd__buf_2
XFILLER_126_139 VGND VGND VPWR VPWR sky130_fd_sc_hd__fill_1
XFILLER_119_51 VGND VGND VPWR VPWR sky130_fd_sc_hd__decap_3
Xrebuffer585 wire44/X VGND VGND VPWR VPWR _8192_/A2 sky130_fd_sc_hd__buf_2
XFILLER_119_84 VGND VGND VPWR VPWR sky130_fd_sc_hd__decap_3
XFILLER_122_301 VGND VGND VPWR VPWR sky130_fd_sc_hd__decap_3
XTAP_TAPCELL_ROW_56_1034 VGND VPWR sky130_fd_sc_hd__tapvpwrvgnd_1
XFILLER_79_66 VGND VGND VPWR VPWR sky130_fd_sc_hd__decap_3
XFILLER_1_620 VGND VGND VPWR VPWR sky130_fd_sc_hd__decap_3
XFILLER_122_334 VGND VGND VPWR VPWR sky130_fd_sc_hd__decap_3
XFILLER_79_99 VGND VGND VPWR VPWR sky130_fd_sc_hd__decap_3
XFILLER_1_653 VGND VGND VPWR VPWR sky130_fd_sc_hd__decap_3
XFILLER_49_602 VGND VGND VPWR VPWR sky130_fd_sc_hd__decap_3
XFILLER_0_141 VGND VGND VPWR VPWR sky130_fd_sc_hd__decap_3
XFILLER_95_10 VGND VGND VPWR VPWR sky130_fd_sc_hd__decap_3
XFILLER_103_570 VGND VGND VPWR VPWR sky130_fd_sc_hd__decap_3
XFILLER_95_43 VGND VGND VPWR VPWR sky130_fd_sc_hd__decap_3
XFILLER_76_421 VGND VGND VPWR VPWR sky130_fd_sc_hd__decap_3
XFILLER_1_697 VGND VGND VPWR VPWR sky130_fd_sc_hd__decap_3
XFILLER_49_657 VGND VGND VPWR VPWR sky130_fd_sc_hd__decap_3
XFILLER_76_454 VGND VGND VPWR VPWR sky130_fd_sc_hd__decap_3
XFILLER_95_87 VGND VGND VPWR VPWR sky130_fd_sc_hd__decap_3
XFILLER_49_679 VGND VGND VPWR VPWR sky130_fd_sc_hd__decap_3
XFILLER_48_156 VGND VGND VPWR VPWR sky130_fd_sc_hd__decap_3
XFILLER_91_402 VGND VGND VPWR VPWR sky130_fd_sc_hd__decap_3
XFILLER_76_487 VGND VGND VPWR VPWR sky130_fd_sc_hd__decap_3
XFILLER_48_189 VGND VGND VPWR VPWR sky130_fd_sc_hd__decap_3
XTAP_TAPCELL_ROW_19_538 VGND VPWR sky130_fd_sc_hd__tapvpwrvgnd_1
XFILLER_57_690 VGND VGND VPWR VPWR sky130_fd_sc_hd__decap_3
XFILLER_91_479 VGND VGND VPWR VPWR sky130_fd_sc_hd__decap_3
XTAP_TAPCELL_ROW_121_1909 VGND VPWR sky130_fd_sc_hd__tapvpwrvgnd_1
XFILLER_44_351 VGND VGND VPWR VPWR sky130_fd_sc_hd__decap_3
XFILLER_72_682 VGND VGND VPWR VPWR sky130_fd_sc_hd__decap_3
XFILLER_32_513 VGND VGND VPWR VPWR sky130_fd_sc_hd__decap_3
XTAP_TAPCELL_ROW_67_1185 VGND VPWR sky130_fd_sc_hd__tapvpwrvgnd_1
XFILLER_44_80 VGND VGND VPWR VPWR sky130_fd_sc_hd__decap_3
XFILLER_44_91 VGND VGND VPWR VPWR sky130_fd_sc_hd__fill_1
XFILLER_20_719 VGND VGND VPWR VPWR sky130_fd_sc_hd__decap_3
XTAP_TAPCELL_ROW_80_1363 VGND VPWR sky130_fd_sc_hd__tapvpwrvgnd_1
XFILLER_13_771 VGND VGND VPWR VPWR sky130_fd_sc_hd__decap_3
XFILLER_81_6 VGND VGND VPWR VPWR sky130_fd_sc_hd__decap_3
XFILLER_9_753 VGND VGND VPWR VPWR sky130_fd_sc_hd__decap_3
XFILLER_12_281 VGND VGND VPWR VPWR sky130_fd_sc_hd__decap_3
XFILLER_118_607 VGND VGND VPWR VPWR sky130_fd_sc_hd__decap_3
XFILLER_118_618 VGND VGND VPWR VPWR sky130_fd_sc_hd__decap_3
XFILLER_8_274 VGND VGND VPWR VPWR sky130_fd_sc_hd__decap_3
X_5380_ _9040_/Q _9104_/Q _5462_/S VGND VGND VPWR VPWR _5380_/X sky130_fd_sc_hd__mux2_2
XFILLER_126_651 VGND VGND VPWR VPWR sky130_fd_sc_hd__decap_3
XFILLER_5_30 VGND VGND VPWR VPWR sky130_fd_sc_hd__decap_3
XFILLER_126_684 VGND VGND VPWR VPWR sky130_fd_sc_hd__decap_3
XFILLER_125_161 VGND VGND VPWR VPWR sky130_fd_sc_hd__decap_3
XFILLER_125_172 VGND VGND VPWR VPWR sky130_fd_sc_hd__decap_3
X_7050_ _7050_/A _7050_/B VGND VGND VPWR VPWR _7050_/Y sky130_fd_sc_hd__xnor2_2
XFILLER_99_557 VGND VGND VPWR VPWR sky130_fd_sc_hd__decap_3
X_6001_ _6680_/B VGND VGND VPWR VPWR _8315_/A sky130_fd_sc_hd__clkbuf_2
XFILLER_113_389 VGND VGND VPWR VPWR sky130_fd_sc_hd__decap_3
XFILLER_79_270 VGND VGND VPWR VPWR sky130_fd_sc_hd__decap_3
XFILLER_79_281 VGND VGND VPWR VPWR sky130_fd_sc_hd__fill_2
XFILLER_67_421 VGND VGND VPWR VPWR sky130_fd_sc_hd__fill_1
XFILLER_95_763 VGND VGND VPWR VPWR sky130_fd_sc_hd__decap_3
XFILLER_67_487 VGND VGND VPWR VPWR sky130_fd_sc_hd__decap_3
XFILLER_55_627 VGND VGND VPWR VPWR sky130_fd_sc_hd__decap_3
XFILLER_39_178 VGND VGND VPWR VPWR sky130_fd_sc_hd__fill_2
XFILLER_82_424 VGND VGND VPWR VPWR sky130_fd_sc_hd__decap_3
X_7952_ _7952_/A _8161_/B VGND VGND VPWR VPWR _8070_/C sky130_fd_sc_hd__nor2_2
XFILLER_54_126 VGND VGND VPWR VPWR sky130_fd_sc_hd__fill_1
XFILLER_82_446 VGND VGND VPWR VPWR sky130_fd_sc_hd__decap_3
XFILLER_54_148 VGND VGND VPWR VPWR sky130_fd_sc_hd__fill_2
X_6903_ _7148_/A _6903_/B VGND VGND VPWR VPWR _6903_/X sky130_fd_sc_hd__xor2_2
X_7883_ _7656_/A _7879_/X _7882_/X VGND VGND VPWR VPWR _7884_/B sky130_fd_sc_hd__a21o_2
XFILLER_63_682 VGND VGND VPWR VPWR sky130_fd_sc_hd__fill_2
XFILLER_23_524 VGND VGND VPWR VPWR sky130_fd_sc_hd__decap_3
X_6834_ _6834_/A _6834_/B VGND VGND VPWR VPWR _6835_/B sky130_fd_sc_hd__xor2_2
XFILLER_35_384 VGND VGND VPWR VPWR sky130_fd_sc_hd__decap_3
XFILLER_62_192 VGND VGND VPWR VPWR sky130_fd_sc_hd__decap_3
XFILLER_23_557 VGND VGND VPWR VPWR sky130_fd_sc_hd__decap_3
XFILLER_11_708 VGND VGND VPWR VPWR sky130_fd_sc_hd__decap_3
XFILLER_50_354 VGND VGND VPWR VPWR sky130_fd_sc_hd__decap_3
X_6765_ _6765_/A _6765_/B VGND VGND VPWR VPWR _6766_/B sky130_fd_sc_hd__nand2_2
XFILLER_50_365 VGND VGND VPWR VPWR sky130_fd_sc_hd__decap_3
XFILLER_23_579 VGND VGND VPWR VPWR sky130_fd_sc_hd__decap_3
XFILLER_10_218 VGND VGND VPWR VPWR sky130_fd_sc_hd__fill_1
X_8504_ _8504_/A _8504_/B VGND VGND VPWR VPWR _8504_/Y sky130_fd_sc_hd__nor2_2
XTAP_TAPCELL_ROW_98_1602 VGND VPWR sky130_fd_sc_hd__tapvpwrvgnd_1
X_5716_ _5716_/A _6758_/B VGND VGND VPWR VPWR _5718_/A sky130_fd_sc_hd__nand2_2
XFILLER_50_398 VGND VGND VPWR VPWR sky130_fd_sc_hd__decap_3
X_6696_ _6581_/B _6694_/X _6695_/X VGND VGND VPWR VPWR _6697_/C sky130_fd_sc_hd__a21oi_4
X_8435_ _8435_/A _8435_/B VGND VGND VPWR VPWR _8504_/A sky130_fd_sc_hd__xnor2_2
XFILLER_40_27 VGND VGND VPWR VPWR sky130_fd_sc_hd__fill_1
X_5647_ _5497_/A _5645_/X _5646_/X VGND VGND VPWR VPWR _5773_/A sky130_fd_sc_hd__a21oi_4
X_8366_ wire61/X _8357_/X _8360_/X _9219_/Q _8365_/X VGND VGND VPWR VPWR _8379_/B
+ sky130_fd_sc_hd__o221a_4
X_5578_ _5760_/A _5760_/B VGND VGND VPWR VPWR _5607_/B sky130_fd_sc_hd__nand2_2
XFILLER_117_673 VGND VGND VPWR VPWR sky130_fd_sc_hd__decap_3
X_7317_ _7317_/A _7317_/B VGND VGND VPWR VPWR _7317_/X sky130_fd_sc_hd__or2_2
X_4529_ _4529_/A VGND VGND VPWR VPWR _9017_/D sky130_fd_sc_hd__buf_1
XFILLER_104_323 VGND VGND VPWR VPWR sky130_fd_sc_hd__fill_1
X_8297_ _8297_/A VGND VGND VPWR VPWR _8297_/Y sky130_fd_sc_hd__inv_2
XFILLER_49_25 VGND VGND VPWR VPWR sky130_fd_sc_hd__decap_3
X_7248_ _6797_/B _7702_/A _7243_/B _7243_/A VGND VGND VPWR VPWR _7248_/X sky130_fd_sc_hd__a211o_2
XFILLER_58_410 VGND VGND VPWR VPWR sky130_fd_sc_hd__decap_3
X_7179_ _7179_/A _7179_/B VGND VGND VPWR VPWR _7183_/A sky130_fd_sc_hd__xnor2_2
XFILLER_58_421 VGND VGND VPWR VPWR sky130_fd_sc_hd__decap_3
XFILLER_105_42 VGND VGND VPWR VPWR sky130_fd_sc_hd__fill_2
XFILLER_58_465 VGND VGND VPWR VPWR sky130_fd_sc_hd__decap_3
XFILLER_73_402 VGND VGND VPWR VPWR sky130_fd_sc_hd__decap_3
XFILLER_18_307 VGND VGND VPWR VPWR sky130_fd_sc_hd__fill_1
XFILLER_100_573 VGND VGND VPWR VPWR sky130_fd_sc_hd__decap_3
XFILLER_58_487 VGND VGND VPWR VPWR sky130_fd_sc_hd__decap_3
XFILLER_45_104 VGND VGND VPWR VPWR sky130_fd_sc_hd__decap_3
XFILLER_85_273 VGND VGND VPWR VPWR sky130_fd_sc_hd__decap_3
XFILLER_58_498 VGND VGND VPWR VPWR sky130_fd_sc_hd__decap_3
XFILLER_46_638 VGND VGND VPWR VPWR sky130_fd_sc_hd__decap_3
XTAP_TAPCELL_ROW_107_1720 VGND VPWR sky130_fd_sc_hd__tapvpwrvgnd_1
XFILLER_73_446 VGND VGND VPWR VPWR sky130_fd_sc_hd__fill_2
XFILLER_65_68 VGND VGND VPWR VPWR sky130_fd_sc_hd__fill_2
XTAP_TAPCELL_ROW_107_1731 VGND VPWR sky130_fd_sc_hd__tapvpwrvgnd_1
XFILLER_45_148 VGND VGND VPWR VPWR sky130_fd_sc_hd__decap_3
XFILLER_121_30 VGND VGND VPWR VPWR sky130_fd_sc_hd__decap_3
XFILLER_54_682 VGND VGND VPWR VPWR sky130_fd_sc_hd__fill_1
XFILLER_14_513 VGND VGND VPWR VPWR sky130_fd_sc_hd__decap_3
XFILLER_81_12 VGND VGND VPWR VPWR sky130_fd_sc_hd__decap_3
XFILLER_60_129 VGND VGND VPWR VPWR sky130_fd_sc_hd__fill_2
XFILLER_41_310 VGND VGND VPWR VPWR sky130_fd_sc_hd__decap_3
XFILLER_121_63 VGND VGND VPWR VPWR sky130_fd_sc_hd__decap_3
XFILLER_26_395 VGND VGND VPWR VPWR sky130_fd_sc_hd__decap_3
XFILLER_81_34 VGND VGND VPWR VPWR sky130_fd_sc_hd__fill_2
XFILLER_53_181 VGND VGND VPWR VPWR sky130_fd_sc_hd__decap_3
XFILLER_14_557 VGND VGND VPWR VPWR sky130_fd_sc_hd__decap_3
XFILLER_121_96 VGND VGND VPWR VPWR sky130_fd_sc_hd__decap_3
XFILLER_41_343 VGND VGND VPWR VPWR sky130_fd_sc_hd__decap_3
XFILLER_41_376 VGND VGND VPWR VPWR sky130_fd_sc_hd__fill_1
XFILLER_6_701 VGND VGND VPWR VPWR sky130_fd_sc_hd__decap_3
XFILLER_14_94 VGND VGND VPWR VPWR sky130_fd_sc_hd__decap_3
XFILLER_10_752 VGND VGND VPWR VPWR sky130_fd_sc_hd__decap_3
XFILLER_127_415 VGND VGND VPWR VPWR sky130_fd_sc_hd__decap_3
XFILLER_10_763 VGND VGND VPWR VPWR sky130_fd_sc_hd__decap_3
XFILLER_127_426 VGND VGND VPWR VPWR sky130_fd_sc_hd__decap_3
XFILLER_6_734 VGND VGND VPWR VPWR sky130_fd_sc_hd__decap_3
XFILLER_108_651 VGND VGND VPWR VPWR sky130_fd_sc_hd__decap_3
XTAP_TAPCELL_ROW_118_1871 VGND VPWR sky130_fd_sc_hd__tapvpwrvgnd_1
XFILLER_5_266 VGND VGND VPWR VPWR sky130_fd_sc_hd__decap_3
XFILLER_108_695 VGND VGND VPWR VPWR sky130_fd_sc_hd__decap_3
XFILLER_123_654 VGND VGND VPWR VPWR sky130_fd_sc_hd__decap_3
XFILLER_69_719 VGND VGND VPWR VPWR sky130_fd_sc_hd__fill_2
XFILLER_122_153 VGND VGND VPWR VPWR sky130_fd_sc_hd__decap_3
XFILLER_122_186 VGND VGND VPWR VPWR sky130_fd_sc_hd__decap_3
XFILLER_77_741 VGND VGND VPWR VPWR sky130_fd_sc_hd__fill_2
XFILLER_122_197 VGND VGND VPWR VPWR sky130_fd_sc_hd__decap_3
XFILLER_110_359 VGND VGND VPWR VPWR sky130_fd_sc_hd__decap_3
XFILLER_76_251 VGND VGND VPWR VPWR sky130_fd_sc_hd__fill_1
Xinput9 sample_in[1] VGND VGND VPWR VPWR input9/X sky130_fd_sc_hd__clkbuf_2
XTAP_TAPCELL_ROW_69_1214 VGND VPWR sky130_fd_sc_hd__tapvpwrvgnd_1
XFILLER_49_487 VGND VGND VPWR VPWR sky130_fd_sc_hd__decap_3
XFILLER_76_284 VGND VGND VPWR VPWR sky130_fd_sc_hd__decap_3
XFILLER_36_159 VGND VGND VPWR VPWR sky130_fd_sc_hd__decap_3
XFILLER_17_340 VGND VGND VPWR VPWR sky130_fd_sc_hd__decap_3
XFILLER_91_265 VGND VGND VPWR VPWR sky130_fd_sc_hd__fill_1
XFILLER_45_682 VGND VGND VPWR VPWR sky130_fd_sc_hd__decap_3
XFILLER_17_384 VGND VGND VPWR VPWR sky130_fd_sc_hd__decap_3
X_4880_ _4907_/B VGND VGND VPWR VPWR _4899_/B sky130_fd_sc_hd__clkbuf_2
XFILLER_44_192 VGND VGND VPWR VPWR sky130_fd_sc_hd__decap_3
XTAP_TAPCELL_ROW_43_861 VGND VPWR sky130_fd_sc_hd__tapvpwrvgnd_1
XFILLER_32_365 VGND VGND VPWR VPWR sky130_fd_sc_hd__decap_3
XFILLER_20_516 VGND VGND VPWR VPWR sky130_fd_sc_hd__decap_3
XFILLER_32_387 VGND VGND VPWR VPWR sky130_fd_sc_hd__decap_3
X_6550_ _6992_/A _6550_/B _7430_/A _7430_/B VGND VGND VPWR VPWR _6550_/X sky130_fd_sc_hd__or4_4
XFILLER_118_404 VGND VGND VPWR VPWR sky130_fd_sc_hd__decap_3
X_5501_ _6436_/A _5804_/B _5804_/A _4970_/X VGND VGND VPWR VPWR _5501_/X sky130_fd_sc_hd__a211o_2
X_6481_ _6418_/A _6418_/B _6480_/X VGND VGND VPWR VPWR _6485_/A sky130_fd_sc_hd__a21oi_2
X_8220_ _8217_/Y _8219_/X _8187_/A VGND VGND VPWR VPWR _8220_/X sky130_fd_sc_hd__a21bo_2
X_5432_ _5019_/X _5272_/X _6313_/B1 _5041_/B VGND VGND VPWR VPWR _5433_/B sky130_fd_sc_hd__a211o_2
XFILLER_105_109 VGND VGND VPWR VPWR sky130_fd_sc_hd__decap_3
XTAP_TAPCELL_ROW_93_1532 VGND VPWR sky130_fd_sc_hd__tapvpwrvgnd_1
X_5363_ _6304_/A _5439_/S _5362_/X VGND VGND VPWR VPWR _5363_/Y sky130_fd_sc_hd__a21boi_2
X_8151_ _8149_/A _8058_/Y _8232_/A VGND VGND VPWR VPWR _8151_/X sky130_fd_sc_hd__mux2_2
XFILLER_99_310 VGND VGND VPWR VPWR sky130_fd_sc_hd__fill_2
XTAP_TAPCELL_ROW_93_1543 VGND VPWR sky130_fd_sc_hd__tapvpwrvgnd_1
XFILLER_99_321 VGND VGND VPWR VPWR sky130_fd_sc_hd__decap_3
X_7102_ _7103_/B _7103_/C _7103_/A VGND VGND VPWR VPWR _7102_/X sky130_fd_sc_hd__a21o_2
XFILLER_99_343 VGND VGND VPWR VPWR sky130_fd_sc_hd__decap_3
XFILLER_114_654 VGND VGND VPWR VPWR sky130_fd_sc_hd__decap_3
X_5294_ _6033_/A _5294_/B VGND VGND VPWR VPWR _7043_/A sky130_fd_sc_hd__and2_2
X_8082_ _9218_/Q VGND VGND VPWR VPWR _8271_/A sky130_fd_sc_hd__inv_2
XFILLER_87_505 VGND VGND VPWR VPWR sky130_fd_sc_hd__decap_3
XFILLER_87_516 VGND VGND VPWR VPWR sky130_fd_sc_hd__decap_3
XFILLER_114_698 VGND VGND VPWR VPWR sky130_fd_sc_hd__fill_2
X_7033_ _7033_/A _7033_/B VGND VGND VPWR VPWR _7033_/X sky130_fd_sc_hd__or2_4
XFILLER_87_549 VGND VGND VPWR VPWR sky130_fd_sc_hd__decap_3
XFILLER_101_337 VGND VGND VPWR VPWR sky130_fd_sc_hd__decap_3
XFILLER_68_763 VGND VGND VPWR VPWR sky130_fd_sc_hd__fill_1
XFILLER_28_627 VGND VGND VPWR VPWR sky130_fd_sc_hd__decap_3
XFILLER_95_593 VGND VGND VPWR VPWR sky130_fd_sc_hd__decap_3
XFILLER_67_284 VGND VGND VPWR VPWR sky130_fd_sc_hd__decap_3
X_8984_ _9333_/Q hold829/X _8988_/S VGND VGND VPWR VPWR _8984_/X sky130_fd_sc_hd__mux2_2
XFILLER_83_766 VGND VGND VPWR VPWR sky130_fd_sc_hd__decap_3
X_7935_ _7590_/A _7763_/B _7772_/B _7934_/Y VGND VGND VPWR VPWR _7936_/B sky130_fd_sc_hd__o31a_2
XFILLER_82_265 VGND VGND VPWR VPWR sky130_fd_sc_hd__fill_1
XFILLER_70_427 VGND VGND VPWR VPWR sky130_fd_sc_hd__decap_3
XFILLER_42_118 VGND VGND VPWR VPWR sky130_fd_sc_hd__decap_3
X_7866_ _7867_/A _8018_/A VGND VGND VPWR VPWR _7866_/Y sky130_fd_sc_hd__nand2_2
XFILLER_23_321 VGND VGND VPWR VPWR sky130_fd_sc_hd__decap_3
X_6817_ _6817_/A _7170_/S VGND VGND VPWR VPWR _6817_/Y sky130_fd_sc_hd__xnor2_2
X_7797_ _7609_/A _7608_/B _7608_/A VGND VGND VPWR VPWR _7797_/Y sky130_fd_sc_hd__a21boi_2
XFILLER_51_685 VGND VGND VPWR VPWR sky130_fd_sc_hd__decap_3
XTAP_TAPCELL_ROW_102_1661 VGND VPWR sky130_fd_sc_hd__tapvpwrvgnd_1
XFILLER_23_387 VGND VGND VPWR VPWR sky130_fd_sc_hd__decap_3
X_6748_ _9211_/Q _7117_/A VGND VGND VPWR VPWR _6934_/B sky130_fd_sc_hd__xnor2_2
XFILLER_50_195 VGND VGND VPWR VPWR sky130_fd_sc_hd__fill_1
XFILLER_109_426 VGND VGND VPWR VPWR sky130_fd_sc_hd__decap_3
XTAP_TAPCELL_ROW_21_566 VGND VPWR sky130_fd_sc_hd__tapvpwrvgnd_1
XFILLER_129_6 VGND VGND VPWR VPWR sky130_fd_sc_hd__decap_3
X_6679_ _6547_/A _6547_/B _6678_/X VGND VGND VPWR VPWR _6691_/A sky130_fd_sc_hd__o21a_2
X_8418_ _8332_/A _8418_/B _8482_/A VGND VGND VPWR VPWR _8418_/Y sky130_fd_sc_hd__nand3b_2
XFILLER_124_418 VGND VGND VPWR VPWR sky130_fd_sc_hd__fill_2
XFILLER_3_715 VGND VGND VPWR VPWR sky130_fd_sc_hd__decap_3
XFILLER_124_429 VGND VGND VPWR VPWR sky130_fd_sc_hd__decap_3
X_8349_ _8446_/B _8349_/B VGND VGND VPWR VPWR _8399_/A sky130_fd_sc_hd__xnor2_2
XFILLER_117_481 VGND VGND VPWR VPWR sky130_fd_sc_hd__decap_3
XFILLER_3_759 VGND VGND VPWR VPWR sky130_fd_sc_hd__decap_3
XFILLER_78_505 VGND VGND VPWR VPWR sky130_fd_sc_hd__fill_2
XFILLER_105_676 VGND VGND VPWR VPWR sky130_fd_sc_hd__decap_3
XFILLER_120_602 VGND VGND VPWR VPWR sky130_fd_sc_hd__decap_3
XFILLER_116_41 VGND VGND VPWR VPWR sky130_fd_sc_hd__decap_3
XFILLER_78_538 VGND VGND VPWR VPWR sky130_fd_sc_hd__decap_3
XFILLER_120_624 VGND VGND VPWR VPWR sky130_fd_sc_hd__decap_3
XFILLER_104_197 VGND VGND VPWR VPWR sky130_fd_sc_hd__decap_3
XFILLER_116_74 VGND VGND VPWR VPWR sky130_fd_sc_hd__decap_3
XFILLER_116_85 VGND VGND VPWR VPWR sky130_fd_sc_hd__decap_3
XFILLER_59_752 VGND VGND VPWR VPWR sky130_fd_sc_hd__decap_3
XFILLER_93_508 VGND VGND VPWR VPWR sky130_fd_sc_hd__fill_1
XFILLER_76_56 VGND VGND VPWR VPWR sky130_fd_sc_hd__decap_3
XFILLER_18_115 VGND VGND VPWR VPWR sky130_fd_sc_hd__decap_3
XFILLER_46_457 VGND VGND VPWR VPWR sky130_fd_sc_hd__decap_3
XFILLER_73_265 VGND VGND VPWR VPWR sky130_fd_sc_hd__decap_3
XTAP_TAPCELL_ROW_29_677 VGND VPWR sky130_fd_sc_hd__tapvpwrvgnd_1
XFILLER_27_671 VGND VGND VPWR VPWR sky130_fd_sc_hd__fill_1
XTAP_TAPCELL_ROW_1_291 VGND VPWR sky130_fd_sc_hd__tapvpwrvgnd_1
XFILLER_61_449 VGND VGND VPWR VPWR sky130_fd_sc_hd__decap_3
XFILLER_14_321 VGND VGND VPWR VPWR sky130_fd_sc_hd__decap_3
XFILLER_54_490 VGND VGND VPWR VPWR sky130_fd_sc_hd__fill_1
XTAP_TAPCELL_ROW_64_1144 VGND VPWR sky130_fd_sc_hd__tapvpwrvgnd_1
XFILLER_14_332 VGND VGND VPWR VPWR sky130_fd_sc_hd__decap_3
XFILLER_14_365 VGND VGND VPWR VPWR sky130_fd_sc_hd__decap_3
XFILLER_41_151 VGND VGND VPWR VPWR sky130_fd_sc_hd__decap_3
XTAP_TAPCELL_ROW_40_820 VGND VPWR sky130_fd_sc_hd__tapvpwrvgnd_1
XFILLER_41_184 VGND VGND VPWR VPWR sky130_fd_sc_hd__decap_3
XFILLER_128_713 VGND VGND VPWR VPWR sky130_fd_sc_hd__decap_3
XFILLER_128_746 VGND VGND VPWR VPWR sky130_fd_sc_hd__decap_3
XFILLER_10_560 VGND VGND VPWR VPWR sky130_fd_sc_hd__decap_3
XFILLER_6_520 VGND VGND VPWR VPWR sky130_fd_sc_hd__fill_2
XFILLER_128_757 VGND VGND VPWR VPWR sky130_fd_sc_hd__decap_3
XFILLER_127_223 VGND VGND VPWR VPWR sky130_fd_sc_hd__fill_1
XFILLER_127_234 VGND VGND VPWR VPWR sky130_fd_sc_hd__decap_3
XFILLER_6_542 VGND VGND VPWR VPWR sky130_fd_sc_hd__decap_3
XFILLER_115_407 VGND VGND VPWR VPWR sky130_fd_sc_hd__decap_3
XFILLER_6_564 VGND VGND VPWR VPWR sky130_fd_sc_hd__decap_3
XFILLER_115_429 VGND VGND VPWR VPWR sky130_fd_sc_hd__decap_3
XFILLER_6_597 VGND VGND VPWR VPWR sky130_fd_sc_hd__decap_3
XFILLER_44_6 VGND VGND VPWR VPWR sky130_fd_sc_hd__fill_2
XFILLER_123_440 VGND VGND VPWR VPWR sky130_fd_sc_hd__decap_3
XFILLER_69_505 VGND VGND VPWR VPWR sky130_fd_sc_hd__decap_3
XTAP_TAPCELL_ROW_75_1295 VGND VPWR sky130_fd_sc_hd__tapvpwrvgnd_1
XFILLER_69_549 VGND VGND VPWR VPWR sky130_fd_sc_hd__decap_3
XPHY_EDGE_ROW_10_Right_10 VGND VGND VPWR VPWR sky130_fd_sc_hd__decap_3
XFILLER_49_240 VGND VGND VPWR VPWR sky130_fd_sc_hd__decap_3
XFILLER_111_679 VGND VGND VPWR VPWR sky130_fd_sc_hd__fill_2
XFILLER_2_53 VGND VGND VPWR VPWR sky130_fd_sc_hd__decap_3
XFILLER_110_167 VGND VGND VPWR VPWR sky130_fd_sc_hd__decap_3
XFILLER_49_273 VGND VGND VPWR VPWR sky130_fd_sc_hd__decap_3
XFILLER_37_413 VGND VGND VPWR VPWR sky130_fd_sc_hd__fill_1
XFILLER_49_284 VGND VGND VPWR VPWR sky130_fd_sc_hd__fill_2
XTAP_TAPCELL_ROW_48_931 VGND VPWR sky130_fd_sc_hd__tapvpwrvgnd_1
XFILLER_2_97 VGND VGND VPWR VPWR sky130_fd_sc_hd__decap_3
XFILLER_92_530 VGND VGND VPWR VPWR sky130_fd_sc_hd__fill_2
XFILLER_37_446 VGND VGND VPWR VPWR sky130_fd_sc_hd__fill_2
XFILLER_64_232 VGND VGND VPWR VPWR sky130_fd_sc_hd__decap_3
XFILLER_92_552 VGND VGND VPWR VPWR sky130_fd_sc_hd__decap_3
XFILLER_37_468 VGND VGND VPWR VPWR sky130_fd_sc_hd__fill_2
XFILLER_25_608 VGND VGND VPWR VPWR sky130_fd_sc_hd__decap_3
XFILLER_92_574 VGND VGND VPWR VPWR sky130_fd_sc_hd__decap_3
X_5981_ _7065_/B VGND VGND VPWR VPWR _8231_/A sky130_fd_sc_hd__clkbuf_2
XFILLER_52_416 VGND VGND VPWR VPWR sky130_fd_sc_hd__decap_3
X_7720_ _7881_/C _7720_/B VGND VGND VPWR VPWR _7721_/B sky130_fd_sc_hd__xnor2_2
XFILLER_24_129 VGND VGND VPWR VPWR sky130_fd_sc_hd__decap_3
X_4932_ _9270_/Q _6757_/B _6756_/B VGND VGND VPWR VPWR _4940_/C sky130_fd_sc_hd__and3_2
XFILLER_17_181 VGND VGND VPWR VPWR sky130_fd_sc_hd__decap_3
XFILLER_33_641 VGND VGND VPWR VPWR sky130_fd_sc_hd__decap_3
X_7651_ _7651_/A _7899_/A VGND VGND VPWR VPWR _7651_/Y sky130_fd_sc_hd__xnor2_2
X_4863_ _8990_/A VGND VGND VPWR VPWR _8969_/A sky130_fd_sc_hd__buf_1
X_6602_ _9332_/Q _6603_/B _6604_/C VGND VGND VPWR VPWR _6602_/X sky130_fd_sc_hd__and3_2
XFILLER_60_493 VGND VGND VPWR VPWR sky130_fd_sc_hd__decap_3
X_7582_ _7582_/A _7816_/B VGND VGND VPWR VPWR _7583_/B sky130_fd_sc_hd__xor2_2
X_4794_ _4828_/A1 _4794_/A1 _4798_/S VGND VGND VPWR VPWR _4795_/A sky130_fd_sc_hd__mux2_2
XFILLER_119_702 VGND VGND VPWR VPWR sky130_fd_sc_hd__decap_3
X_9321_ clkload4/A _9321_/D wire372/X VGND VGND VPWR VPWR _9321_/Q sky130_fd_sc_hd__dfrtp_2
X_6533_ _6533_/A1 _6363_/B _6535_/A _6532_/X VGND VGND VPWR VPWR _6534_/B sky130_fd_sc_hd__a31o_2
XFILLER_119_735 VGND VGND VPWR VPWR sky130_fd_sc_hd__decap_3
XFILLER_21_18 VGND VGND VPWR VPWR sky130_fd_sc_hd__decap_3
XFILLER_119_768 VGND VGND VPWR VPWR sky130_fd_sc_hd__decap_3
X_9252_ clkload3/A _9252_/D load_slew374/X VGND VGND VPWR VPWR _9252_/Q sky130_fd_sc_hd__dfrtp_2
X_6464_ _6470_/A _6412_/A _7533_/A VGND VGND VPWR VPWR _6464_/X sky130_fd_sc_hd__o21a_2
XFILLER_118_267 VGND VGND VPWR VPWR sky130_fd_sc_hd__decap_3
X_8203_ _8283_/A _8283_/C VGND VGND VPWR VPWR _8204_/B sky130_fd_sc_hd__xor2_2
XFILLER_118_289 VGND VGND VPWR VPWR sky130_fd_sc_hd__decap_3
X_5415_ _5416_/A _5416_/B VGND VGND VPWR VPWR _5417_/A sky130_fd_sc_hd__nor2_2
X_9183_ _9189_/CLK _9183_/D fanout413/X VGND VGND VPWR VPWR _9183_/Q sky130_fd_sc_hd__dfrtp_2
X_6395_ _6395_/A _6809_/A VGND VGND VPWR VPWR _6395_/Y sky130_fd_sc_hd__nand2_2
X_8134_ _8283_/B VGND VGND VPWR VPWR _8189_/A sky130_fd_sc_hd__inv_2
XFILLER_0_707 VGND VGND VPWR VPWR sky130_fd_sc_hd__decap_3
X_5346_ _5346_/A _5346_/B VGND VGND VPWR VPWR _5347_/B sky130_fd_sc_hd__xnor2_2
XFILLER_114_462 VGND VGND VPWR VPWR sky130_fd_sc_hd__fill_1
XFILLER_0_729 VGND VGND VPWR VPWR sky130_fd_sc_hd__decap_3
XFILLER_102_635 VGND VGND VPWR VPWR sky130_fd_sc_hd__decap_3
X_8065_ _7943_/A _7942_/A _8064_/X VGND VGND VPWR VPWR _8073_/A sky130_fd_sc_hd__o21a_2
X_5277_ _9201_/Q VGND VGND VPWR VPWR _5279_/A sky130_fd_sc_hd__inv_2
XFILLER_102_657 VGND VGND VPWR VPWR sky130_fd_sc_hd__decap_3
XFILLER_87_357 VGND VGND VPWR VPWR sky130_fd_sc_hd__decap_3
X_7016_ _7016_/A _7016_/B _7016_/C VGND VGND VPWR VPWR _7016_/X sky130_fd_sc_hd__and3_2
XFILLER_75_508 VGND VGND VPWR VPWR sky130_fd_sc_hd__decap_3
XFILLER_56_711 VGND VGND VPWR VPWR sky130_fd_sc_hd__decap_3
XFILLER_28_402 VGND VGND VPWR VPWR sky130_fd_sc_hd__decap_3
XFILLER_28_424 VGND VGND VPWR VPWR sky130_fd_sc_hd__decap_3
XFILLER_56_744 VGND VGND VPWR VPWR sky130_fd_sc_hd__decap_3
XFILLER_95_390 VGND VGND VPWR VPWR sky130_fd_sc_hd__fill_2
XFILLER_83_530 VGND VGND VPWR VPWR sky130_fd_sc_hd__decap_3
XPHY_EDGE_ROW_106_Right_106 VGND VGND VPWR VPWR sky130_fd_sc_hd__decap_3
Xmax_cap49 _8678_/B VGND VGND VPWR VPWR _8676_/C sky130_fd_sc_hd__clkbuf_2
X_8967_ _9001_/A1 _8967_/A1 _8967_/S VGND VGND VPWR VPWR _8968_/A sky130_fd_sc_hd__mux2_2
XFILLER_83_596 VGND VGND VPWR VPWR sky130_fd_sc_hd__decap_3
XFILLER_15_129 VGND VGND VPWR VPWR sky130_fd_sc_hd__fill_1
X_7918_ _7840_/B _7914_/X _7915_/Y _7824_/A _7917_/Y VGND VGND VPWR VPWR _7918_/X
+ sky130_fd_sc_hd__o221a_2
XTAP_TAPCELL_ROW_26_636 VGND VPWR sky130_fd_sc_hd__tapvpwrvgnd_1
XFILLER_43_449 VGND VGND VPWR VPWR sky130_fd_sc_hd__decap_3
XFILLER_36_490 VGND VGND VPWR VPWR sky130_fd_sc_hd__decap_3
X_8898_ _9292_/Q hold878/X _8904_/S VGND VGND VPWR VPWR _8898_/X sky130_fd_sc_hd__mux2_2
Xclkbuf_leaf_35_clk clkload1/A VGND VGND VPWR VPWR _9209_/CLK sky130_fd_sc_hd__clkbuf_8
X_7849_ _7651_/A _7650_/A _7848_/X VGND VGND VPWR VPWR _7850_/B sky130_fd_sc_hd__o21a_2
XFILLER_24_674 VGND VGND VPWR VPWR sky130_fd_sc_hd__decap_3
XFILLER_11_302 VGND VGND VPWR VPWR sky130_fd_sc_hd__decap_3
XFILLER_24_696 VGND VGND VPWR VPWR sky130_fd_sc_hd__decap_3
XFILLER_51_493 VGND VGND VPWR VPWR sky130_fd_sc_hd__decap_3
Xwire226 wire226/A VGND VGND VPWR VPWR result_out[2] sky130_fd_sc_hd__buf_4
XFILLER_127_3 VGND VGND VPWR VPWR sky130_fd_sc_hd__decap_3
XFILLER_109_234 VGND VGND VPWR VPWR sky130_fd_sc_hd__decap_3
XPHY_EDGE_ROW_12_Left_143 VGND VGND VPWR VPWR sky130_fd_sc_hd__decap_3
XFILLER_125_716 VGND VGND VPWR VPWR sky130_fd_sc_hd__decap_3
XFILLER_109_289 VGND VGND VPWR VPWR sky130_fd_sc_hd__fill_2
XFILLER_125_738 VGND VGND VPWR VPWR sky130_fd_sc_hd__decap_3
XTAP_TAPCELL_ROW_115_1830 VGND VPWR sky130_fd_sc_hd__tapvpwrvgnd_1
XFILLER_124_215 VGND VGND VPWR VPWR sky130_fd_sc_hd__decap_3
XFILLER_11_51 VGND VGND VPWR VPWR sky130_fd_sc_hd__decap_3
XFILLER_3_523 VGND VGND VPWR VPWR sky130_fd_sc_hd__fill_2
XFILLER_124_248 VGND VGND VPWR VPWR sky130_fd_sc_hd__decap_3
XFILLER_127_51 VGND VGND VPWR VPWR sky130_fd_sc_hd__decap_3
XFILLER_3_556 VGND VGND VPWR VPWR sky130_fd_sc_hd__decap_3
XFILLER_124_259 VGND VGND VPWR VPWR sky130_fd_sc_hd__decap_3
XFILLER_11_95 VGND VGND VPWR VPWR sky130_fd_sc_hd__decap_3
XFILLER_87_22 VGND VGND VPWR VPWR sky130_fd_sc_hd__decap_3
XFILLER_127_84 VGND VGND VPWR VPWR sky130_fd_sc_hd__decap_3
XFILLER_105_462 VGND VGND VPWR VPWR sky130_fd_sc_hd__decap_3
XFILLER_3_589 VGND VGND VPWR VPWR sky130_fd_sc_hd__decap_3
XFILLER_87_55 VGND VGND VPWR VPWR sky130_fd_sc_hd__fill_1
XFILLER_105_495 VGND VGND VPWR VPWR sky130_fd_sc_hd__decap_3
XFILLER_87_77 VGND VGND VPWR VPWR sky130_fd_sc_hd__decap_3
XFILLER_78_368 VGND VGND VPWR VPWR sky130_fd_sc_hd__decap_3
XFILLER_120_454 VGND VGND VPWR VPWR sky130_fd_sc_hd__decap_3
XTAP_TAPCELL_ROW_6_361 VGND VPWR sky130_fd_sc_hd__tapvpwrvgnd_1
XFILLER_93_305 VGND VGND VPWR VPWR sky130_fd_sc_hd__decap_3
XFILLER_47_711 VGND VGND VPWR VPWR sky130_fd_sc_hd__fill_1
Xfanout381 fanout385/X VGND VGND VPWR VPWR fanout381/X sky130_fd_sc_hd__clkdlybuf4s25_1
XPHY_EDGE_ROW_21_Left_152 VGND VGND VPWR VPWR sky130_fd_sc_hd__decap_3
Xfanout392 fanout402/X VGND VGND VPWR VPWR fanout392/X sky130_fd_sc_hd__clkdlybuf4s25_1
XFILLER_59_582 VGND VGND VPWR VPWR sky130_fd_sc_hd__decap_3
XFILLER_47_744 VGND VGND VPWR VPWR sky130_fd_sc_hd__decap_3
XFILLER_74_563 VGND VGND VPWR VPWR sky130_fd_sc_hd__fill_1
XFILLER_19_479 VGND VGND VPWR VPWR sky130_fd_sc_hd__decap_3
XFILLER_74_585 VGND VGND VPWR VPWR sky130_fd_sc_hd__decap_3
XFILLER_46_276 VGND VGND VPWR VPWR sky130_fd_sc_hd__decap_3
XFILLER_34_427 VGND VGND VPWR VPWR sky130_fd_sc_hd__decap_3
XTAP_TAPCELL_ROW_126_1981 VGND VPWR sky130_fd_sc_hd__tapvpwrvgnd_1
Xclkbuf_leaf_26_clk clkload1/A VGND VGND VPWR VPWR _9343_/CLK sky130_fd_sc_hd__clkbuf_8
XFILLER_15_641 VGND VGND VPWR VPWR sky130_fd_sc_hd__decap_3
XFILLER_61_257 VGND VGND VPWR VPWR sky130_fd_sc_hd__decap_3
XFILLER_15_685 VGND VGND VPWR VPWR sky130_fd_sc_hd__decap_3
XFILLER_30_622 VGND VGND VPWR VPWR sky130_fd_sc_hd__fill_2
XPHY_EDGE_ROW_30_Left_161 VGND VGND VPWR VPWR sky130_fd_sc_hd__decap_3
XFILLER_128_521 VGND VGND VPWR VPWR sky130_fd_sc_hd__fill_2
Xinput12 sample_in[4] VGND VGND VPWR VPWR _5674_/A sky130_fd_sc_hd__clkbuf_2
XTAP_TAPCELL_ROW_77_1324 VGND VPWR sky130_fd_sc_hd__tapvpwrvgnd_1
XFILLER_128_576 VGND VGND VPWR VPWR sky130_fd_sc_hd__decap_3
Xhold807 _9214_/Q VGND VGND VPWR VPWR hold807/X sky130_fd_sc_hd__dlygate4sd3_1
XFILLER_6_361 VGND VGND VPWR VPWR sky130_fd_sc_hd__decap_3
Xhold818 _4902_/X VGND VGND VPWR VPWR _9191_/D sky130_fd_sc_hd__dlygate4sd3_1
XFILLER_128_598 VGND VGND VPWR VPWR sky130_fd_sc_hd__decap_3
Xhold829 _9317_/Q VGND VGND VPWR VPWR hold829/X sky130_fd_sc_hd__dlygate4sd3_1
XFILLER_6_383 VGND VGND VPWR VPWR sky130_fd_sc_hd__decap_3
X_5200_ _6206_/C _5197_/Y _5199_/X _5283_/A VGND VGND VPWR VPWR _5201_/A sky130_fd_sc_hd__a211o_2
XTAP_TAPCELL_ROW_90_1502 VGND VPWR sky130_fd_sc_hd__tapvpwrvgnd_1
XFILLER_42_3 VGND VGND VPWR VPWR sky130_fd_sc_hd__decap_3
X_6180_ _6180_/A _6180_/B VGND VGND VPWR VPWR _6181_/A sky130_fd_sc_hd__xnor2_4
XFILLER_124_760 VGND VGND VPWR VPWR sky130_fd_sc_hd__decap_3
XFILLER_130_218 VGND VGND VPWR VPWR sky130_fd_sc_hd__decap_3
X_5131_ _7313_/A _7313_/B VGND VGND VPWR VPWR _7099_/C sky130_fd_sc_hd__nand2_8
XFILLER_123_292 VGND VGND VPWR VPWR sky130_fd_sc_hd__decap_3
XFILLER_97_666 VGND VGND VPWR VPWR sky130_fd_sc_hd__decap_3
XFILLER_57_508 VGND VGND VPWR VPWR sky130_fd_sc_hd__decap_3
X_5062_ _5062_/A _5990_/A VGND VGND VPWR VPWR _5062_/X sky130_fd_sc_hd__and2_4
XFILLER_84_305 VGND VGND VPWR VPWR sky130_fd_sc_hd__decap_3
XFILLER_111_498 VGND VGND VPWR VPWR sky130_fd_sc_hd__decap_3
XFILLER_38_733 VGND VGND VPWR VPWR sky130_fd_sc_hd__decap_3
XFILLER_37_221 VGND VGND VPWR VPWR sky130_fd_sc_hd__decap_3
XFILLER_38_755 VGND VGND VPWR VPWR sky130_fd_sc_hd__fill_1
XFILLER_38_766 VGND VGND VPWR VPWR sky130_fd_sc_hd__decap_3
XFILLER_65_552 VGND VGND VPWR VPWR sky130_fd_sc_hd__decap_3
X_8821_ _8821_/A VGND VGND VPWR VPWR _9255_/D sky130_fd_sc_hd__buf_1
XTAP_TAPCELL_ROW_88_1464 VGND VPWR sky130_fd_sc_hd__tapvpwrvgnd_1
XTAP_TAPCELL_ROW_88_1475 VGND VPWR sky130_fd_sc_hd__tapvpwrvgnd_1
XFILLER_80_500 VGND VGND VPWR VPWR sky130_fd_sc_hd__decap_3
XFILLER_16_18 VGND VGND VPWR VPWR sky130_fd_sc_hd__decap_3
XFILLER_53_736 VGND VGND VPWR VPWR sky130_fd_sc_hd__decap_3
XFILLER_37_287 VGND VGND VPWR VPWR sky130_fd_sc_hd__fill_1
XFILLER_16_29 VGND VGND VPWR VPWR sky130_fd_sc_hd__decap_3
XFILLER_80_533 VGND VGND VPWR VPWR sky130_fd_sc_hd__decap_3
X_8752_ _8750_/X _8751_/Y _8753_/A VGND VGND VPWR VPWR _8752_/X sky130_fd_sc_hd__mux2_2
X_5964_ _5965_/A _5965_/B VGND VGND VPWR VPWR _5966_/A sky130_fd_sc_hd__and2_2
Xclkbuf_leaf_17_clk clkbuf_leaf_9_clk/A VGND VGND VPWR VPWR _9313_/CLK sky130_fd_sc_hd__clkbuf_8
X_7703_ _7740_/A _7703_/B VGND VGND VPWR VPWR _7703_/X sky130_fd_sc_hd__and2_2
X_4915_ _5050_/A _5143_/B VGND VGND VPWR VPWR _4916_/A sky130_fd_sc_hd__nor2_2
X_8683_ _8706_/C _8718_/A VGND VGND VPWR VPWR _8684_/B sky130_fd_sc_hd__nand2_2
XFILLER_80_599 VGND VGND VPWR VPWR sky130_fd_sc_hd__fill_1
XFILLER_33_460 VGND VGND VPWR VPWR sky130_fd_sc_hd__decap_3
X_5895_ _6246_/A _5895_/B _5895_/C VGND VGND VPWR VPWR _5900_/B sky130_fd_sc_hd__or3_4
XFILLER_33_482 VGND VGND VPWR VPWR sky130_fd_sc_hd__decap_3
X_7634_ _7634_/A _7634_/B VGND VGND VPWR VPWR _7634_/Y sky130_fd_sc_hd__xnor2_4
X_4846_ _4846_/A VGND VGND VPWR VPWR _9167_/D sky130_fd_sc_hd__buf_1
XFILLER_21_688 VGND VGND VPWR VPWR sky130_fd_sc_hd__decap_3
X_7565_ _7565_/A _7565_/B VGND VGND VPWR VPWR _7565_/Y sky130_fd_sc_hd__nand2_2
XFILLER_20_165 VGND VGND VPWR VPWR sky130_fd_sc_hd__decap_3
XFILLER_119_521 VGND VGND VPWR VPWR sky130_fd_sc_hd__fill_2
X_4777_ hold835/X _4777_/A1 _4777_/S VGND VGND VPWR VPWR _4778_/A sky130_fd_sc_hd__mux2_2
X_9304_ clkload5/A _9304_/D fanout373/X VGND VGND VPWR VPWR _9304_/Q sky130_fd_sc_hd__dfrtp_2
XTAP_TAPCELL_ROW_31_694 VGND VPWR sky130_fd_sc_hd__tapvpwrvgnd_1
XFILLER_119_554 VGND VGND VPWR VPWR sky130_fd_sc_hd__decap_3
X_6516_ _6516_/A_N _6523_/A VGND VGND VPWR VPWR _6516_/Y sky130_fd_sc_hd__nand2b_4
X_7496_ _7496_/A _7496_/B VGND VGND VPWR VPWR _7496_/X sky130_fd_sc_hd__or2_2
XFILLER_4_309 VGND VGND VPWR VPWR sky130_fd_sc_hd__decap_3
XFILLER_113_9 VGND VGND VPWR VPWR sky130_fd_sc_hd__decap_3
XFILLER_107_738 VGND VGND VPWR VPWR sky130_fd_sc_hd__decap_3
X_9235_ _9333_/CLK _9235_/D wire417/X VGND VGND VPWR VPWR _9235_/Q sky130_fd_sc_hd__dfrtp_2
X_6447_ _6885_/A VGND VGND VPWR VPWR _6886_/B sky130_fd_sc_hd__inv_2
XFILLER_106_237 VGND VGND VPWR VPWR sky130_fd_sc_hd__decap_3
X_9166_ _9339_/CLK _9166_/D fanout383/X VGND VGND VPWR VPWR _9166_/Q sky130_fd_sc_hd__dfrtp_2
XFILLER_88_600 VGND VGND VPWR VPWR sky130_fd_sc_hd__decap_3
X_6378_ _6378_/A _6378_/B VGND VGND VPWR VPWR _6378_/Y sky130_fd_sc_hd__nor2_2
XFILLER_0_526 VGND VGND VPWR VPWR sky130_fd_sc_hd__decap_3
X_8117_ _8045_/X _8116_/Y _8117_/S VGND VGND VPWR VPWR _8118_/A sky130_fd_sc_hd__mux2_2
XFILLER_102_421 VGND VGND VPWR VPWR sky130_fd_sc_hd__decap_3
X_5329_ _5320_/Y _5328_/Y _6441_/A1 VGND VGND VPWR VPWR _5330_/B sky130_fd_sc_hd__a21oi_2
XFILLER_0_548 VGND VGND VPWR VPWR sky130_fd_sc_hd__decap_3
X_9097_ _9228_/CLK _9097_/D wire406/A VGND VGND VPWR VPWR _9097_/Q sky130_fd_sc_hd__dfrtp_2
XFILLER_130_741 VGND VGND VPWR VPWR sky130_fd_sc_hd__decap_3
XTAP_TAPCELL_ROW_110_1760 VGND VPWR sky130_fd_sc_hd__tapvpwrvgnd_1
XFILLER_130_763 VGND VGND VPWR VPWR sky130_fd_sc_hd__decap_3
X_8048_ _8048_/A VGND VGND VPWR VPWR _8048_/Y sky130_fd_sc_hd__inv_2
XFILLER_88_688 VGND VGND VPWR VPWR sky130_fd_sc_hd__decap_3
XFILLER_75_305 VGND VGND VPWR VPWR sky130_fd_sc_hd__decap_3
XFILLER_57_36 VGND VGND VPWR VPWR sky130_fd_sc_hd__decap_3
XTAP_TAPCELL_ROW_110_1771 VGND VPWR sky130_fd_sc_hd__tapvpwrvgnd_1
XTAP_TAPCELL_ROW_3_320 VGND VPWR sky130_fd_sc_hd__tapvpwrvgnd_1
XFILLER_87_187 VGND VGND VPWR VPWR sky130_fd_sc_hd__decap_3
XFILLER_75_327 VGND VGND VPWR VPWR sky130_fd_sc_hd__decap_3
XFILLER_57_69 VGND VGND VPWR VPWR sky130_fd_sc_hd__decap_3
XFILLER_28_221 VGND VGND VPWR VPWR sky130_fd_sc_hd__decap_3
XFILLER_56_541 VGND VGND VPWR VPWR sky130_fd_sc_hd__decap_3
XFILLER_29_766 VGND VGND VPWR VPWR sky130_fd_sc_hd__decap_3
XFILLER_113_42 VGND VGND VPWR VPWR sky130_fd_sc_hd__decap_3
XFILLER_44_714 VGND VGND VPWR VPWR sky130_fd_sc_hd__decap_3
XFILLER_56_585 VGND VGND VPWR VPWR sky130_fd_sc_hd__decap_3
XFILLER_71_522 VGND VGND VPWR VPWR sky130_fd_sc_hd__decap_3
XFILLER_71_533 VGND VGND VPWR VPWR sky130_fd_sc_hd__decap_3
XFILLER_28_298 VGND VGND VPWR VPWR sky130_fd_sc_hd__fill_2
XFILLER_73_57 VGND VGND VPWR VPWR sky130_fd_sc_hd__decap_3
XFILLER_43_235 VGND VGND VPWR VPWR sky130_fd_sc_hd__decap_3
XFILLER_71_555 VGND VGND VPWR VPWR sky130_fd_sc_hd__decap_3
XFILLER_31_408 VGND VGND VPWR VPWR sky130_fd_sc_hd__decap_3
Xwire91 wire91/A VGND VGND VPWR VPWR wire91/X sky130_fd_sc_hd__buf_2
XFILLER_24_460 VGND VGND VPWR VPWR sky130_fd_sc_hd__decap_3
XFILLER_12_600 VGND VGND VPWR VPWR sky130_fd_sc_hd__decap_3
XTAP_TAPCELL_ROW_61_1103 VGND VPWR sky130_fd_sc_hd__tapvpwrvgnd_1
XFILLER_7_125 VGND VGND VPWR VPWR sky130_fd_sc_hd__decap_3
XFILLER_8_659 VGND VGND VPWR VPWR sky130_fd_sc_hd__decap_3
XFILLER_125_502 VGND VGND VPWR VPWR sky130_fd_sc_hd__fill_2
XTAP_TAPCELL_ROW_59_1076 VGND VPWR sky130_fd_sc_hd__tapvpwrvgnd_1
XFILLER_125_579 VGND VGND VPWR VPWR sky130_fd_sc_hd__fill_1
XFILLER_79_600 VGND VGND VPWR VPWR sky130_fd_sc_hd__decap_3
XFILLER_78_110 VGND VGND VPWR VPWR sky130_fd_sc_hd__decap_3
XFILLER_105_281 VGND VGND VPWR VPWR sky130_fd_sc_hd__fill_1
XTAP_TAPCELL_ROW_72_1254 VGND VPWR sky130_fd_sc_hd__tapvpwrvgnd_1
XFILLER_79_644 VGND VGND VPWR VPWR sky130_fd_sc_hd__decap_3
XFILLER_121_741 VGND VGND VPWR VPWR sky130_fd_sc_hd__decap_3
XFILLER_79_677 VGND VGND VPWR VPWR sky130_fd_sc_hd__decap_3
XFILLER_39_508 VGND VGND VPWR VPWR sky130_fd_sc_hd__decap_3
XFILLER_121_774 VGND VGND VPWR VPWR sky130_fd_sc_hd__decap_3
XFILLER_66_305 VGND VGND VPWR VPWR sky130_fd_sc_hd__decap_3
XFILLER_93_113 VGND VGND VPWR VPWR sky130_fd_sc_hd__decap_3
XFILLER_66_327 VGND VGND VPWR VPWR sky130_fd_sc_hd__fill_1
XFILLER_120_273 VGND VGND VPWR VPWR sky130_fd_sc_hd__decap_3
XFILLER_94_658 VGND VGND VPWR VPWR sky130_fd_sc_hd__decap_3
XFILLER_59_390 VGND VGND VPWR VPWR sky130_fd_sc_hd__fill_2
XFILLER_47_530 VGND VGND VPWR VPWR sky130_fd_sc_hd__decap_3
XFILLER_93_146 VGND VGND VPWR VPWR sky130_fd_sc_hd__decap_3
XFILLER_47_80 VGND VGND VPWR VPWR sky130_fd_sc_hd__decap_3
XFILLER_19_254 VGND VGND VPWR VPWR sky130_fd_sc_hd__fill_1
XFILLER_62_511 VGND VGND VPWR VPWR sky130_fd_sc_hd__decap_3
XFILLER_47_585 VGND VGND VPWR VPWR sky130_fd_sc_hd__decap_3
XFILLER_74_371 VGND VGND VPWR VPWR sky130_fd_sc_hd__decap_3
XFILLER_19_287 VGND VGND VPWR VPWR sky130_fd_sc_hd__decap_3
XFILLER_34_213 VGND VGND VPWR VPWR sky130_fd_sc_hd__decap_3
XFILLER_62_533 VGND VGND VPWR VPWR sky130_fd_sc_hd__decap_3
XFILLER_62_566 VGND VGND VPWR VPWR sky130_fd_sc_hd__decap_3
XFILLER_50_717 VGND VGND VPWR VPWR sky130_fd_sc_hd__decap_3
XFILLER_22_408 VGND VGND VPWR VPWR sky130_fd_sc_hd__decap_3
XFILLER_15_482 VGND VGND VPWR VPWR sky130_fd_sc_hd__decap_3
X_4700_ _9098_/Q hold874/X _4714_/S VGND VGND VPWR VPWR _4700_/X sky130_fd_sc_hd__mux2_2
X_5680_ _5544_/A _5544_/B _5679_/X _5934_/A VGND VGND VPWR VPWR _5780_/B sky130_fd_sc_hd__a22o_2
XFILLER_30_452 VGND VGND VPWR VPWR sky130_fd_sc_hd__decap_3
XFILLER_8_41 VGND VGND VPWR VPWR sky130_fd_sc_hd__decap_3
X_4631_ _4631_/A VGND VGND VPWR VPWR _4650_/S sky130_fd_sc_hd__clkbuf_2
XFILLER_30_474 VGND VGND VPWR VPWR sky130_fd_sc_hd__fill_2
XFILLER_8_85 VGND VGND VPWR VPWR sky130_fd_sc_hd__fill_1
X_7350_ _7103_/A _7349_/X _7103_/C VGND VGND VPWR VPWR _7468_/C sky130_fd_sc_hd__o21ai_2
X_4562_ _9033_/Q hold967/X _4566_/S VGND VGND VPWR VPWR _4562_/X sky130_fd_sc_hd__mux2_2
X_6301_ _6298_/X _6300_/X _6301_/S VGND VGND VPWR VPWR _6325_/D sky130_fd_sc_hd__mux2_4
X_7281_ _6778_/B _6778_/C _6778_/A VGND VGND VPWR VPWR _7281_/X sky130_fd_sc_hd__a21o_2
XFILLER_7_692 VGND VGND VPWR VPWR sky130_fd_sc_hd__decap_3
X_9020_ clkload5/A _9020_/D wire372/A VGND VGND VPWR VPWR _9020_/Q sky130_fd_sc_hd__dfrtp_2
XFILLER_104_719 VGND VGND VPWR VPWR sky130_fd_sc_hd__decap_3
X_6232_ _7794_/A _9174_/Q _6232_/C VGND VGND VPWR VPWR _6232_/X sky130_fd_sc_hd__and3b_2
XFILLER_89_419 VGND VGND VPWR VPWR sky130_fd_sc_hd__decap_3
Xclkbuf_leaf_6_clk clkload1/A VGND VGND VPWR VPWR _9236_/CLK sky130_fd_sc_hd__clkbuf_8
X_6163_ _6163_/A _6163_/B _6163_/C VGND VGND VPWR VPWR _6263_/A sky130_fd_sc_hd__nand3_2
XFILLER_112_752 VGND VGND VPWR VPWR sky130_fd_sc_hd__fill_1
XFILLER_97_452 VGND VGND VPWR VPWR sky130_fd_sc_hd__fill_2
X_5114_ _5114_/A VGND VGND VPWR VPWR _5456_/B sky130_fd_sc_hd__buf_4
XFILLER_69_165 VGND VGND VPWR VPWR sky130_fd_sc_hd__decap_3
X_6094_ _6809_/A _6094_/B VGND VGND VPWR VPWR _6095_/B sky130_fd_sc_hd__and2b_2
XFILLER_97_485 VGND VGND VPWR VPWR sky130_fd_sc_hd__decap_3
XFILLER_111_284 VGND VGND VPWR VPWR sky130_fd_sc_hd__decap_3
X_5045_ _5045_/A _5045_/B VGND VGND VPWR VPWR _5081_/A sky130_fd_sc_hd__xor2_2
XFILLER_85_669 VGND VGND VPWR VPWR sky130_fd_sc_hd__decap_3
XFILLER_27_17 VGND VGND VPWR VPWR sky130_fd_sc_hd__decap_3
XFILLER_53_500 VGND VGND VPWR VPWR sky130_fd_sc_hd__decap_3
XFILLER_26_725 VGND VGND VPWR VPWR sky130_fd_sc_hd__fill_2
XFILLER_53_511 VGND VGND VPWR VPWR sky130_fd_sc_hd__decap_3
XFILLER_93_691 VGND VGND VPWR VPWR sky130_fd_sc_hd__decap_3
XFILLER_65_393 VGND VGND VPWR VPWR sky130_fd_sc_hd__decap_3
XFILLER_26_747 VGND VGND VPWR VPWR sky130_fd_sc_hd__decap_3
X_8804_ _9247_/Q hold780/X _8820_/S VGND VGND VPWR VPWR _8804_/X sky130_fd_sc_hd__mux2_2
XFILLER_53_544 VGND VGND VPWR VPWR sky130_fd_sc_hd__decap_3
XFILLER_53_555 VGND VGND VPWR VPWR sky130_fd_sc_hd__decap_3
XFILLER_26_769 VGND VGND VPWR VPWR sky130_fd_sc_hd__decap_3
X_6996_ _5975_/A _6996_/A2 _5353_/X VGND VGND VPWR VPWR _6997_/B sky130_fd_sc_hd__a21o_2
XFILLER_41_706 VGND VGND VPWR VPWR sky130_fd_sc_hd__decap_3
XTAP_TAPCELL_ROW_36_764 VGND VPWR sky130_fd_sc_hd__tapvpwrvgnd_1
X_8735_ _8695_/X _8732_/B _8753_/B _8755_/B _8734_/X VGND VGND VPWR VPWR _8735_/X
+ sky130_fd_sc_hd__a221o_2
XFILLER_25_279 VGND VGND VPWR VPWR sky130_fd_sc_hd__fill_1
X_5947_ _6098_/A _6821_/S _6416_/A VGND VGND VPWR VPWR _5948_/B sky130_fd_sc_hd__mux2_4
XFILLER_53_599 VGND VGND VPWR VPWR sky130_fd_sc_hd__decap_3
XFILLER_40_216 VGND VGND VPWR VPWR sky130_fd_sc_hd__decap_3
X_8666_ _8666_/A _8666_/B VGND VGND VPWR VPWR _8667_/B sky130_fd_sc_hd__nand2_2
X_5878_ _9296_/Q _5878_/B _5878_/C VGND VGND VPWR VPWR _5878_/X sky130_fd_sc_hd__and3_2
X_7617_ _7763_/B _7617_/B _7617_/C VGND VGND VPWR VPWR _7617_/X sky130_fd_sc_hd__or3_2
X_4829_ _4829_/A VGND VGND VPWR VPWR _9159_/D sky130_fd_sc_hd__buf_1
XFILLER_21_474 VGND VGND VPWR VPWR sky130_fd_sc_hd__decap_3
X_8597_ _8597_/A VGND VGND VPWR VPWR _8654_/S sky130_fd_sc_hd__inv_2
XFILLER_119_340 VGND VGND VPWR VPWR sky130_fd_sc_hd__decap_3
X_7548_ _7548_/A _7548_/B VGND VGND VPWR VPWR _7549_/B sky130_fd_sc_hd__xnor2_2
XFILLER_119_351 VGND VGND VPWR VPWR sky130_fd_sc_hd__decap_3
XFILLER_119_362 VGND VGND VPWR VPWR sky130_fd_sc_hd__decap_3
XFILLER_4_106 VGND VGND VPWR VPWR sky130_fd_sc_hd__decap_3
XFILLER_111_6 VGND VGND VPWR VPWR sky130_fd_sc_hd__decap_3
X_7479_ _9213_/Q _5633_/A _9214_/Q VGND VGND VPWR VPWR _7479_/Y sky130_fd_sc_hd__o21ai_2
XFILLER_107_579 VGND VGND VPWR VPWR sky130_fd_sc_hd__decap_3
X_9218_ _9219_/CLK _9218_/D fanout413/X VGND VGND VPWR VPWR _9218_/Q sky130_fd_sc_hd__dfrtp_2
XTAP_TAPCELL_ROW_112_1800 VGND VPWR sky130_fd_sc_hd__tapvpwrvgnd_1
XFILLER_122_516 VGND VGND VPWR VPWR sky130_fd_sc_hd__fill_2
XFILLER_68_35 VGND VGND VPWR VPWR sky130_fd_sc_hd__fill_1
X_9149_ clkload5/A _9149_/D wire372/A VGND VGND VPWR VPWR _9149_/Q sky130_fd_sc_hd__dfrtp_2
XFILLER_0_334 VGND VGND VPWR VPWR sky130_fd_sc_hd__fill_2
XTAP_TAPCELL_ROW_128_2007 VGND VPWR sky130_fd_sc_hd__tapvpwrvgnd_1
XFILLER_0_356 VGND VGND VPWR VPWR sky130_fd_sc_hd__decap_3
XFILLER_68_79 VGND VGND VPWR VPWR sky130_fd_sc_hd__decap_3
XFILLER_88_474 VGND VGND VPWR VPWR sky130_fd_sc_hd__fill_2
XFILLER_88_485 VGND VGND VPWR VPWR sky130_fd_sc_hd__decap_3
XFILLER_75_102 VGND VGND VPWR VPWR sky130_fd_sc_hd__fill_2
XFILLER_76_636 VGND VGND VPWR VPWR sky130_fd_sc_hd__decap_3
XFILLER_75_113 VGND VGND VPWR VPWR sky130_fd_sc_hd__fill_1
XFILLER_130_582 VGND VGND VPWR VPWR sky130_fd_sc_hd__decap_3
XFILLER_124_41 VGND VGND VPWR VPWR sky130_fd_sc_hd__decap_3
XFILLER_102_295 VGND VGND VPWR VPWR sky130_fd_sc_hd__decap_3
XFILLER_124_74 VGND VGND VPWR VPWR sky130_fd_sc_hd__decap_3
XFILLER_75_146 VGND VGND VPWR VPWR sky130_fd_sc_hd__decap_3
XFILLER_91_606 VGND VGND VPWR VPWR sky130_fd_sc_hd__decap_3
XFILLER_124_85 VGND VGND VPWR VPWR sky130_fd_sc_hd__decap_3
XFILLER_91_617 VGND VGND VPWR VPWR sky130_fd_sc_hd__decap_3
XFILLER_91_639 VGND VGND VPWR VPWR sky130_fd_sc_hd__decap_3
XFILLER_56_371 VGND VGND VPWR VPWR sky130_fd_sc_hd__decap_3
XFILLER_17_725 VGND VGND VPWR VPWR sky130_fd_sc_hd__decap_3
XFILLER_44_533 VGND VGND VPWR VPWR sky130_fd_sc_hd__decap_3
XFILLER_17_747 VGND VGND VPWR VPWR sky130_fd_sc_hd__decap_3
XFILLER_83_190 VGND VGND VPWR VPWR sky130_fd_sc_hd__decap_3
XFILLER_16_235 VGND VGND VPWR VPWR sky130_fd_sc_hd__decap_3
XTAP_TAPCELL_ROW_123_1940 VGND VPWR sky130_fd_sc_hd__tapvpwrvgnd_1
XFILLER_16_268 VGND VGND VPWR VPWR sky130_fd_sc_hd__decap_3
XFILLER_71_374 VGND VGND VPWR VPWR sky130_fd_sc_hd__decap_3
XFILLER_31_216 VGND VGND VPWR VPWR sky130_fd_sc_hd__decap_3
XTAP_TAPCELL_ROW_14_469 VGND VPWR sky130_fd_sc_hd__tapvpwrvgnd_1
XFILLER_8_401 VGND VGND VPWR VPWR sky130_fd_sc_hd__decap_3
XFILLER_33_60 VGND VGND VPWR VPWR sky130_fd_sc_hd__decap_3
XFILLER_40_772 VGND VGND VPWR VPWR sky130_fd_sc_hd__decap_3
XFILLER_129_137 VGND VGND VPWR VPWR sky130_fd_sc_hd__decap_3
XFILLER_33_93 VGND VGND VPWR VPWR sky130_fd_sc_hd__fill_2
XFILLER_125_343 VGND VGND VPWR VPWR sky130_fd_sc_hd__decap_3
XFILLER_125_365 VGND VGND VPWR VPWR sky130_fd_sc_hd__decap_3
XFILLER_113_505 VGND VGND VPWR VPWR sky130_fd_sc_hd__decap_3
XFILLER_4_673 VGND VGND VPWR VPWR sky130_fd_sc_hd__decap_3
XFILLER_98_227 VGND VGND VPWR VPWR sky130_fd_sc_hd__decap_3
XFILLER_113_538 VGND VGND VPWR VPWR sky130_fd_sc_hd__decap_3
XFILLER_67_636 VGND VGND VPWR VPWR sky130_fd_sc_hd__decap_3
XFILLER_94_433 VGND VGND VPWR VPWR sky130_fd_sc_hd__decap_3
XFILLER_94_455 VGND VGND VPWR VPWR sky130_fd_sc_hd__decap_3
XFILLER_94_477 VGND VGND VPWR VPWR sky130_fd_sc_hd__decap_3
XFILLER_82_617 VGND VGND VPWR VPWR sky130_fd_sc_hd__fill_2
XFILLER_47_360 VGND VGND VPWR VPWR sky130_fd_sc_hd__decap_3
XFILLER_81_116 VGND VGND VPWR VPWR sky130_fd_sc_hd__fill_1
XTAP_TAPCELL_ROW_85_1423 VGND VPWR sky130_fd_sc_hd__tapvpwrvgnd_1
XTAP_TAPCELL_ROW_85_1434 VGND VPWR sky130_fd_sc_hd__tapvpwrvgnd_1
XFILLER_47_393 VGND VGND VPWR VPWR sky130_fd_sc_hd__decap_3
X_6850_ _6850_/A _6850_/B VGND VGND VPWR VPWR _6850_/Y sky130_fd_sc_hd__xnor2_2
XFILLER_62_330 VGND VGND VPWR VPWR sky130_fd_sc_hd__decap_3
XFILLER_62_352 VGND VGND VPWR VPWR sky130_fd_sc_hd__decap_3
X_5801_ _6414_/A _5801_/B VGND VGND VPWR VPWR _5801_/Y sky130_fd_sc_hd__nor2_2
XFILLER_62_374 VGND VGND VPWR VPWR sky130_fd_sc_hd__decap_3
XFILLER_35_588 VGND VGND VPWR VPWR sky130_fd_sc_hd__decap_3
XFILLER_22_205 VGND VGND VPWR VPWR sky130_fd_sc_hd__decap_3
X_6781_ _6781_/A _6781_/B VGND VGND VPWR VPWR _6781_/X sky130_fd_sc_hd__xor2_2
XPHY_EDGE_ROW_8_Right_8 VGND VGND VPWR VPWR sky130_fd_sc_hd__decap_3
XTAP_TAPCELL_ROW_33_723 VGND VPWR sky130_fd_sc_hd__tapvpwrvgnd_1
XFILLER_22_227 VGND VGND VPWR VPWR sky130_fd_sc_hd__decap_3
X_8520_ _8697_/C _8493_/A _8562_/A VGND VGND VPWR VPWR _8520_/X sky130_fd_sc_hd__mux2_2
X_5732_ _9075_/Q _5456_/B _5115_/X _9091_/Q VGND VGND VPWR VPWR _5735_/B sky130_fd_sc_hd__a22o_2
XFILLER_50_558 VGND VGND VPWR VPWR sky130_fd_sc_hd__decap_3
XFILLER_22_249 VGND VGND VPWR VPWR sky130_fd_sc_hd__decap_3
XFILLER_50_569 VGND VGND VPWR VPWR sky130_fd_sc_hd__decap_3
XFILLER_31_772 VGND VGND VPWR VPWR sky130_fd_sc_hd__decap_3
X_8451_ _8504_/A _8504_/B VGND VGND VPWR VPWR _8453_/A sky130_fd_sc_hd__nand2_2
X_5663_ _6416_/B _5664_/B VGND VGND VPWR VPWR _5663_/Y sky130_fd_sc_hd__xnor2_2
XFILLER_30_271 VGND VGND VPWR VPWR sky130_fd_sc_hd__decap_3
X_7402_ _7408_/A _7590_/A VGND VGND VPWR VPWR _7402_/Y sky130_fd_sc_hd__nand2_2
X_4614_ _4614_/A VGND VGND VPWR VPWR _9057_/D sky130_fd_sc_hd__buf_1
X_8382_ _8379_/B _8372_/X _8374_/Y _8381_/X VGND VGND VPWR VPWR _8383_/B sky130_fd_sc_hd__o211ai_2
X_5594_ _7050_/A _5897_/D VGND VGND VPWR VPWR _5595_/B sky130_fd_sc_hd__nand2_2
XFILLER_129_671 VGND VGND VPWR VPWR sky130_fd_sc_hd__fill_1
XFILLER_129_682 VGND VGND VPWR VPWR sky130_fd_sc_hd__decap_3
X_7333_ _7443_/A _7333_/B _7333_/C VGND VGND VPWR VPWR _7346_/A sky130_fd_sc_hd__nand3_2
X_4545_ _4545_/A VGND VGND VPWR VPWR _9025_/D sky130_fd_sc_hd__buf_1
XFILLER_128_192 VGND VGND VPWR VPWR sky130_fd_sc_hd__decap_3
XTAP_TAPCELL_ROW_96_1574 VGND VPWR sky130_fd_sc_hd__tapvpwrvgnd_1
Xmax_cap153 _6963_/B VGND VGND VPWR VPWR _7065_/A sky130_fd_sc_hd__buf_4
XFILLER_116_365 VGND VGND VPWR VPWR sky130_fd_sc_hd__decap_3
X_7264_ _7259_/A _7264_/B VGND VGND VPWR VPWR _7264_/X sky130_fd_sc_hd__and2b_2
XFILLER_1_109 VGND VGND VPWR VPWR sky130_fd_sc_hd__decap_3
Xmax_cap175 _7416_/B VGND VGND VPWR VPWR _8312_/A sky130_fd_sc_hd__buf_2
X_9003_ _9003_/A0 _9003_/A1 _9009_/S VGND VGND VPWR VPWR _9004_/A sky130_fd_sc_hd__mux2_2
Xmax_cap186 _8780_/B VGND VGND VPWR VPWR _5348_/S sky130_fd_sc_hd__buf_2
X_6215_ _6368_/A _6215_/B _6215_/C VGND VGND VPWR VPWR _6216_/C sky130_fd_sc_hd__nand3_2
Xmax_cap197 _7681_/A VGND VGND VPWR VPWR _8011_/B sky130_fd_sc_hd__buf_2
X_7195_ _7195_/A _8013_/A VGND VGND VPWR VPWR _8031_/A sky130_fd_sc_hd__xnor2_2
XPHY_EDGE_ROW_39_Right_39 VGND VGND VPWR VPWR sky130_fd_sc_hd__decap_3
X_6146_ _6143_/A _6143_/B _6145_/X _6061_/C _6065_/A VGND VGND VPWR VPWR _6146_/X
+ sky130_fd_sc_hd__a221o_2
XFILLER_112_560 VGND VGND VPWR VPWR sky130_fd_sc_hd__fill_1
XFILLER_112_571 VGND VGND VPWR VPWR sky130_fd_sc_hd__decap_3
Xhold1101 _9130_/Q VGND VGND VPWR VPWR _4801_/A1 sky130_fd_sc_hd__dlygate4sd3_1
XFILLER_58_636 VGND VGND VPWR VPWR sky130_fd_sc_hd__decap_3
Xload_slew370 fanout369/X VGND VGND VPWR VPWR load_slew370/X sky130_fd_sc_hd__clkbuf_4
Xhold1112 _9292_/Q VGND VGND VPWR VPWR _8932_/A1 sky130_fd_sc_hd__dlygate4sd3_1
XFILLER_85_422 VGND VGND VPWR VPWR sky130_fd_sc_hd__decap_3
XFILLER_38_49 VGND VGND VPWR VPWR sky130_fd_sc_hd__fill_1
Xhold1123 _9067_/Q VGND VGND VPWR VPWR _4668_/A1 sky130_fd_sc_hd__dlygate4sd3_1
XFILLER_57_124 VGND VGND VPWR VPWR sky130_fd_sc_hd__fill_2
XFILLER_85_444 VGND VGND VPWR VPWR sky130_fd_sc_hd__decap_3
X_6077_ _6077_/A _6416_/A _6091_/A VGND VGND VPWR VPWR _6077_/X sky130_fd_sc_hd__and3_2
Xhold1134 _9085_/Q VGND VGND VPWR VPWR _4706_/A1 sky130_fd_sc_hd__dlygate4sd3_1
XFILLER_57_146 VGND VGND VPWR VPWR sky130_fd_sc_hd__fill_1
Xhold1145 _9297_/Q VGND VGND VPWR VPWR _8942_/A1 sky130_fd_sc_hd__dlygate4sd3_1
Xhold1156 _9247_/Q VGND VGND VPWR VPWR _8837_/A1 sky130_fd_sc_hd__dlygate4sd3_1
XFILLER_85_466 VGND VGND VPWR VPWR sky130_fd_sc_hd__decap_3
Xhold1167 _8875_/X VGND VGND VPWR VPWR _8876_/A sky130_fd_sc_hd__dlygate4sd3_1
XFILLER_85_477 VGND VGND VPWR VPWR sky130_fd_sc_hd__decap_3
XFILLER_73_617 VGND VGND VPWR VPWR sky130_fd_sc_hd__fill_1
XFILLER_45_308 VGND VGND VPWR VPWR sky130_fd_sc_hd__fill_1
X_5028_ _5016_/A _7114_/B _5012_/X _5024_/Y _8271_/B VGND VGND VPWR VPWR _5028_/X
+ sky130_fd_sc_hd__a32o_2
Xhold1178 _9344_/Q VGND VGND VPWR VPWR _9007_/A0 sky130_fd_sc_hd__dlygate4sd3_1
XFILLER_85_499 VGND VGND VPWR VPWR sky130_fd_sc_hd__decap_3
XFILLER_73_639 VGND VGND VPWR VPWR sky130_fd_sc_hd__decap_3
Xhold1189 _9255_/Q VGND VGND VPWR VPWR _8854_/A1 sky130_fd_sc_hd__dlygate4sd3_1
XFILLER_38_371 VGND VGND VPWR VPWR sky130_fd_sc_hd__decap_3
XFILLER_66_691 VGND VGND VPWR VPWR sky130_fd_sc_hd__decap_3
XFILLER_72_138 VGND VGND VPWR VPWR sky130_fd_sc_hd__fill_2
XFILLER_38_393 VGND VGND VPWR VPWR sky130_fd_sc_hd__decap_3
XFILLER_26_533 VGND VGND VPWR VPWR sky130_fd_sc_hd__decap_3
XFILLER_53_352 VGND VGND VPWR VPWR sky130_fd_sc_hd__fill_1
XFILLER_53_363 VGND VGND VPWR VPWR sky130_fd_sc_hd__decap_3
XFILLER_41_514 VGND VGND VPWR VPWR sky130_fd_sc_hd__decap_3
XFILLER_14_728 VGND VGND VPWR VPWR sky130_fd_sc_hd__decap_3
XFILLER_13_216 VGND VGND VPWR VPWR sky130_fd_sc_hd__decap_3
X_6979_ _7117_/A _7034_/A _6978_/X VGND VGND VPWR VPWR _6980_/B sky130_fd_sc_hd__or3b_4
XPHY_EDGE_ROW_48_Right_48 VGND VGND VPWR VPWR sky130_fd_sc_hd__decap_3
XFILLER_110_21 VGND VGND VPWR VPWR sky130_fd_sc_hd__decap_3
XFILLER_41_547 VGND VGND VPWR VPWR sky130_fd_sc_hd__decap_3
XFILLER_110_32 VGND VGND VPWR VPWR sky130_fd_sc_hd__decap_3
X_8718_ _8718_/A _8721_/B _8672_/B VGND VGND VPWR VPWR _8718_/X sky130_fd_sc_hd__or3b_2
XFILLER_22_772 VGND VGND VPWR VPWR sky130_fd_sc_hd__decap_3
X_8649_ _8678_/A _8649_/B _8649_/C VGND VGND VPWR VPWR _8649_/X sky130_fd_sc_hd__and3_2
XFILLER_21_260 VGND VGND VPWR VPWR sky130_fd_sc_hd__decap_3
XTAP_TAPCELL_ROW_11_428 VGND VPWR sky130_fd_sc_hd__tapvpwrvgnd_1
XFILLER_21_271 VGND VGND VPWR VPWR sky130_fd_sc_hd__decap_3
Xrebuffer520 _6288_/Y VGND VGND VPWR VPWR _6301_/S sky130_fd_sc_hd__buf_6
Xrebuffer531 _7439_/X VGND VGND VPWR VPWR _7461_/C1 sky130_fd_sc_hd__buf_2
Xrebuffer542 _6294_/X VGND VGND VPWR VPWR _6298_/B2 sky130_fd_sc_hd__buf_2
XFILLER_126_118 VGND VGND VPWR VPWR sky130_fd_sc_hd__decap_3
XFILLER_119_30 VGND VGND VPWR VPWR sky130_fd_sc_hd__decap_3
Xrebuffer553 _6218_/A VGND VGND VPWR VPWR _6370_/B sky130_fd_sc_hd__buf_4
XFILLER_5_426 VGND VGND VPWR VPWR sky130_fd_sc_hd__fill_1
Xrebuffer564 _5681_/A VGND VGND VPWR VPWR _5780_/A sky130_fd_sc_hd__buf_2
Xrebuffer575 _5816_/X VGND VGND VPWR VPWR _5914_/A sky130_fd_sc_hd__buf_2
XFILLER_119_63 VGND VGND VPWR VPWR sky130_fd_sc_hd__decap_3
XFILLER_119_181 VGND VGND VPWR VPWR sky130_fd_sc_hd__decap_3
Xrebuffer586 wire142/X VGND VGND VPWR VPWR _6741_/A sky130_fd_sc_hd__buf_2
Xrebuffer597 _6220_/X VGND VGND VPWR VPWR _6262_/A sky130_fd_sc_hd__buf_2
XFILLER_119_96 VGND VGND VPWR VPWR sky130_fd_sc_hd__decap_3
XFILLER_107_376 VGND VGND VPWR VPWR sky130_fd_sc_hd__decap_3
XTAP_TAPCELL_ROW_56_1035 VGND VPWR sky130_fd_sc_hd__tapvpwrvgnd_1
XPHY_EDGE_ROW_57_Right_57 VGND VGND VPWR VPWR sky130_fd_sc_hd__decap_3
XFILLER_1_632 VGND VGND VPWR VPWR sky130_fd_sc_hd__decap_3
Xhold990 _4590_/X VGND VGND VPWR VPWR _4591_/A sky130_fd_sc_hd__dlygate4sd3_1
XFILLER_122_368 VGND VGND VPWR VPWR sky130_fd_sc_hd__decap_3
XFILLER_1_665 VGND VGND VPWR VPWR sky130_fd_sc_hd__decap_3
XFILLER_0_153 VGND VGND VPWR VPWR sky130_fd_sc_hd__decap_3
XFILLER_1_676 VGND VGND VPWR VPWR sky130_fd_sc_hd__decap_3
XFILLER_103_582 VGND VGND VPWR VPWR sky130_fd_sc_hd__fill_1
XFILLER_0_197 VGND VGND VPWR VPWR sky130_fd_sc_hd__decap_3
XFILLER_49_669 VGND VGND VPWR VPWR sky130_fd_sc_hd__decap_3
XFILLER_76_466 VGND VGND VPWR VPWR sky130_fd_sc_hd__decap_3
XFILLER_76_477 VGND VGND VPWR VPWR sky130_fd_sc_hd__decap_3
XFILLER_76_499 VGND VGND VPWR VPWR sky130_fd_sc_hd__fill_2
XFILLER_28_71 VGND VGND VPWR VPWR sky130_fd_sc_hd__decap_3
XFILLER_63_116 VGND VGND VPWR VPWR sky130_fd_sc_hd__fill_2
XFILLER_29_371 VGND VGND VPWR VPWR sky130_fd_sc_hd__decap_3
XFILLER_17_511 VGND VGND VPWR VPWR sky130_fd_sc_hd__decap_3
XTAP_TAPCELL_ROW_19_539 VGND VPWR sky130_fd_sc_hd__tapvpwrvgnd_1
XFILLER_91_458 VGND VGND VPWR VPWR sky130_fd_sc_hd__decap_3
XPHY_EDGE_ROW_66_Right_66 VGND VGND VPWR VPWR sky130_fd_sc_hd__decap_3
XFILLER_72_661 VGND VGND VPWR VPWR sky130_fd_sc_hd__decap_3
XTAP_TAPCELL_ROW_67_1186 VGND VPWR sky130_fd_sc_hd__tapvpwrvgnd_1
XFILLER_32_525 VGND VGND VPWR VPWR sky130_fd_sc_hd__fill_1
XFILLER_44_396 VGND VGND VPWR VPWR sky130_fd_sc_hd__fill_2
XFILLER_71_182 VGND VGND VPWR VPWR sky130_fd_sc_hd__decap_3
XFILLER_13_750 VGND VGND VPWR VPWR sky130_fd_sc_hd__decap_3
XPHY_EDGE_ROW_4_Left_135 VGND VGND VPWR VPWR sky130_fd_sc_hd__decap_3
XTAP_TAPCELL_ROW_80_1364 VGND VPWR sky130_fd_sc_hd__tapvpwrvgnd_1
XFILLER_9_721 VGND VGND VPWR VPWR sky130_fd_sc_hd__decap_3
XFILLER_9_732 VGND VGND VPWR VPWR sky130_fd_sc_hd__decap_3
XFILLER_12_271 VGND VGND VPWR VPWR sky130_fd_sc_hd__decap_3
XFILLER_9_765 VGND VGND VPWR VPWR sky130_fd_sc_hd__decap_3
XFILLER_74_6 VGND VGND VPWR VPWR sky130_fd_sc_hd__decap_3
XFILLER_8_253 VGND VGND VPWR VPWR sky130_fd_sc_hd__decap_3
XFILLER_8_286 VGND VGND VPWR VPWR sky130_fd_sc_hd__decap_3
XFILLER_60_91 VGND VGND VPWR VPWR sky130_fd_sc_hd__decap_3
XFILLER_126_630 VGND VGND VPWR VPWR sky130_fd_sc_hd__decap_3
XPHY_EDGE_ROW_75_Right_75 VGND VGND VPWR VPWR sky130_fd_sc_hd__decap_3
XFILLER_99_503 VGND VGND VPWR VPWR sky130_fd_sc_hd__fill_1
XFILLER_126_663 VGND VGND VPWR VPWR sky130_fd_sc_hd__decap_3
XFILLER_125_140 VGND VGND VPWR VPWR sky130_fd_sc_hd__decap_3
XFILLER_5_42 VGND VGND VPWR VPWR sky130_fd_sc_hd__decap_3
XFILLER_126_696 VGND VGND VPWR VPWR sky130_fd_sc_hd__decap_3
XFILLER_99_536 VGND VGND VPWR VPWR sky130_fd_sc_hd__decap_3
XFILLER_125_184 VGND VGND VPWR VPWR sky130_fd_sc_hd__decap_3
XFILLER_5_86 VGND VGND VPWR VPWR sky130_fd_sc_hd__decap_3
XFILLER_113_335 VGND VGND VPWR VPWR sky130_fd_sc_hd__fill_1
XFILLER_101_508 VGND VGND VPWR VPWR sky130_fd_sc_hd__fill_1
X_6000_ _9206_/Q _6177_/B _6680_/B VGND VGND VPWR VPWR _6003_/B sky130_fd_sc_hd__and3_2
XFILLER_39_113 VGND VGND VPWR VPWR sky130_fd_sc_hd__fill_1
XFILLER_94_230 VGND VGND VPWR VPWR sky130_fd_sc_hd__fill_2
XFILLER_121_390 VGND VGND VPWR VPWR sky130_fd_sc_hd__fill_2
XFILLER_67_455 VGND VGND VPWR VPWR sky130_fd_sc_hd__decap_3
XFILLER_55_617 VGND VGND VPWR VPWR sky130_fd_sc_hd__decap_3
XFILLER_27_319 VGND VGND VPWR VPWR sky130_fd_sc_hd__decap_3
X_7951_ _7951_/A _7951_/B VGND VGND VPWR VPWR _7953_/A sky130_fd_sc_hd__nor2_2
XFILLER_55_639 VGND VGND VPWR VPWR sky130_fd_sc_hd__decap_3
XPHY_EDGE_ROW_84_Right_84 VGND VGND VPWR VPWR sky130_fd_sc_hd__decap_3
X_6902_ _6896_/Y _6897_/X _6901_/X VGND VGND VPWR VPWR _6903_/B sky130_fd_sc_hd__o21ai_2
XFILLER_82_458 VGND VGND VPWR VPWR sky130_fd_sc_hd__decap_3
X_7882_ _7229_/A _7880_/Y _7881_/X _8011_/A VGND VGND VPWR VPWR _7882_/X sky130_fd_sc_hd__o211a_2
XFILLER_35_352 VGND VGND VPWR VPWR sky130_fd_sc_hd__decap_3
XFILLER_23_503 VGND VGND VPWR VPWR sky130_fd_sc_hd__fill_1
X_6833_ _6833_/A _6833_/B VGND VGND VPWR VPWR _6834_/B sky130_fd_sc_hd__xnor2_2
XFILLER_35_396 VGND VGND VPWR VPWR sky130_fd_sc_hd__fill_1
XFILLER_24_18 VGND VGND VPWR VPWR sky130_fd_sc_hd__decap_3
XFILLER_24_29 VGND VGND VPWR VPWR sky130_fd_sc_hd__fill_2
X_6764_ _6764_/A _8406_/A VGND VGND VPWR VPWR _6765_/B sky130_fd_sc_hd__xnor2_2
X_8503_ _8503_/A _8503_/B VGND VGND VPWR VPWR _8511_/A sky130_fd_sc_hd__xnor2_2
XFILLER_50_377 VGND VGND VPWR VPWR sky130_fd_sc_hd__decap_3
X_5715_ _5713_/Y _5711_/Y _5714_/Y _7098_/A VGND VGND VPWR VPWR _5715_/X sky130_fd_sc_hd__a211o_4
XTAP_TAPCELL_ROW_98_1603 VGND VPWR sky130_fd_sc_hd__tapvpwrvgnd_1
X_6695_ _6695_/A _6695_/B _6695_/C _6695_/D VGND VGND VPWR VPWR _6695_/X sky130_fd_sc_hd__and4_2
XFILLER_31_580 VGND VGND VPWR VPWR sky130_fd_sc_hd__decap_3
X_8434_ _8469_/A _8434_/B VGND VGND VPWR VPWR _8435_/B sky130_fd_sc_hd__xnor2_2
X_5646_ _5495_/A _5497_/A _5495_/C _5495_/B VGND VGND VPWR VPWR _5646_/X sky130_fd_sc_hd__o211a_4
XPHY_EDGE_ROW_93_Right_93 VGND VGND VPWR VPWR sky130_fd_sc_hd__decap_3
XFILLER_108_129 VGND VGND VPWR VPWR sky130_fd_sc_hd__fill_2
X_8365_ _8445_/A _8362_/X _8363_/Y _8566_/A _8364_/X VGND VGND VPWR VPWR _8365_/X
+ sky130_fd_sc_hd__o221a_2
X_5577_ _5576_/A _5576_/B _5435_/B VGND VGND VPWR VPWR _5760_/B sky130_fd_sc_hd__o21bai_2
X_7316_ _7313_/A _7313_/B _5193_/B VGND VGND VPWR VPWR _7317_/B sky130_fd_sc_hd__a21o_2
X_4528_ hold967/X _4528_/A1 _4544_/S VGND VGND VPWR VPWR _4529_/A sky130_fd_sc_hd__mux2_2
XFILLER_2_418 VGND VGND VPWR VPWR sky130_fd_sc_hd__fill_2
X_8296_ _8204_/A _8294_/X _8295_/X _8204_/B VGND VGND VPWR VPWR _8296_/X sky130_fd_sc_hd__a22o_2
XFILLER_2_429 VGND VGND VPWR VPWR sky130_fd_sc_hd__decap_3
XFILLER_117_696 VGND VGND VPWR VPWR sky130_fd_sc_hd__decap_3
XFILLER_6_9 VGND VGND VPWR VPWR sky130_fd_sc_hd__decap_3
X_7247_ _6797_/B _7244_/Y _7246_/X VGND VGND VPWR VPWR _7247_/X sky130_fd_sc_hd__o21a_2
XPHY_EDGE_ROW_68_Left_199 VGND VGND VPWR VPWR sky130_fd_sc_hd__decap_3
XFILLER_78_709 VGND VGND VPWR VPWR sky130_fd_sc_hd__decap_3
X_7178_ _7676_/C _7178_/B VGND VGND VPWR VPWR _7179_/B sky130_fd_sc_hd__xnor2_2
XFILLER_86_720 VGND VGND VPWR VPWR sky130_fd_sc_hd__decap_3
XFILLER_98_580 VGND VGND VPWR VPWR sky130_fd_sc_hd__decap_3
XFILLER_58_433 VGND VGND VPWR VPWR sky130_fd_sc_hd__decap_3
X_6129_ _6790_/A VGND VGND VPWR VPWR _6798_/S sky130_fd_sc_hd__inv_2
XFILLER_85_230 VGND VGND VPWR VPWR sky130_fd_sc_hd__fill_1
XFILLER_58_455 VGND VGND VPWR VPWR sky130_fd_sc_hd__fill_2
XFILLER_46_617 VGND VGND VPWR VPWR sky130_fd_sc_hd__decap_3
XFILLER_100_585 VGND VGND VPWR VPWR sky130_fd_sc_hd__decap_3
XFILLER_73_425 VGND VGND VPWR VPWR sky130_fd_sc_hd__decap_3
XFILLER_45_116 VGND VGND VPWR VPWR sky130_fd_sc_hd__decap_3
XTAP_TAPCELL_ROW_107_1721 VGND VPWR sky130_fd_sc_hd__tapvpwrvgnd_1
XTAP_TAPCELL_ROW_107_1732 VGND VPWR sky130_fd_sc_hd__tapvpwrvgnd_1
XFILLER_73_458 VGND VGND VPWR VPWR sky130_fd_sc_hd__decap_3
XFILLER_38_190 VGND VGND VPWR VPWR sky130_fd_sc_hd__decap_3
XFILLER_26_341 VGND VGND VPWR VPWR sky130_fd_sc_hd__decap_3
XFILLER_26_363 VGND VGND VPWR VPWR sky130_fd_sc_hd__fill_1
XFILLER_121_42 VGND VGND VPWR VPWR sky130_fd_sc_hd__decap_3
XFILLER_26_374 VGND VGND VPWR VPWR sky130_fd_sc_hd__decap_3
XFILLER_14_525 VGND VGND VPWR VPWR sky130_fd_sc_hd__decap_3
XFILLER_81_480 VGND VGND VPWR VPWR sky130_fd_sc_hd__decap_3
XFILLER_121_75 VGND VGND VPWR VPWR sky130_fd_sc_hd__decap_3
XFILLER_81_57 VGND VGND VPWR VPWR sky130_fd_sc_hd__decap_3
XFILLER_41_355 VGND VGND VPWR VPWR sky130_fd_sc_hd__fill_1
XFILLER_41_388 VGND VGND VPWR VPWR sky130_fd_sc_hd__decap_3
XFILLER_10_731 VGND VGND VPWR VPWR sky130_fd_sc_hd__decap_3
XFILLER_6_713 VGND VGND VPWR VPWR sky130_fd_sc_hd__decap_3
XFILLER_10_775 VGND VGND VPWR VPWR sky130_fd_sc_hd__fill_2
XFILLER_127_438 VGND VGND VPWR VPWR sky130_fd_sc_hd__fill_1
XFILLER_127_449 VGND VGND VPWR VPWR sky130_fd_sc_hd__fill_2
XFILLER_6_746 VGND VGND VPWR VPWR sky130_fd_sc_hd__decap_3
XFILLER_6_757 VGND VGND VPWR VPWR sky130_fd_sc_hd__decap_3
XFILLER_5_234 VGND VGND VPWR VPWR sky130_fd_sc_hd__decap_3
XFILLER_108_663 VGND VGND VPWR VPWR sky130_fd_sc_hd__decap_3
XTAP_TAPCELL_ROW_118_1872 VGND VPWR sky130_fd_sc_hd__tapvpwrvgnd_1
XFILLER_123_600 VGND VGND VPWR VPWR sky130_fd_sc_hd__decap_3
XFILLER_107_184 VGND VGND VPWR VPWR sky130_fd_sc_hd__fill_1
XFILLER_122_121 VGND VGND VPWR VPWR sky130_fd_sc_hd__decap_3
XFILLER_96_506 VGND VGND VPWR VPWR sky130_fd_sc_hd__decap_3
XFILLER_68_208 VGND VGND VPWR VPWR sky130_fd_sc_hd__decap_3
XFILLER_49_400 VGND VGND VPWR VPWR sky130_fd_sc_hd__decap_3
XFILLER_122_165 VGND VGND VPWR VPWR sky130_fd_sc_hd__decap_3
XFILLER_110_327 VGND VGND VPWR VPWR sky130_fd_sc_hd__decap_3
XFILLER_39_81 VGND VGND VPWR VPWR sky130_fd_sc_hd__decap_3
XFILLER_92_701 VGND VGND VPWR VPWR sky130_fd_sc_hd__fill_1
XFILLER_77_775 VGND VGND VPWR VPWR sky130_fd_sc_hd__fill_2
XFILLER_49_466 VGND VGND VPWR VPWR sky130_fd_sc_hd__fill_1
XFILLER_37_606 VGND VGND VPWR VPWR sky130_fd_sc_hd__decap_3
XFILLER_92_712 VGND VGND VPWR VPWR sky130_fd_sc_hd__decap_3
XFILLER_37_617 VGND VGND VPWR VPWR sky130_fd_sc_hd__decap_3
XTAP_TAPCELL_ROW_69_1215 VGND VPWR sky130_fd_sc_hd__tapvpwrvgnd_1
XFILLER_49_499 VGND VGND VPWR VPWR sky130_fd_sc_hd__decap_3
XFILLER_36_127 VGND VGND VPWR VPWR sky130_fd_sc_hd__decap_3
XFILLER_64_458 VGND VGND VPWR VPWR sky130_fd_sc_hd__decap_3
XFILLER_52_609 VGND VGND VPWR VPWR sky130_fd_sc_hd__decap_3
XFILLER_72_480 VGND VGND VPWR VPWR sky130_fd_sc_hd__decap_3
XFILLER_44_171 VGND VGND VPWR VPWR sky130_fd_sc_hd__decap_3
XFILLER_32_344 VGND VGND VPWR VPWR sky130_fd_sc_hd__fill_1
XTAP_TAPCELL_ROW_43_862 VGND VPWR sky130_fd_sc_hd__tapvpwrvgnd_1
XFILLER_20_528 VGND VGND VPWR VPWR sky130_fd_sc_hd__decap_3
XFILLER_9_540 VGND VGND VPWR VPWR sky130_fd_sc_hd__decap_3
X_5500_ _5957_/A _5507_/A VGND VGND VPWR VPWR _5500_/Y sky130_fd_sc_hd__xnor2_2
X_6480_ _5514_/A _5100_/C _6418_/A _6418_/B _5954_/Y VGND VGND VPWR VPWR _6480_/X
+ sky130_fd_sc_hd__o221a_2
XFILLER_72_3 VGND VGND VPWR VPWR sky130_fd_sc_hd__fill_1
XFILLER_118_416 VGND VGND VPWR VPWR sky130_fd_sc_hd__decap_3
XFILLER_118_427 VGND VGND VPWR VPWR sky130_fd_sc_hd__decap_3
X_5431_ _7114_/B _7413_/A VGND VGND VPWR VPWR _5433_/A sky130_fd_sc_hd__nand2_2
X_8150_ _8058_/Y _8149_/Y _7945_/A VGND VGND VPWR VPWR _8150_/X sky130_fd_sc_hd__o21a_2
XTAP_TAPCELL_ROW_93_1533 VGND VPWR sky130_fd_sc_hd__tapvpwrvgnd_1
X_5362_ _5855_/A _7569_/A _7573_/B VGND VGND VPWR VPWR _5362_/X sky130_fd_sc_hd__or3_2
XFILLER_126_471 VGND VGND VPWR VPWR sky130_fd_sc_hd__decap_3
X_7101_ _7097_/X _7100_/X _7117_/A VGND VGND VPWR VPWR _7103_/A sky130_fd_sc_hd__a21o_4
X_8081_ _8137_/A _8126_/A _8080_/X _8216_/A VGND VGND VPWR VPWR _8090_/A sky130_fd_sc_hd__o211a_2
X_5293_ _5855_/A _7799_/A _8137_/A _7317_/A VGND VGND VPWR VPWR _5298_/A sky130_fd_sc_hd__o211a_2
XFILLER_114_677 VGND VGND VPWR VPWR sky130_fd_sc_hd__decap_3
X_7032_ _7033_/B _7033_/A _7021_/A VGND VGND VPWR VPWR _7032_/X sky130_fd_sc_hd__a21o_2
XFILLER_87_528 VGND VGND VPWR VPWR sky130_fd_sc_hd__decap_3
XFILLER_101_327 VGND VGND VPWR VPWR sky130_fd_sc_hd__decap_3
XFILLER_99_399 VGND VGND VPWR VPWR sky130_fd_sc_hd__decap_3
XFILLER_19_18 VGND VGND VPWR VPWR sky130_fd_sc_hd__decap_3
XFILLER_95_550 VGND VGND VPWR VPWR sky130_fd_sc_hd__decap_3
XFILLER_95_561 VGND VGND VPWR VPWR sky130_fd_sc_hd__fill_2
XFILLER_95_572 VGND VGND VPWR VPWR sky130_fd_sc_hd__decap_3
XFILLER_83_723 VGND VGND VPWR VPWR sky130_fd_sc_hd__decap_3
XFILLER_82_211 VGND VGND VPWR VPWR sky130_fd_sc_hd__decap_3
X_8983_ _8983_/A VGND VGND VPWR VPWR _9332_/D sky130_fd_sc_hd__buf_1
XFILLER_67_296 VGND VGND VPWR VPWR sky130_fd_sc_hd__fill_2
XFILLER_55_436 VGND VGND VPWR VPWR sky130_fd_sc_hd__decap_3
XFILLER_55_458 VGND VGND VPWR VPWR sky130_fd_sc_hd__decap_3
X_7934_ _8155_/A _8050_/B VGND VGND VPWR VPWR _7934_/Y sky130_fd_sc_hd__nand2_2
XFILLER_70_417 VGND VGND VPWR VPWR sky130_fd_sc_hd__decap_3
XFILLER_23_300 VGND VGND VPWR VPWR sky130_fd_sc_hd__decap_3
X_7865_ _7736_/A _7735_/A _7864_/X VGND VGND VPWR VPWR _8006_/B sky130_fd_sc_hd__a21o_2
XFILLER_51_620 VGND VGND VPWR VPWR sky130_fd_sc_hd__decap_3
X_6816_ _5949_/A _6810_/X _6815_/X VGND VGND VPWR VPWR _6833_/A sky130_fd_sc_hd__a21oi_2
X_7796_ _8780_/A _7793_/X _7795_/Y _8248_/B VGND VGND VPWR VPWR _7810_/A sky130_fd_sc_hd__a31o_2
XFILLER_50_141 VGND VGND VPWR VPWR sky130_fd_sc_hd__decap_3
XTAP_TAPCELL_ROW_102_1662 VGND VPWR sky130_fd_sc_hd__tapvpwrvgnd_1
X_6747_ _6747_/A _6747_/B VGND VGND VPWR VPWR _6767_/A sky130_fd_sc_hd__nand2_2
XFILLER_51_49 VGND VGND VPWR VPWR sky130_fd_sc_hd__decap_3
X_6678_ _7445_/A _5892_/A _6547_/A _6547_/B VGND VGND VPWR VPWR _6678_/X sky130_fd_sc_hd__a22o_2
XTAP_TAPCELL_ROW_21_567 VGND VPWR sky130_fd_sc_hd__tapvpwrvgnd_1
XFILLER_109_438 VGND VGND VPWR VPWR sky130_fd_sc_hd__decap_3
XFILLER_109_449 VGND VGND VPWR VPWR sky130_fd_sc_hd__decap_3
X_5629_ _5629_/A VGND VGND VPWR VPWR _7430_/B sky130_fd_sc_hd__buf_6
X_8417_ _8416_/A _8416_/B _8325_/X _8416_/Y VGND VGND VPWR VPWR _8482_/A sky130_fd_sc_hd__o31a_2
XPHY_EDGE_ROW_76_Left_207 VGND VGND VPWR VPWR sky130_fd_sc_hd__decap_3
X_8348_ _8446_/A _8348_/B VGND VGND VPWR VPWR _8349_/B sky130_fd_sc_hd__xnor2_2
XFILLER_3_727 VGND VGND VPWR VPWR sky130_fd_sc_hd__fill_1
XFILLER_117_460 VGND VGND VPWR VPWR sky130_fd_sc_hd__decap_3
XFILLER_3_738 VGND VGND VPWR VPWR sky130_fd_sc_hd__decap_3
XFILLER_105_633 VGND VGND VPWR VPWR sky130_fd_sc_hd__decap_3
XFILLER_117_493 VGND VGND VPWR VPWR sky130_fd_sc_hd__decap_3
XFILLER_4_6 VGND VGND VPWR VPWR sky130_fd_sc_hd__decap_3
X_8279_ _8283_/A _8283_/C VGND VGND VPWR VPWR _8299_/B sky130_fd_sc_hd__or2_2
XFILLER_2_248 VGND VGND VPWR VPWR sky130_fd_sc_hd__decap_3
XFILLER_105_688 VGND VGND VPWR VPWR sky130_fd_sc_hd__decap_3
XFILLER_116_53 VGND VGND VPWR VPWR sky130_fd_sc_hd__decap_3
XFILLER_76_24 VGND VGND VPWR VPWR sky130_fd_sc_hd__decap_3
XFILLER_76_35 VGND VGND VPWR VPWR sky130_fd_sc_hd__decap_3
XFILLER_116_97 VGND VGND VPWR VPWR sky130_fd_sc_hd__decap_3
XFILLER_59_775 VGND VGND VPWR VPWR sky130_fd_sc_hd__fill_2
XFILLER_76_68 VGND VGND VPWR VPWR sky130_fd_sc_hd__decap_3
XFILLER_74_701 VGND VGND VPWR VPWR sky130_fd_sc_hd__decap_3
XFILLER_19_617 VGND VGND VPWR VPWR sky130_fd_sc_hd__decap_3
XFILLER_46_403 VGND VGND VPWR VPWR sky130_fd_sc_hd__decap_3
XFILLER_74_745 VGND VGND VPWR VPWR sky130_fd_sc_hd__decap_3
XPHY_EDGE_ROW_85_Left_216 VGND VGND VPWR VPWR sky130_fd_sc_hd__decap_3
XFILLER_34_609 VGND VGND VPWR VPWR sky130_fd_sc_hd__decap_3
XTAP_TAPCELL_ROW_29_667 VGND VPWR sky130_fd_sc_hd__tapvpwrvgnd_1
XTAP_TAPCELL_ROW_29_678 VGND VPWR sky130_fd_sc_hd__tapvpwrvgnd_1
XFILLER_92_56 VGND VGND VPWR VPWR sky130_fd_sc_hd__fill_2
XFILLER_33_119 VGND VGND VPWR VPWR sky130_fd_sc_hd__decap_3
XTAP_TAPCELL_ROW_1_292 VGND VPWR sky130_fd_sc_hd__tapvpwrvgnd_1
XFILLER_27_694 VGND VGND VPWR VPWR sky130_fd_sc_hd__decap_3
XTAP_TAPCELL_ROW_64_1145 VGND VPWR sky130_fd_sc_hd__tapvpwrvgnd_1
XFILLER_14_344 VGND VGND VPWR VPWR sky130_fd_sc_hd__fill_1
XFILLER_42_686 VGND VGND VPWR VPWR sky130_fd_sc_hd__fill_1
XFILLER_25_94 VGND VGND VPWR VPWR sky130_fd_sc_hd__decap_3
XFILLER_42_697 VGND VGND VPWR VPWR sky130_fd_sc_hd__decap_3
XTAP_TAPCELL_ROW_40_821 VGND VPWR sky130_fd_sc_hd__tapvpwrvgnd_1
XFILLER_128_725 VGND VGND VPWR VPWR sky130_fd_sc_hd__decap_3
XFILLER_127_202 VGND VGND VPWR VPWR sky130_fd_sc_hd__decap_3
XPHY_EDGE_ROW_94_Left_225 VGND VGND VPWR VPWR sky130_fd_sc_hd__decap_3
XFILLER_128_769 VGND VGND VPWR VPWR sky130_fd_sc_hd__decap_3
XFILLER_127_246 VGND VGND VPWR VPWR sky130_fd_sc_hd__fill_1
XFILLER_115_419 VGND VGND VPWR VPWR sky130_fd_sc_hd__fill_1
XFILLER_6_587 VGND VGND VPWR VPWR sky130_fd_sc_hd__fill_1
XFILLER_123_452 VGND VGND VPWR VPWR sky130_fd_sc_hd__decap_3
XFILLER_111_603 VGND VGND VPWR VPWR sky130_fd_sc_hd__decap_3
XTAP_TAPCELL_ROW_75_1296 VGND VPWR sky130_fd_sc_hd__tapvpwrvgnd_1
XFILLER_69_517 VGND VGND VPWR VPWR sky130_fd_sc_hd__decap_3
XFILLER_2_760 VGND VGND VPWR VPWR sky130_fd_sc_hd__decap_3
XFILLER_37_6 VGND VGND VPWR VPWR sky130_fd_sc_hd__fill_1
XFILLER_111_614 VGND VGND VPWR VPWR sky130_fd_sc_hd__fill_2
XFILLER_2_21 VGND VGND VPWR VPWR sky130_fd_sc_hd__decap_3
XFILLER_1_281 VGND VGND VPWR VPWR sky130_fd_sc_hd__fill_2
XFILLER_2_32 VGND VGND VPWR VPWR sky130_fd_sc_hd__decap_3
XFILLER_84_509 VGND VGND VPWR VPWR sky130_fd_sc_hd__decap_3
XFILLER_77_561 VGND VGND VPWR VPWR sky130_fd_sc_hd__decap_3
XFILLER_65_701 VGND VGND VPWR VPWR sky130_fd_sc_hd__decap_3
XFILLER_2_65 VGND VGND VPWR VPWR sky130_fd_sc_hd__decap_3
XFILLER_110_179 VGND VGND VPWR VPWR sky130_fd_sc_hd__decap_3
XFILLER_77_583 VGND VGND VPWR VPWR sky130_fd_sc_hd__decap_3
XFILLER_65_734 VGND VGND VPWR VPWR sky130_fd_sc_hd__decap_3
XTAP_TAPCELL_ROW_48_932 VGND VPWR sky130_fd_sc_hd__tapvpwrvgnd_1
X_5980_ _9206_/Q _7065_/B _5978_/X _5979_/Y _5978_/B VGND VGND VPWR VPWR _5980_/X
+ sky130_fd_sc_hd__o32a_2
XFILLER_80_704 VGND VGND VPWR VPWR sky130_fd_sc_hd__decap_3
XFILLER_92_586 VGND VGND VPWR VPWR sky130_fd_sc_hd__fill_2
X_4931_ _5878_/C VGND VGND VPWR VPWR _6608_/C sky130_fd_sc_hd__clkbuf_1
XFILLER_80_748 VGND VGND VPWR VPWR sky130_fd_sc_hd__decap_3
XFILLER_52_439 VGND VGND VPWR VPWR sky130_fd_sc_hd__decap_3
XFILLER_64_299 VGND VGND VPWR VPWR sky130_fd_sc_hd__decap_3
XFILLER_33_620 VGND VGND VPWR VPWR sky130_fd_sc_hd__fill_1
X_7650_ _7650_/A _7650_/B VGND VGND VPWR VPWR _7899_/A sky130_fd_sc_hd__xor2_2
X_4862_ _4862_/A VGND VGND VPWR VPWR _9175_/D sky130_fd_sc_hd__buf_1
XFILLER_33_664 VGND VGND VPWR VPWR sky130_fd_sc_hd__decap_3
XFILLER_32_141 VGND VGND VPWR VPWR sky130_fd_sc_hd__fill_1
XFILLER_60_461 VGND VGND VPWR VPWR sky130_fd_sc_hd__decap_3
XFILLER_33_686 VGND VGND VPWR VPWR sky130_fd_sc_hd__decap_3
X_6601_ _6301_/S _6296_/C _6600_/X VGND VGND VPWR VPWR _6636_/A sky130_fd_sc_hd__a21oi_2
XFILLER_32_174 VGND VGND VPWR VPWR sky130_fd_sc_hd__fill_1
X_7581_ _7434_/A _7579_/X _7580_/X VGND VGND VPWR VPWR _7816_/B sky130_fd_sc_hd__a21oi_2
XFILLER_20_325 VGND VGND VPWR VPWR sky130_fd_sc_hd__decap_3
X_4793_ _4793_/A VGND VGND VPWR VPWR _9142_/D sky130_fd_sc_hd__buf_1
X_9320_ clkload5/A _9320_/D fanout373/X VGND VGND VPWR VPWR _9320_/Q sky130_fd_sc_hd__dfrtp_2
XFILLER_119_714 VGND VGND VPWR VPWR sky130_fd_sc_hd__decap_3
X_6532_ _6528_/A _6528_/B _6367_/Y VGND VGND VPWR VPWR _6532_/X sky130_fd_sc_hd__a21bo_2
XFILLER_119_747 VGND VGND VPWR VPWR sky130_fd_sc_hd__decap_3
XFILLER_9_381 VGND VGND VPWR VPWR sky130_fd_sc_hd__decap_3
X_9251_ clkload3/A _9251_/D load_slew370/X VGND VGND VPWR VPWR _9251_/Q sky130_fd_sc_hd__dfrtp_2
XFILLER_118_235 VGND VGND VPWR VPWR sky130_fd_sc_hd__fill_2
X_6463_ _7728_/A _7243_/A VGND VGND VPWR VPWR _7533_/A sky130_fd_sc_hd__nand2_2
X_8202_ wire61/A _8194_/X _8197_/X _9217_/Q _8201_/X VGND VGND VPWR VPWR _8283_/C
+ sky130_fd_sc_hd__o221a_2
X_5414_ _5407_/A _5405_/Y _5409_/Y _5413_/X VGND VGND VPWR VPWR _5416_/B sky130_fd_sc_hd__a211o_2
X_9182_ _9219_/CLK _9182_/D fanout413/X VGND VGND VPWR VPWR _9182_/Q sky130_fd_sc_hd__dfrtp_2
X_6394_ _6394_/A VGND VGND VPWR VPWR _6458_/A sky130_fd_sc_hd__inv_2
X_8133_ _8127_/X _8131_/X _8132_/X VGND VGND VPWR VPWR _8283_/B sky130_fd_sc_hd__o21ai_2
XFILLER_114_430 VGND VGND VPWR VPWR sky130_fd_sc_hd__decap_3
X_5345_ _5345_/A _7764_/A VGND VGND VPWR VPWR _5346_/B sky130_fd_sc_hd__nand2_2
XFILLER_99_130 VGND VGND VPWR VPWR sky130_fd_sc_hd__decap_3
XFILLER_0_719 VGND VGND VPWR VPWR sky130_fd_sc_hd__decap_3
XFILLER_87_303 VGND VGND VPWR VPWR sky130_fd_sc_hd__decap_3
X_8064_ _7943_/A _7942_/A _7942_/B VGND VGND VPWR VPWR _8064_/X sky130_fd_sc_hd__a21bo_2
X_5276_ _5276_/A VGND VGND VPWR VPWR _7590_/A sky130_fd_sc_hd__clkbuf_4
X_7015_ _7016_/B _7016_/C _7016_/A VGND VGND VPWR VPWR _7015_/Y sky130_fd_sc_hd__a21oi_2
XFILLER_28_414 VGND VGND VPWR VPWR sky130_fd_sc_hd__fill_1
XFILLER_83_520 VGND VGND VPWR VPWR sky130_fd_sc_hd__fill_1
XFILLER_46_27 VGND VGND VPWR VPWR sky130_fd_sc_hd__fill_1
XFILLER_110_691 VGND VGND VPWR VPWR sky130_fd_sc_hd__decap_3
XFILLER_83_542 VGND VGND VPWR VPWR sky130_fd_sc_hd__decap_3
XFILLER_83_564 VGND VGND VPWR VPWR sky130_fd_sc_hd__decap_3
X_8966_ _8966_/A VGND VGND VPWR VPWR _9324_/D sky130_fd_sc_hd__buf_1
XFILLER_70_203 VGND VGND VPWR VPWR sky130_fd_sc_hd__decap_3
X_7917_ wire61/A _7916_/Y _7915_/Y wire71/A VGND VGND VPWR VPWR _7917_/Y sky130_fd_sc_hd__o211ai_2
XTAP_TAPCELL_ROW_26_626 VGND VPWR sky130_fd_sc_hd__tapvpwrvgnd_1
XFILLER_43_439 VGND VGND VPWR VPWR sky130_fd_sc_hd__decap_3
XFILLER_24_620 VGND VGND VPWR VPWR sky130_fd_sc_hd__decap_3
XTAP_TAPCELL_ROW_26_637 VGND VPWR sky130_fd_sc_hd__tapvpwrvgnd_1
X_8897_ _8897_/A VGND VGND VPWR VPWR _9291_/D sky130_fd_sc_hd__buf_1
XFILLER_102_66 VGND VGND VPWR VPWR sky130_fd_sc_hd__decap_3
X_7848_ _7651_/A _7650_/A _7650_/B VGND VGND VPWR VPWR _7848_/X sky130_fd_sc_hd__a21bo_2
XFILLER_51_461 VGND VGND VPWR VPWR sky130_fd_sc_hd__decap_3
XFILLER_51_483 VGND VGND VPWR VPWR sky130_fd_sc_hd__fill_2
XFILLER_23_174 VGND VGND VPWR VPWR sky130_fd_sc_hd__decap_3
X_7779_ _8070_/A _7960_/C VGND VGND VPWR VPWR _7781_/A sky130_fd_sc_hd__nand2_2
XFILLER_11_358 VGND VGND VPWR VPWR sky130_fd_sc_hd__fill_1
Xwire227 wire227/A VGND VGND VPWR VPWR result_out[1] sky130_fd_sc_hd__buf_4
XFILLER_11_30 VGND VGND VPWR VPWR sky130_fd_sc_hd__decap_3
XFILLER_109_279 VGND VGND VPWR VPWR sky130_fd_sc_hd__fill_1
XTAP_TAPCELL_ROW_115_1831 VGND VPWR sky130_fd_sc_hd__tapvpwrvgnd_1
XFILLER_127_30 VGND VGND VPWR VPWR sky130_fd_sc_hd__decap_3
XFILLER_124_227 VGND VGND VPWR VPWR sky130_fd_sc_hd__fill_2
XFILLER_11_63 VGND VGND VPWR VPWR sky130_fd_sc_hd__decap_3
XFILLER_105_430 VGND VGND VPWR VPWR sky130_fd_sc_hd__decap_3
XFILLER_2_3 VGND VGND VPWR VPWR sky130_fd_sc_hd__decap_3
XFILLER_127_63 VGND VGND VPWR VPWR sky130_fd_sc_hd__decap_3
XFILLER_127_96 VGND VGND VPWR VPWR sky130_fd_sc_hd__decap_3
XFILLER_105_485 VGND VGND VPWR VPWR sky130_fd_sc_hd__decap_3
XFILLER_78_325 VGND VGND VPWR VPWR sky130_fd_sc_hd__decap_3
XFILLER_120_411 VGND VGND VPWR VPWR sky130_fd_sc_hd__fill_2
XFILLER_78_347 VGND VGND VPWR VPWR sky130_fd_sc_hd__fill_2
XFILLER_120_433 VGND VGND VPWR VPWR sky130_fd_sc_hd__decap_3
XFILLER_78_358 VGND VGND VPWR VPWR sky130_fd_sc_hd__decap_3
XTAP_TAPCELL_ROW_6_362 VGND VPWR sky130_fd_sc_hd__tapvpwrvgnd_1
Xfanout360 fanout360/A VGND VGND VPWR VPWR _5940_/A1 sky130_fd_sc_hd__buf_6
Xfanout371 fanout373/X VGND VGND VPWR VPWR wire372/A sky130_fd_sc_hd__clkdlybuf4s25_1
XFILLER_59_561 VGND VGND VPWR VPWR sky130_fd_sc_hd__decap_3
XFILLER_120_477 VGND VGND VPWR VPWR sky130_fd_sc_hd__decap_3
XFILLER_46_200 VGND VGND VPWR VPWR sky130_fd_sc_hd__decap_3
XFILLER_86_380 VGND VGND VPWR VPWR sky130_fd_sc_hd__decap_3
XFILLER_46_211 VGND VGND VPWR VPWR sky130_fd_sc_hd__fill_1
XFILLER_74_542 VGND VGND VPWR VPWR sky130_fd_sc_hd__fill_2
XFILLER_19_458 VGND VGND VPWR VPWR sky130_fd_sc_hd__decap_3
XFILLER_62_704 VGND VGND VPWR VPWR sky130_fd_sc_hd__decap_3
XFILLER_34_406 VGND VGND VPWR VPWR sky130_fd_sc_hd__decap_3
XFILLER_61_203 VGND VGND VPWR VPWR sky130_fd_sc_hd__decap_3
XFILLER_46_288 VGND VGND VPWR VPWR sky130_fd_sc_hd__decap_3
XTAP_TAPCELL_ROW_126_1982 VGND VPWR sky130_fd_sc_hd__tapvpwrvgnd_1
XFILLER_61_225 VGND VGND VPWR VPWR sky130_fd_sc_hd__decap_3
XFILLER_36_71 VGND VGND VPWR VPWR sky130_fd_sc_hd__decap_3
XFILLER_34_439 VGND VGND VPWR VPWR sky130_fd_sc_hd__decap_3
XFILLER_15_620 VGND VGND VPWR VPWR sky130_fd_sc_hd__decap_3
XFILLER_61_247 VGND VGND VPWR VPWR sky130_fd_sc_hd__fill_2
XFILLER_61_269 VGND VGND VPWR VPWR sky130_fd_sc_hd__decap_3
XFILLER_14_130 VGND VGND VPWR VPWR sky130_fd_sc_hd__decap_3
XFILLER_14_141 VGND VGND VPWR VPWR sky130_fd_sc_hd__decap_3
XFILLER_42_461 VGND VGND VPWR VPWR sky130_fd_sc_hd__decap_3
XFILLER_15_697 VGND VGND VPWR VPWR sky130_fd_sc_hd__decap_3
XFILLER_30_645 VGND VGND VPWR VPWR sky130_fd_sc_hd__fill_1
XFILLER_52_70 VGND VGND VPWR VPWR sky130_fd_sc_hd__decap_3
Xinput13 sample_in[5] VGND VGND VPWR VPWR _5946_/A sky130_fd_sc_hd__clkbuf_4
XFILLER_30_689 VGND VGND VPWR VPWR sky130_fd_sc_hd__decap_3
XFILLER_128_544 VGND VGND VPWR VPWR sky130_fd_sc_hd__decap_3
XFILLER_128_555 VGND VGND VPWR VPWR sky130_fd_sc_hd__fill_1
XTAP_TAPCELL_ROW_77_1325 VGND VPWR sky130_fd_sc_hd__tapvpwrvgnd_1
XFILLER_116_717 VGND VGND VPWR VPWR sky130_fd_sc_hd__decap_3
Xhold808 _9211_/Q VGND VGND VPWR VPWR hold808/X sky130_fd_sc_hd__dlygate4sd3_1
XFILLER_115_205 VGND VGND VPWR VPWR sky130_fd_sc_hd__decap_3
Xhold819 _9146_/Q VGND VGND VPWR VPWR hold819/X sky130_fd_sc_hd__dlygate4sd3_1
XTAP_TAPCELL_ROW_90_1503 VGND VPWR sky130_fd_sc_hd__tapvpwrvgnd_1
XFILLER_97_612 VGND VGND VPWR VPWR sky130_fd_sc_hd__decap_3
XFILLER_124_772 VGND VGND VPWR VPWR sky130_fd_sc_hd__decap_3
X_5130_ _5165_/B VGND VGND VPWR VPWR _7313_/B sky130_fd_sc_hd__clkbuf_4
XFILLER_35_3 VGND VGND VPWR VPWR sky130_fd_sc_hd__decap_3
XFILLER_97_656 VGND VGND VPWR VPWR sky130_fd_sc_hd__decap_3
XFILLER_96_144 VGND VGND VPWR VPWR sky130_fd_sc_hd__fill_1
X_5061_ _5990_/A _5053_/X _5060_/X _5055_/X _5054_/X VGND VGND VPWR VPWR _5061_/Y
+ sky130_fd_sc_hd__a2111oi_4
XFILLER_38_701 VGND VGND VPWR VPWR sky130_fd_sc_hd__decap_3
XFILLER_111_477 VGND VGND VPWR VPWR sky130_fd_sc_hd__decap_3
XFILLER_37_200 VGND VGND VPWR VPWR sky130_fd_sc_hd__decap_3
X_8820_ _8854_/A1 _8820_/A1 _8820_/S VGND VGND VPWR VPWR _8821_/A sky130_fd_sc_hd__mux2_2
XTAP_TAPCELL_ROW_88_1465 VGND VPWR sky130_fd_sc_hd__tapvpwrvgnd_1
XFILLER_65_564 VGND VGND VPWR VPWR sky130_fd_sc_hd__decap_3
XTAP_TAPCELL_ROW_88_1476 VGND VPWR sky130_fd_sc_hd__tapvpwrvgnd_1
XFILLER_53_715 VGND VGND VPWR VPWR sky130_fd_sc_hd__fill_2
XFILLER_65_586 VGND VGND VPWR VPWR sky130_fd_sc_hd__decap_3
XFILLER_25_428 VGND VGND VPWR VPWR sky130_fd_sc_hd__decap_3
XFILLER_80_523 VGND VGND VPWR VPWR sky130_fd_sc_hd__fill_1
X_5963_ _5963_/A _5963_/B VGND VGND VPWR VPWR _5965_/B sky130_fd_sc_hd__xnor2_2
X_8751_ _8728_/S _8755_/B _8655_/B VGND VGND VPWR VPWR _8751_/Y sky130_fd_sc_hd__a21oi_2
XFILLER_80_567 VGND VGND VPWR VPWR sky130_fd_sc_hd__decap_3
X_4914_ _5350_/B _4916_/B VGND VGND VPWR VPWR _4914_/Y sky130_fd_sc_hd__nand2_2
X_7702_ _7702_/A _7702_/B VGND VGND VPWR VPWR _7703_/B sky130_fd_sc_hd__or2_2
X_5894_ _9205_/Q _7955_/A _5894_/B1 VGND VGND VPWR VPWR _5895_/C sky130_fd_sc_hd__a21oi_2
X_8682_ _8706_/C _8718_/A VGND VGND VPWR VPWR _8707_/B sky130_fd_sc_hd__or2_2
XFILLER_21_601 VGND VGND VPWR VPWR sky130_fd_sc_hd__decap_3
XFILLER_21_612 VGND VGND VPWR VPWR sky130_fd_sc_hd__decap_3
XFILLER_21_623 VGND VGND VPWR VPWR sky130_fd_sc_hd__decap_3
X_4845_ _9167_/Q hold940/X _4861_/S VGND VGND VPWR VPWR _4845_/X sky130_fd_sc_hd__mux2_2
X_7633_ _7633_/A _7633_/B VGND VGND VPWR VPWR _7634_/A sky130_fd_sc_hd__xnor2_4
XFILLER_33_494 VGND VGND VPWR VPWR sky130_fd_sc_hd__decap_3
XFILLER_21_645 VGND VGND VPWR VPWR sky130_fd_sc_hd__decap_3
XFILLER_32_29 VGND VGND VPWR VPWR sky130_fd_sc_hd__decap_3
XFILLER_20_144 VGND VGND VPWR VPWR sky130_fd_sc_hd__decap_3
X_7564_ _7564_/A _7564_/B _7564_/C _7564_/D VGND VGND VPWR VPWR _7564_/X sky130_fd_sc_hd__or4_4
X_4776_ _4776_/A VGND VGND VPWR VPWR _9134_/D sky130_fd_sc_hd__buf_1
XFILLER_119_533 VGND VGND VPWR VPWR sky130_fd_sc_hd__decap_3
XFILLER_20_177 VGND VGND VPWR VPWR sky130_fd_sc_hd__decap_3
X_6515_ wire48/X _5969_/X _6069_/B VGND VGND VPWR VPWR _6523_/A sky130_fd_sc_hd__a21boi_4
X_9303_ clkload6/A _9303_/D load_slew376/X VGND VGND VPWR VPWR _9303_/Q sky130_fd_sc_hd__dfrtp_2
XTAP_TAPCELL_ROW_31_695 VGND VPWR sky130_fd_sc_hd__tapvpwrvgnd_1
X_7495_ _7495_/A _7495_/B VGND VGND VPWR VPWR _7565_/A sky130_fd_sc_hd__xnor2_4
XFILLER_119_577 VGND VGND VPWR VPWR sky130_fd_sc_hd__decap_3
X_6446_ _6446_/A _6446_/B VGND VGND VPWR VPWR _7228_/A sky130_fd_sc_hd__nand2_2
X_9234_ _9333_/CLK _9234_/D wire417/X VGND VGND VPWR VPWR _9234_/Q sky130_fd_sc_hd__dfrtp_2
XFILLER_106_9 VGND VGND VPWR VPWR sky130_fd_sc_hd__decap_3
X_9165_ clkload5/A _9165_/D wire372/A VGND VGND VPWR VPWR _9165_/Q sky130_fd_sc_hd__dfrtp_2
X_6377_ _6378_/A _6378_/B VGND VGND VPWR VPWR _6377_/Y sky130_fd_sc_hd__nand2_2
XFILLER_121_208 VGND VGND VPWR VPWR sky130_fd_sc_hd__decap_3
XFILLER_115_761 VGND VGND VPWR VPWR sky130_fd_sc_hd__decap_3
XFILLER_0_505 VGND VGND VPWR VPWR sky130_fd_sc_hd__decap_3
XFILLER_88_612 VGND VGND VPWR VPWR sky130_fd_sc_hd__decap_3
X_8116_ _8116_/A _8116_/B VGND VGND VPWR VPWR _8116_/Y sky130_fd_sc_hd__xnor2_2
XFILLER_102_411 VGND VGND VPWR VPWR sky130_fd_sc_hd__fill_2
X_5328_ _6077_/A _5328_/B VGND VGND VPWR VPWR _5328_/Y sky130_fd_sc_hd__nand2_2
XFILLER_87_100 VGND VGND VPWR VPWR sky130_fd_sc_hd__decap_3
X_9096_ _9232_/CLK _9096_/D load_slew408/X VGND VGND VPWR VPWR _9096_/Q sky130_fd_sc_hd__dfrtp_2
XFILLER_114_271 VGND VGND VPWR VPWR sky130_fd_sc_hd__decap_3
XFILLER_87_122 VGND VGND VPWR VPWR sky130_fd_sc_hd__decap_3
XFILLER_102_433 VGND VGND VPWR VPWR sky130_fd_sc_hd__fill_2
XFILLER_57_15 VGND VGND VPWR VPWR sky130_fd_sc_hd__decap_3
XFILLER_130_753 VGND VGND VPWR VPWR sky130_fd_sc_hd__decap_3
XFILLER_102_455 VGND VGND VPWR VPWR sky130_fd_sc_hd__decap_3
X_8047_ _7763_/B _7764_/B _8047_/S VGND VGND VPWR VPWR _8048_/A sky130_fd_sc_hd__mux2_2
X_5259_ _9291_/Q _6753_/B _5442_/B _5259_/B1 _5258_/X VGND VGND VPWR VPWR _5259_/X
+ sky130_fd_sc_hd__a32o_2
XTAP_TAPCELL_ROW_110_1761 VGND VPWR sky130_fd_sc_hd__tapvpwrvgnd_1
XTAP_TAPCELL_ROW_110_1772 VGND VPWR sky130_fd_sc_hd__tapvpwrvgnd_1
XFILLER_130_775 VGND VGND VPWR VPWR sky130_fd_sc_hd__fill_2
XFILLER_102_477 VGND VGND VPWR VPWR sky130_fd_sc_hd__decap_3
XFILLER_57_48 VGND VGND VPWR VPWR sky130_fd_sc_hd__decap_3
XFILLER_29_712 VGND VGND VPWR VPWR sky130_fd_sc_hd__decap_3
XFILLER_102_499 VGND VGND VPWR VPWR sky130_fd_sc_hd__decap_3
XTAP_TAPCELL_ROW_3_321 VGND VPWR sky130_fd_sc_hd__tapvpwrvgnd_1
XFILLER_56_531 VGND VGND VPWR VPWR sky130_fd_sc_hd__fill_1
XFILLER_113_21 VGND VGND VPWR VPWR sky130_fd_sc_hd__decap_3
XFILLER_28_233 VGND VGND VPWR VPWR sky130_fd_sc_hd__decap_3
Xclkbuf_2_2__f_clk clkbuf_0_clk/X VGND VGND VPWR VPWR clkload1/A sky130_fd_sc_hd__clkbuf_16
XFILLER_90_309 VGND VGND VPWR VPWR sky130_fd_sc_hd__decap_3
XFILLER_56_564 VGND VGND VPWR VPWR sky130_fd_sc_hd__decap_3
XFILLER_44_704 VGND VGND VPWR VPWR sky130_fd_sc_hd__fill_1
XFILLER_113_54 VGND VGND VPWR VPWR sky130_fd_sc_hd__fill_2
XFILLER_16_406 VGND VGND VPWR VPWR sky130_fd_sc_hd__decap_3
XFILLER_73_25 VGND VGND VPWR VPWR sky130_fd_sc_hd__decap_3
XFILLER_44_748 VGND VGND VPWR VPWR sky130_fd_sc_hd__decap_3
XFILLER_43_225 VGND VGND VPWR VPWR sky130_fd_sc_hd__fill_2
X_8949_ hold856/X _8949_/A1 _8967_/S VGND VGND VPWR VPWR _8950_/A sky130_fd_sc_hd__mux2_2
XFILLER_71_545 VGND VGND VPWR VPWR sky130_fd_sc_hd__decap_3
XFILLER_71_567 VGND VGND VPWR VPWR sky130_fd_sc_hd__fill_2
XTAP_TAPCELL_ROW_61_1104 VGND VPWR sky130_fd_sc_hd__tapvpwrvgnd_1
XFILLER_12_612 VGND VGND VPWR VPWR sky130_fd_sc_hd__decap_3
XFILLER_24_494 VGND VGND VPWR VPWR sky130_fd_sc_hd__decap_3
XFILLER_12_645 VGND VGND VPWR VPWR sky130_fd_sc_hd__decap_3
XFILLER_12_667 VGND VGND VPWR VPWR sky130_fd_sc_hd__fill_2
XTAP_TAPCELL_ROW_50_960 VGND VPWR sky130_fd_sc_hd__tapvpwrvgnd_1
XFILLER_12_689 VGND VGND VPWR VPWR sky130_fd_sc_hd__decap_3
XFILLER_22_40 VGND VGND VPWR VPWR sky130_fd_sc_hd__decap_3
XFILLER_11_188 VGND VGND VPWR VPWR sky130_fd_sc_hd__fill_2
XFILLER_22_73 VGND VGND VPWR VPWR sky130_fd_sc_hd__decap_3
XFILLER_125_547 VGND VGND VPWR VPWR sky130_fd_sc_hd__decap_3
XTAP_TAPCELL_ROW_59_1077 VGND VPWR sky130_fd_sc_hd__tapvpwrvgnd_1
XFILLER_113_709 VGND VGND VPWR VPWR sky130_fd_sc_hd__decap_3
XFILLER_3_343 VGND VGND VPWR VPWR sky130_fd_sc_hd__decap_3
XFILLER_98_88 VGND VGND VPWR VPWR sky130_fd_sc_hd__decap_3
XFILLER_79_612 VGND VGND VPWR VPWR sky130_fd_sc_hd__decap_3
XFILLER_78_100 VGND VGND VPWR VPWR sky130_fd_sc_hd__fill_1
XFILLER_3_387 VGND VGND VPWR VPWR sky130_fd_sc_hd__decap_3
XFILLER_105_293 VGND VGND VPWR VPWR sky130_fd_sc_hd__decap_3
XTAP_TAPCELL_ROW_72_1255 VGND VPWR sky130_fd_sc_hd__tapvpwrvgnd_1
XFILLER_121_753 VGND VGND VPWR VPWR sky130_fd_sc_hd__decap_3
XFILLER_78_144 VGND VGND VPWR VPWR sky130_fd_sc_hd__fill_2
XFILLER_94_604 VGND VGND VPWR VPWR sky130_fd_sc_hd__decap_3
XFILLER_79_689 VGND VGND VPWR VPWR sky130_fd_sc_hd__decap_3
XFILLER_21_9 VGND VGND VPWR VPWR sky130_fd_sc_hd__decap_3
XFILLER_94_626 VGND VGND VPWR VPWR sky130_fd_sc_hd__decap_3
XFILLER_66_339 VGND VGND VPWR VPWR sky130_fd_sc_hd__decap_3
XFILLER_93_169 VGND VGND VPWR VPWR sky130_fd_sc_hd__fill_1
XFILLER_47_564 VGND VGND VPWR VPWR sky130_fd_sc_hd__decap_3
XFILLER_35_726 VGND VGND VPWR VPWR sky130_fd_sc_hd__fill_2
XFILLER_19_277 VGND VGND VPWR VPWR sky130_fd_sc_hd__decap_3
XFILLER_35_748 VGND VGND VPWR VPWR sky130_fd_sc_hd__decap_3
XFILLER_19_299 VGND VGND VPWR VPWR sky130_fd_sc_hd__decap_3
XFILLER_74_394 VGND VGND VPWR VPWR sky130_fd_sc_hd__decap_3
XFILLER_62_589 VGND VGND VPWR VPWR sky130_fd_sc_hd__decap_3
XFILLER_50_729 VGND VGND VPWR VPWR sky130_fd_sc_hd__decap_3
XFILLER_43_770 VGND VGND VPWR VPWR sky130_fd_sc_hd__decap_3
XFILLER_42_280 VGND VGND VPWR VPWR sky130_fd_sc_hd__decap_3
XFILLER_30_431 VGND VGND VPWR VPWR sky130_fd_sc_hd__decap_3
X_4630_ _4630_/A VGND VGND VPWR VPWR _9065_/D sky130_fd_sc_hd__buf_1
XFILLER_8_53 VGND VGND VPWR VPWR sky130_fd_sc_hd__decap_3
XFILLER_30_486 VGND VGND VPWR VPWR sky130_fd_sc_hd__decap_3
X_4561_ _4561_/A VGND VGND VPWR VPWR _9032_/D sky130_fd_sc_hd__buf_1
XFILLER_128_363 VGND VGND VPWR VPWR sky130_fd_sc_hd__fill_1
XFILLER_116_503 VGND VGND VPWR VPWR sky130_fd_sc_hd__decap_3
X_6300_ _6290_/A _6203_/A _6297_/C _6294_/X _6299_/X VGND VGND VPWR VPWR _6300_/X
+ sky130_fd_sc_hd__a221o_2
XFILLER_116_514 VGND VGND VPWR VPWR sky130_fd_sc_hd__decap_3
XFILLER_7_671 VGND VGND VPWR VPWR sky130_fd_sc_hd__fill_1
XFILLER_128_374 VGND VGND VPWR VPWR sky130_fd_sc_hd__fill_1
X_7280_ _7280_/A _7280_/B _7280_/C VGND VGND VPWR VPWR _7564_/D sky130_fd_sc_hd__and3_4
XFILLER_116_536 VGND VGND VPWR VPWR sky130_fd_sc_hd__fill_2
XFILLER_116_547 VGND VGND VPWR VPWR sky130_fd_sc_hd__decap_3
X_6231_ _6232_/C _6231_/B _9266_/Q VGND VGND VPWR VPWR _6231_/X sky130_fd_sc_hd__and3b_2
XFILLER_6_192 VGND VGND VPWR VPWR sky130_fd_sc_hd__decap_3
X_6162_ _6161_/Y _6050_/A _6049_/A _6159_/Y _6158_/A VGND VGND VPWR VPWR _6163_/C
+ sky130_fd_sc_hd__a41o_2
XFILLER_69_122 VGND VGND VPWR VPWR sky130_fd_sc_hd__fill_1
XFILLER_112_742 VGND VGND VPWR VPWR sky130_fd_sc_hd__fill_1
XFILLER_97_442 VGND VGND VPWR VPWR sky130_fd_sc_hd__decap_3
X_5113_ _5175_/B _5879_/B VGND VGND VPWR VPWR _5114_/A sky130_fd_sc_hd__and2_2
XFILLER_85_604 VGND VGND VPWR VPWR sky130_fd_sc_hd__fill_1
X_6093_ _5221_/A _6082_/X _6092_/X VGND VGND VPWR VPWR _6126_/A sky130_fd_sc_hd__a21o_2
XFILLER_85_615 VGND VGND VPWR VPWR sky130_fd_sc_hd__fill_1
XFILLER_85_626 VGND VGND VPWR VPWR sky130_fd_sc_hd__decap_3
XFILLER_111_263 VGND VGND VPWR VPWR sky130_fd_sc_hd__fill_1
XFILLER_97_497 VGND VGND VPWR VPWR sky130_fd_sc_hd__decap_3
X_5044_ _9196_/Q _5044_/B _5044_/C VGND VGND VPWR VPWR _5045_/B sky130_fd_sc_hd__and3_2
XFILLER_85_648 VGND VGND VPWR VPWR sky130_fd_sc_hd__decap_3
XFILLER_38_520 VGND VGND VPWR VPWR sky130_fd_sc_hd__decap_3
XFILLER_111_296 VGND VGND VPWR VPWR sky130_fd_sc_hd__decap_3
XFILLER_27_29 VGND VGND VPWR VPWR sky130_fd_sc_hd__decap_3
XFILLER_84_169 VGND VGND VPWR VPWR sky130_fd_sc_hd__decap_3
XFILLER_38_564 VGND VGND VPWR VPWR sky130_fd_sc_hd__decap_3
XFILLER_65_361 VGND VGND VPWR VPWR sky130_fd_sc_hd__decap_3
XFILLER_38_586 VGND VGND VPWR VPWR sky130_fd_sc_hd__fill_2
XFILLER_53_523 VGND VGND VPWR VPWR sky130_fd_sc_hd__decap_3
XFILLER_25_214 VGND VGND VPWR VPWR sky130_fd_sc_hd__decap_3
X_8803_ _8803_/A VGND VGND VPWR VPWR _9246_/D sky130_fd_sc_hd__buf_1
X_6995_ _5999_/A _5999_/B _6279_/A VGND VGND VPWR VPWR _6997_/A sky130_fd_sc_hd__a21o_2
XTAP_TAPCELL_ROW_36_765 VGND VPWR sky130_fd_sc_hd__tapvpwrvgnd_1
XFILLER_41_718 VGND VGND VPWR VPWR sky130_fd_sc_hd__decap_3
X_8734_ _9230_/Q _8753_/A _8734_/C VGND VGND VPWR VPWR _8734_/X sky130_fd_sc_hd__and3_2
X_5946_ _5946_/A _6446_/B VGND VGND VPWR VPWR _6103_/S sky130_fd_sc_hd__xor2_4
XFILLER_53_589 VGND VGND VPWR VPWR sky130_fd_sc_hd__decap_3
XFILLER_43_28 VGND VGND VPWR VPWR sky130_fd_sc_hd__decap_3
XFILLER_41_729 VGND VGND VPWR VPWR sky130_fd_sc_hd__decap_3
XFILLER_40_228 VGND VGND VPWR VPWR sky130_fd_sc_hd__decap_3
XFILLER_80_397 VGND VGND VPWR VPWR sky130_fd_sc_hd__fill_1
XFILLER_21_420 VGND VGND VPWR VPWR sky130_fd_sc_hd__decap_3
X_5877_ _9140_/Q _5126_/X _5874_/X _5875_/X _5876_/X VGND VGND VPWR VPWR _5890_/D
+ sky130_fd_sc_hd__a2111o_2
X_8665_ _8665_/A VGND VGND VPWR VPWR _8729_/S sky130_fd_sc_hd__inv_2
XFILLER_33_291 VGND VGND VPWR VPWR sky130_fd_sc_hd__decap_3
X_4828_ hold898/X _4828_/A1 _4840_/S VGND VGND VPWR VPWR _4829_/A sky130_fd_sc_hd__mux2_2
X_7616_ _7617_/B _7617_/C _7763_/B VGND VGND VPWR VPWR _7618_/B sky130_fd_sc_hd__o21a_2
X_8596_ _8560_/A _8591_/Y _8593_/Y _8581_/Y _8595_/X VGND VGND VPWR VPWR _8642_/A
+ sky130_fd_sc_hd__a221o_2
X_4759_ _4792_/A1 _4759_/A1 _4777_/S VGND VGND VPWR VPWR _4760_/A sky130_fd_sc_hd__mux2_2
X_7547_ _7547_/A _7547_/B VGND VGND VPWR VPWR _7548_/B sky130_fd_sc_hd__nor2_2
XFILLER_107_503 VGND VGND VPWR VPWR sky130_fd_sc_hd__fill_1
XFILLER_107_514 VGND VGND VPWR VPWR sky130_fd_sc_hd__fill_2
X_7478_ _7476_/Y _7478_/B VGND VGND VPWR VPWR _7643_/B sky130_fd_sc_hd__nand2b_2
XFILLER_4_129 VGND VGND VPWR VPWR sky130_fd_sc_hd__decap_3
XFILLER_107_558 VGND VGND VPWR VPWR sky130_fd_sc_hd__fill_2
XFILLER_108_21 VGND VGND VPWR VPWR sky130_fd_sc_hd__decap_3
XFILLER_104_6 VGND VGND VPWR VPWR sky130_fd_sc_hd__decap_3
XFILLER_108_32 VGND VGND VPWR VPWR sky130_fd_sc_hd__decap_3
X_9217_ _9219_/CLK _9217_/D fanout413/X VGND VGND VPWR VPWR _9217_/Q sky130_fd_sc_hd__dfrtp_2
X_6429_ _6886_/A _6885_/A VGND VGND VPWR VPWR _6430_/B sky130_fd_sc_hd__nand2_2
XFILLER_0_302 VGND VGND VPWR VPWR sky130_fd_sc_hd__decap_3
XFILLER_122_539 VGND VGND VPWR VPWR sky130_fd_sc_hd__decap_3
X_9148_ _9236_/CLK _9148_/D fanout398/X VGND VGND VPWR VPWR _9148_/Q sky130_fd_sc_hd__dfrtp_2
XFILLER_115_580 VGND VGND VPWR VPWR sky130_fd_sc_hd__decap_3
XFILLER_0_346 VGND VGND VPWR VPWR sky130_fd_sc_hd__decap_3
XTAP_TAPCELL_ROW_128_2008 VGND VPWR sky130_fd_sc_hd__tapvpwrvgnd_1
X_9079_ _9159_/CLK _9079_/D load_slew390/X VGND VGND VPWR VPWR _9079_/Q sky130_fd_sc_hd__dfrtp_2
XFILLER_0_368 VGND VGND VPWR VPWR sky130_fd_sc_hd__decap_3
XFILLER_130_561 VGND VGND VPWR VPWR sky130_fd_sc_hd__decap_3
XFILLER_88_497 VGND VGND VPWR VPWR sky130_fd_sc_hd__fill_1
XFILLER_76_648 VGND VGND VPWR VPWR sky130_fd_sc_hd__decap_3
XFILLER_124_53 VGND VGND VPWR VPWR sky130_fd_sc_hd__decap_3
XFILLER_124_97 VGND VGND VPWR VPWR sky130_fd_sc_hd__decap_3
XFILLER_75_169 VGND VGND VPWR VPWR sky130_fd_sc_hd__fill_2
XFILLER_56_350 VGND VGND VPWR VPWR sky130_fd_sc_hd__decap_3
XFILLER_29_564 VGND VGND VPWR VPWR sky130_fd_sc_hd__decap_3
XFILLER_17_704 VGND VGND VPWR VPWR sky130_fd_sc_hd__decap_3
XFILLER_90_106 VGND VGND VPWR VPWR sky130_fd_sc_hd__decap_3
XFILLER_84_68 VGND VGND VPWR VPWR sky130_fd_sc_hd__decap_3
XFILLER_44_512 VGND VGND VPWR VPWR sky130_fd_sc_hd__decap_3
XFILLER_90_128 VGND VGND VPWR VPWR sky130_fd_sc_hd__decap_3
XFILLER_16_214 VGND VGND VPWR VPWR sky130_fd_sc_hd__decap_3
XFILLER_90_139 VGND VGND VPWR VPWR sky130_fd_sc_hd__fill_1
XFILLER_17_51 VGND VGND VPWR VPWR sky130_fd_sc_hd__decap_3
XFILLER_17_759 VGND VGND VPWR VPWR sky130_fd_sc_hd__decap_3
XFILLER_16_247 VGND VGND VPWR VPWR sky130_fd_sc_hd__decap_3
XTAP_TAPCELL_ROW_123_1941 VGND VPWR sky130_fd_sc_hd__tapvpwrvgnd_1
XFILLER_32_718 VGND VGND VPWR VPWR sky130_fd_sc_hd__decap_3
XFILLER_32_729 VGND VGND VPWR VPWR sky130_fd_sc_hd__decap_3
XFILLER_24_280 VGND VGND VPWR VPWR sky130_fd_sc_hd__fill_1
XFILLER_24_291 VGND VGND VPWR VPWR sky130_fd_sc_hd__decap_3
XFILLER_129_105 VGND VGND VPWR VPWR sky130_fd_sc_hd__decap_3
XFILLER_129_116 VGND VGND VPWR VPWR sky130_fd_sc_hd__decap_3
XFILLER_12_497 VGND VGND VPWR VPWR sky130_fd_sc_hd__decap_3
XFILLER_129_149 VGND VGND VPWR VPWR sky130_fd_sc_hd__decap_3
XFILLER_69_9 VGND VGND VPWR VPWR sky130_fd_sc_hd__decap_3
XFILLER_4_652 VGND VGND VPWR VPWR sky130_fd_sc_hd__decap_3
XFILLER_99_729 VGND VGND VPWR VPWR sky130_fd_sc_hd__decap_3
XFILLER_113_517 VGND VGND VPWR VPWR sky130_fd_sc_hd__fill_1
XFILLER_4_685 VGND VGND VPWR VPWR sky130_fd_sc_hd__decap_3
XFILLER_125_388 VGND VGND VPWR VPWR sky130_fd_sc_hd__decap_3
XFILLER_79_420 VGND VGND VPWR VPWR sky130_fd_sc_hd__fill_1
XFILLER_3_184 VGND VGND VPWR VPWR sky130_fd_sc_hd__fill_2
XFILLER_79_475 VGND VGND VPWR VPWR sky130_fd_sc_hd__fill_1
XFILLER_121_561 VGND VGND VPWR VPWR sky130_fd_sc_hd__decap_3
XFILLER_66_103 VGND VGND VPWR VPWR sky130_fd_sc_hd__decap_3
XFILLER_94_445 VGND VGND VPWR VPWR sky130_fd_sc_hd__fill_1
XFILLER_66_136 VGND VGND VPWR VPWR sky130_fd_sc_hd__fill_1
XFILLER_94_467 VGND VGND VPWR VPWR sky130_fd_sc_hd__decap_3
XFILLER_94_489 VGND VGND VPWR VPWR sky130_fd_sc_hd__decap_3
XFILLER_75_670 VGND VGND VPWR VPWR sky130_fd_sc_hd__fill_2
XFILLER_47_372 VGND VGND VPWR VPWR sky130_fd_sc_hd__decap_3
XTAP_TAPCELL_ROW_85_1424 VGND VPWR sky130_fd_sc_hd__tapvpwrvgnd_1
XTAP_TAPCELL_ROW_85_1435 VGND VPWR sky130_fd_sc_hd__tapvpwrvgnd_1
XFILLER_35_556 VGND VGND VPWR VPWR sky130_fd_sc_hd__decap_3
XFILLER_35_567 VGND VGND VPWR VPWR sky130_fd_sc_hd__decap_3
X_5800_ _5922_/A _5800_/B VGND VGND VPWR VPWR _5808_/A sky130_fd_sc_hd__xnor2_4
X_6780_ _6905_/A _6780_/B VGND VGND VPWR VPWR _6781_/B sky130_fd_sc_hd__or2_2
XFILLER_23_729 VGND VGND VPWR VPWR sky130_fd_sc_hd__decap_3
XFILLER_90_695 VGND VGND VPWR VPWR sky130_fd_sc_hd__decap_3
XFILLER_62_386 VGND VGND VPWR VPWR sky130_fd_sc_hd__decap_3
XTAP_TAPCELL_ROW_33_724 VGND VPWR sky130_fd_sc_hd__tapvpwrvgnd_1
XFILLER_50_537 VGND VGND VPWR VPWR sky130_fd_sc_hd__decap_3
X_5731_ _9059_/Q _5730_/X _4992_/X _9327_/Q VGND VGND VPWR VPWR _5735_/A sky130_fd_sc_hd__a22o_2
XFILLER_15_291 VGND VGND VPWR VPWR sky130_fd_sc_hd__decap_3
X_5662_ _5662_/A _5662_/B VGND VGND VPWR VPWR _5673_/B sky130_fd_sc_hd__xnor2_2
X_8450_ _8560_/B _8442_/Y _8445_/X _8449_/X VGND VGND VPWR VPWR _8504_/B sky130_fd_sc_hd__a211o_2
X_4613_ _4646_/A1 _4613_/A1 _4629_/S VGND VGND VPWR VPWR _4614_/A sky130_fd_sc_hd__mux2_2
X_7401_ _7407_/A wire84/X _7344_/B _7408_/A VGND VGND VPWR VPWR _7401_/X sky130_fd_sc_hd__a211o_2
XFILLER_30_283 VGND VGND VPWR VPWR sky130_fd_sc_hd__decap_3
X_8381_ _8377_/Y _8380_/X _8402_/A VGND VGND VPWR VPWR _8381_/X sky130_fd_sc_hd__mux2_2
XFILLER_129_650 VGND VGND VPWR VPWR sky130_fd_sc_hd__decap_3
X_5593_ _7114_/C _6972_/A VGND VGND VPWR VPWR _5727_/B sky130_fd_sc_hd__nand2_2
X_7332_ _7332_/A _7332_/B _7443_/B VGND VGND VPWR VPWR _7333_/C sky130_fd_sc_hd__nand3_2
XFILLER_116_300 VGND VGND VPWR VPWR sky130_fd_sc_hd__decap_3
X_4544_ hold841/X _9001_/A0 _4544_/S VGND VGND VPWR VPWR _4545_/A sky130_fd_sc_hd__mux2_2
XFILLER_129_694 VGND VGND VPWR VPWR sky130_fd_sc_hd__decap_3
XFILLER_128_171 VGND VGND VPWR VPWR sky130_fd_sc_hd__decap_3
Xmax_cap121 _5855_/B VGND VGND VPWR VPWR _8240_/A sky130_fd_sc_hd__buf_2
XTAP_TAPCELL_ROW_96_1575 VGND VPWR sky130_fd_sc_hd__tapvpwrvgnd_1
Xmax_cap132 _5093_/X VGND VGND VPWR VPWR _6270_/S sky130_fd_sc_hd__buf_6
X_7263_ _7263_/A _7263_/B VGND VGND VPWR VPWR _7508_/B sky130_fd_sc_hd__nand2_2
Xmax_cap154 _5388_/Y VGND VGND VPWR VPWR _6167_/A2 sky130_fd_sc_hd__buf_6
Xmax_cap165 _7231_/A VGND VGND VPWR VPWR _6870_/A sky130_fd_sc_hd__clkbuf_2
Xmax_cap176 _5386_/Y VGND VGND VPWR VPWR _5388_/A1 sky130_fd_sc_hd__clkbuf_2
X_6214_ _6368_/A _6215_/B _6215_/C VGND VGND VPWR VPWR _6216_/B sky130_fd_sc_hd__a21o_2
X_9002_ _9002_/A VGND VGND VPWR VPWR _9341_/D sky130_fd_sc_hd__buf_1
XFILLER_89_228 VGND VGND VPWR VPWR sky130_fd_sc_hd__fill_2
Xmax_cap187 _5040_/A VGND VGND VPWR VPWR _7050_/B sky130_fd_sc_hd__buf_2
X_7194_ _7194_/A _7194_/B VGND VGND VPWR VPWR _7210_/A sky130_fd_sc_hd__xnor2_2
Xmax_cap198 _6450_/B VGND VGND VPWR VPWR _7656_/A sky130_fd_sc_hd__buf_4
X_6145_ _6064_/A1 _6145_/B VGND VGND VPWR VPWR _6145_/X sky130_fd_sc_hd__and2b_2
XFILLER_100_701 VGND VGND VPWR VPWR sky130_fd_sc_hd__decap_3
XFILLER_58_615 VGND VGND VPWR VPWR sky130_fd_sc_hd__decap_3
XFILLER_97_272 VGND VGND VPWR VPWR sky130_fd_sc_hd__fill_2
Xhold1102 _9342_/Q VGND VGND VPWR VPWR _9003_/A0 sky130_fd_sc_hd__dlygate4sd3_1
XFILLER_100_734 VGND VGND VPWR VPWR sky130_fd_sc_hd__fill_1
Xhold1113 _8932_/X VGND VGND VPWR VPWR _8933_/A sky130_fd_sc_hd__dlygate4sd3_1
XFILLER_58_648 VGND VGND VPWR VPWR sky130_fd_sc_hd__decap_3
X_6076_ _6076_/A _6416_/A _6091_/A VGND VGND VPWR VPWR _6076_/X sky130_fd_sc_hd__or3b_2
Xload_slew382 fanout381/X VGND VGND VPWR VPWR fanout379/A sky130_fd_sc_hd__clkbuf_4
Xhold1124 _9116_/Q VGND VGND VPWR VPWR _4771_/A1 sky130_fd_sc_hd__dlygate4sd3_1
Xload_slew393 load_slew394/X VGND VGND VPWR VPWR load_slew393/X sky130_fd_sc_hd__buf_4
Xhold1135 _4706_/X VGND VGND VPWR VPWR _4707_/A sky130_fd_sc_hd__dlygate4sd3_1
Xhold1146 _8909_/X VGND VGND VPWR VPWR _8910_/A sky130_fd_sc_hd__dlygate4sd3_1
XFILLER_57_158 VGND VGND VPWR VPWR sky130_fd_sc_hd__fill_2
X_5027_ _6765_/A VGND VGND VPWR VPWR _8271_/B sky130_fd_sc_hd__clkbuf_2
Xhold1157 _9243_/Q VGND VGND VPWR VPWR _8829_/A1 sky130_fd_sc_hd__dlygate4sd3_1
Xhold1168 _9043_/Q VGND VGND VPWR VPWR _4617_/A1 sky130_fd_sc_hd__dlygate4sd3_1
Xhold1179 _9048_/Q VGND VGND VPWR VPWR _4627_/A1 sky130_fd_sc_hd__dlygate4sd3_1
XFILLER_85_489 VGND VGND VPWR VPWR sky130_fd_sc_hd__fill_2
XFILLER_66_670 VGND VGND VPWR VPWR sky130_fd_sc_hd__decap_3
XFILLER_38_361 VGND VGND VPWR VPWR sky130_fd_sc_hd__decap_3
XFILLER_26_501 VGND VGND VPWR VPWR sky130_fd_sc_hd__decap_3
XFILLER_72_117 VGND VGND VPWR VPWR sky130_fd_sc_hd__fill_2
XFILLER_26_523 VGND VGND VPWR VPWR sky130_fd_sc_hd__decap_3
XFILLER_38_383 VGND VGND VPWR VPWR sky130_fd_sc_hd__decap_3
XFILLER_81_640 VGND VGND VPWR VPWR sky130_fd_sc_hd__decap_3
XFILLER_26_545 VGND VGND VPWR VPWR sky130_fd_sc_hd__decap_3
XFILLER_14_707 VGND VGND VPWR VPWR sky130_fd_sc_hd__decap_3
XFILLER_81_662 VGND VGND VPWR VPWR sky130_fd_sc_hd__decap_3
XFILLER_53_375 VGND VGND VPWR VPWR sky130_fd_sc_hd__decap_3
X_6978_ _6953_/A _6954_/X _6976_/X _7099_/C VGND VGND VPWR VPWR _6978_/X sky130_fd_sc_hd__a211o_2
XFILLER_81_695 VGND VGND VPWR VPWR sky130_fd_sc_hd__decap_3
XFILLER_41_526 VGND VGND VPWR VPWR sky130_fd_sc_hd__decap_3
X_8717_ _8671_/A _8715_/Y _8716_/Y VGND VGND VPWR VPWR _8717_/X sky130_fd_sc_hd__a21o_2
XTAP_TAPCELL_ROW_105_1693 VGND VPWR sky130_fd_sc_hd__tapvpwrvgnd_1
XFILLER_80_194 VGND VGND VPWR VPWR sky130_fd_sc_hd__fill_2
XFILLER_110_44 VGND VGND VPWR VPWR sky130_fd_sc_hd__decap_3
X_5929_ _6084_/A _7195_/A VGND VGND VPWR VPWR _5929_/Y sky130_fd_sc_hd__nor2_2
XFILLER_41_559 VGND VGND VPWR VPWR sky130_fd_sc_hd__fill_1
XFILLER_22_740 VGND VGND VPWR VPWR sky130_fd_sc_hd__decap_3
XFILLER_70_37 VGND VGND VPWR VPWR sky130_fd_sc_hd__decap_3
X_8648_ _8627_/A _8645_/X _8646_/X _8647_/X VGND VGND VPWR VPWR _8648_/X sky130_fd_sc_hd__a22o_2
XFILLER_110_99 VGND VGND VPWR VPWR sky130_fd_sc_hd__decap_3
XTAP_TAPCELL_ROW_11_429 VGND VPWR sky130_fd_sc_hd__tapvpwrvgnd_1
Xrebuffer510 _6908_/A VGND VGND VPWR VPWR _6599_/A sky130_fd_sc_hd__buf_2
Xrebuffer521 _5973_/C VGND VGND VPWR VPWR _5906_/B1 sky130_fd_sc_hd__buf_2
X_8579_ _8577_/Y _8512_/X _8578_/Y VGND VGND VPWR VPWR _8579_/Y sky130_fd_sc_hd__o21ai_4
Xrebuffer532 wire151/X VGND VGND VPWR VPWR _6681_/A2 sky130_fd_sc_hd__buf_2
Xrebuffer543 _6924_/B VGND VGND VPWR VPWR _6910_/A sky130_fd_sc_hd__buf_2
Xrebuffer554 _8276_/Y VGND VGND VPWR VPWR _8288_/A sky130_fd_sc_hd__buf_2
Xrebuffer565 _6374_/A VGND VGND VPWR VPWR _6375_/A1 sky130_fd_sc_hd__buf_2
XFILLER_119_42 VGND VGND VPWR VPWR sky130_fd_sc_hd__decap_3
Xrebuffer576 _6215_/B VGND VGND VPWR VPWR _6368_/B sky130_fd_sc_hd__buf_2
XFILLER_107_333 VGND VGND VPWR VPWR sky130_fd_sc_hd__decap_3
Xrebuffer587 _4991_/C VGND VGND VPWR VPWR _5462_/S sky130_fd_sc_hd__buf_2
XFILLER_79_24 VGND VGND VPWR VPWR sky130_fd_sc_hd__decap_3
XFILLER_119_75 VGND VGND VPWR VPWR sky130_fd_sc_hd__decap_3
Xrebuffer598 _7046_/B VGND VGND VPWR VPWR _7296_/A1 sky130_fd_sc_hd__buf_2
XFILLER_102_3 VGND VGND VPWR VPWR sky130_fd_sc_hd__decap_3
XFILLER_107_366 VGND VGND VPWR VPWR sky130_fd_sc_hd__decap_3
XTAP_TAPCELL_ROW_56_1036 VGND VPWR sky130_fd_sc_hd__tapvpwrvgnd_1
XFILLER_1_600 VGND VGND VPWR VPWR sky130_fd_sc_hd__decap_3
XFILLER_107_388 VGND VGND VPWR VPWR sky130_fd_sc_hd__decap_3
XFILLER_122_325 VGND VGND VPWR VPWR sky130_fd_sc_hd__decap_3
XFILLER_0_110 VGND VGND VPWR VPWR sky130_fd_sc_hd__fill_2
Xhold980 _4765_/X VGND VGND VPWR VPWR _4766_/A sky130_fd_sc_hd__dlygate4sd3_1
Xhold991 _9315_/Q VGND VGND VPWR VPWR hold991/X sky130_fd_sc_hd__dlygate4sd3_1
XFILLER_89_751 VGND VGND VPWR VPWR sky130_fd_sc_hd__decap_3
XFILLER_1_644 VGND VGND VPWR VPWR sky130_fd_sc_hd__decap_3
XFILLER_0_132 VGND VGND VPWR VPWR sky130_fd_sc_hd__fill_2
XFILLER_103_550 VGND VGND VPWR VPWR sky130_fd_sc_hd__decap_3
XFILLER_88_250 VGND VGND VPWR VPWR sky130_fd_sc_hd__fill_2
XFILLER_103_561 VGND VGND VPWR VPWR sky130_fd_sc_hd__decap_3
XFILLER_0_165 VGND VGND VPWR VPWR sky130_fd_sc_hd__decap_3
XFILLER_48_103 VGND VGND VPWR VPWR sky130_fd_sc_hd__decap_3
XFILLER_1_688 VGND VGND VPWR VPWR sky130_fd_sc_hd__decap_3
XFILLER_49_648 VGND VGND VPWR VPWR sky130_fd_sc_hd__decap_3
XFILLER_130_380 VGND VGND VPWR VPWR sky130_fd_sc_hd__fill_1
XFILLER_76_445 VGND VGND VPWR VPWR sky130_fd_sc_hd__decap_3
XFILLER_64_618 VGND VGND VPWR VPWR sky130_fd_sc_hd__decap_3
XFILLER_28_50 VGND VGND VPWR VPWR sky130_fd_sc_hd__decap_3
XFILLER_17_501 VGND VGND VPWR VPWR sky130_fd_sc_hd__decap_3
XFILLER_91_426 VGND VGND VPWR VPWR sky130_fd_sc_hd__decap_3
XFILLER_57_681 VGND VGND VPWR VPWR sky130_fd_sc_hd__decap_3
XFILLER_28_83 VGND VGND VPWR VPWR sky130_fd_sc_hd__fill_1
XFILLER_29_383 VGND VGND VPWR VPWR sky130_fd_sc_hd__decap_3
XFILLER_44_320 VGND VGND VPWR VPWR sky130_fd_sc_hd__decap_3
XFILLER_44_342 VGND VGND VPWR VPWR sky130_fd_sc_hd__decap_3
XFILLER_17_567 VGND VGND VPWR VPWR sky130_fd_sc_hd__decap_3
XFILLER_32_504 VGND VGND VPWR VPWR sky130_fd_sc_hd__decap_3
XTAP_TAPCELL_ROW_67_1187 VGND VPWR sky130_fd_sc_hd__tapvpwrvgnd_1
XFILLER_71_161 VGND VGND VPWR VPWR sky130_fd_sc_hd__decap_3
XFILLER_71_172 VGND VGND VPWR VPWR sky130_fd_sc_hd__fill_1
XFILLER_44_386 VGND VGND VPWR VPWR sky130_fd_sc_hd__fill_1
XFILLER_44_60 VGND VGND VPWR VPWR sky130_fd_sc_hd__decap_3
XFILLER_44_71 VGND VGND VPWR VPWR sky130_fd_sc_hd__decap_3
XFILLER_9_700 VGND VGND VPWR VPWR sky130_fd_sc_hd__decap_3
XFILLER_13_762 VGND VGND VPWR VPWR sky130_fd_sc_hd__decap_3
XTAP_TAPCELL_ROW_80_1365 VGND VPWR sky130_fd_sc_hd__tapvpwrvgnd_1
XFILLER_9_744 VGND VGND VPWR VPWR sky130_fd_sc_hd__decap_3
XFILLER_117_108 VGND VGND VPWR VPWR sky130_fd_sc_hd__decap_3
XFILLER_8_265 VGND VGND VPWR VPWR sky130_fd_sc_hd__decap_3
XFILLER_60_70 VGND VGND VPWR VPWR sky130_fd_sc_hd__decap_3
XFILLER_126_642 VGND VGND VPWR VPWR sky130_fd_sc_hd__fill_2
XFILLER_5_21 VGND VGND VPWR VPWR sky130_fd_sc_hd__decap_3
XFILLER_126_675 VGND VGND VPWR VPWR sky130_fd_sc_hd__decap_3
XFILLER_125_152 VGND VGND VPWR VPWR sky130_fd_sc_hd__decap_3
XFILLER_5_54 VGND VGND VPWR VPWR sky130_fd_sc_hd__fill_2
XFILLER_4_460 VGND VGND VPWR VPWR sky130_fd_sc_hd__decap_3
XFILLER_113_314 VGND VGND VPWR VPWR sky130_fd_sc_hd__decap_3
XFILLER_99_548 VGND VGND VPWR VPWR sky130_fd_sc_hd__decap_3
XFILLER_4_493 VGND VGND VPWR VPWR sky130_fd_sc_hd__fill_2
XFILLER_125_196 VGND VGND VPWR VPWR sky130_fd_sc_hd__decap_3
XFILLER_113_347 VGND VGND VPWR VPWR sky130_fd_sc_hd__decap_3
XFILLER_79_250 VGND VGND VPWR VPWR sky130_fd_sc_hd__fill_2
XFILLER_67_401 VGND VGND VPWR VPWR sky130_fd_sc_hd__decap_3
XPHY_EDGE_ROW_105_Left_236 VGND VGND VPWR VPWR sky130_fd_sc_hd__decap_3
XFILLER_67_434 VGND VGND VPWR VPWR sky130_fd_sc_hd__decap_3
XFILLER_67_445 VGND VGND VPWR VPWR sky130_fd_sc_hd__decap_3
XFILLER_94_253 VGND VGND VPWR VPWR sky130_fd_sc_hd__decap_3
XFILLER_39_169 VGND VGND VPWR VPWR sky130_fd_sc_hd__decap_3
X_7950_ _8066_/A _8410_/S VGND VGND VPWR VPWR _7954_/A sky130_fd_sc_hd__nor2_2
X_6901_ _6894_/A _7150_/B _7148_/B _6900_/X VGND VGND VPWR VPWR _6901_/X sky130_fd_sc_hd__o2bb2a_2
X_7881_ _8011_/B _8011_/C _7881_/C VGND VGND VPWR VPWR _7881_/X sky130_fd_sc_hd__or3_2
XFILLER_63_651 VGND VGND VPWR VPWR sky130_fd_sc_hd__decap_3
XFILLER_63_673 VGND VGND VPWR VPWR sky130_fd_sc_hd__decap_3
X_6832_ _6865_/A _6832_/B VGND VGND VPWR VPWR _6833_/B sky130_fd_sc_hd__xnor2_2
XFILLER_62_150 VGND VGND VPWR VPWR sky130_fd_sc_hd__decap_3
XFILLER_90_470 VGND VGND VPWR VPWR sky130_fd_sc_hd__fill_2
XFILLER_35_375 VGND VGND VPWR VPWR sky130_fd_sc_hd__decap_3
XFILLER_62_183 VGND VGND VPWR VPWR sky130_fd_sc_hd__decap_3
XFILLER_23_548 VGND VGND VPWR VPWR sky130_fd_sc_hd__decap_3
X_6763_ _6929_/A _6929_/B VGND VGND VPWR VPWR _8406_/A sky130_fd_sc_hd__nand2_4
XPHY_EDGE_ROW_114_Left_245 VGND VGND VPWR VPWR sky130_fd_sc_hd__decap_3
X_8502_ _8502_/A _8502_/B VGND VGND VPWR VPWR _8503_/B sky130_fd_sc_hd__xnor2_2
X_5714_ _5850_/A _7071_/B _8309_/A VGND VGND VPWR VPWR _5714_/Y sky130_fd_sc_hd__a21oi_2
X_6694_ _6695_/A _6695_/B _6695_/C _6695_/D VGND VGND VPWR VPWR _6694_/X sky130_fd_sc_hd__a22o_4
XFILLER_50_389 VGND VGND VPWR VPWR sky130_fd_sc_hd__decap_3
XTAP_TAPCELL_ROW_98_1604 VGND VPWR sky130_fd_sc_hd__tapvpwrvgnd_1
XFILLER_31_592 VGND VGND VPWR VPWR sky130_fd_sc_hd__decap_3
X_8433_ _8433_/A _8433_/B VGND VGND VPWR VPWR _8434_/B sky130_fd_sc_hd__xnor2_2
X_5645_ _5495_/A _5495_/B _5495_/C _5492_/X VGND VGND VPWR VPWR _5645_/X sky130_fd_sc_hd__o31a_2
XFILLER_40_29 VGND VGND VPWR VPWR sky130_fd_sc_hd__fill_2
X_5576_ _5576_/A _5576_/B VGND VGND VPWR VPWR _5760_/A sky130_fd_sc_hd__nand2_2
X_8364_ _8441_/B _8364_/B _8367_/B VGND VGND VPWR VPWR _8364_/X sky130_fd_sc_hd__or3_2
XFILLER_117_642 VGND VGND VPWR VPWR sky130_fd_sc_hd__decap_3
X_4527_ _8990_/A VGND VGND VPWR VPWR _4544_/S sky130_fd_sc_hd__clkbuf_2
X_7315_ _7312_/X _7314_/X _7099_/B VGND VGND VPWR VPWR _7315_/X sky130_fd_sc_hd__a21o_2
XFILLER_116_141 VGND VGND VPWR VPWR sky130_fd_sc_hd__decap_3
X_8295_ _8190_/B _8190_/A _8295_/S VGND VGND VPWR VPWR _8295_/X sky130_fd_sc_hd__mux2_2
X_7246_ _7245_/X _7244_/Y _7728_/A VGND VGND VPWR VPWR _7246_/X sky130_fd_sc_hd__a21o_2
XPHY_EDGE_ROW_123_Left_254 VGND VGND VPWR VPWR sky130_fd_sc_hd__decap_3
XFILLER_77_209 VGND VGND VPWR VPWR sky130_fd_sc_hd__decap_3
X_7177_ _7682_/A _7679_/B VGND VGND VPWR VPWR _7184_/A sky130_fd_sc_hd__xnor2_2
XFILLER_58_401 VGND VGND VPWR VPWR sky130_fd_sc_hd__decap_3
X_6128_ _5960_/A _5960_/B _6127_/X VGND VGND VPWR VPWR _6136_/A sky130_fd_sc_hd__o21ai_2
XFILLER_100_531 VGND VGND VPWR VPWR sky130_fd_sc_hd__fill_1
XFILLER_85_220 VGND VGND VPWR VPWR sky130_fd_sc_hd__decap_3
XFILLER_86_754 VGND VGND VPWR VPWR sky130_fd_sc_hd__fill_2
XFILLER_86_776 VGND VGND VPWR VPWR sky130_fd_sc_hd__fill_1
XFILLER_65_15 VGND VGND VPWR VPWR sky130_fd_sc_hd__fill_2
XFILLER_100_564 VGND VGND VPWR VPWR sky130_fd_sc_hd__decap_3
XFILLER_18_309 VGND VGND VPWR VPWR sky130_fd_sc_hd__decap_3
X_6059_ _6151_/B _6054_/X _6058_/X VGND VGND VPWR VPWR _6060_/B sky130_fd_sc_hd__o21ba_2
XFILLER_46_629 VGND VGND VPWR VPWR sky130_fd_sc_hd__decap_3
XFILLER_105_88 VGND VGND VPWR VPWR sky130_fd_sc_hd__decap_3
XTAP_TAPCELL_ROW_107_1722 VGND VPWR sky130_fd_sc_hd__tapvpwrvgnd_1
XFILLER_121_21 VGND VGND VPWR VPWR sky130_fd_sc_hd__decap_3
XFILLER_26_353 VGND VGND VPWR VPWR sky130_fd_sc_hd__fill_2
XFILLER_54_673 VGND VGND VPWR VPWR sky130_fd_sc_hd__decap_3
XFILLER_41_301 VGND VGND VPWR VPWR sky130_fd_sc_hd__decap_3
XFILLER_121_54 VGND VGND VPWR VPWR sky130_fd_sc_hd__fill_2
XTAP_TAPCELL_ROW_120_1900 VGND VPWR sky130_fd_sc_hd__tapvpwrvgnd_1
XFILLER_26_386 VGND VGND VPWR VPWR sky130_fd_sc_hd__decap_3
XFILLER_81_492 VGND VGND VPWR VPWR sky130_fd_sc_hd__decap_3
XFILLER_14_548 VGND VGND VPWR VPWR sky130_fd_sc_hd__decap_3
XFILLER_121_87 VGND VGND VPWR VPWR sky130_fd_sc_hd__decap_3
XFILLER_41_334 VGND VGND VPWR VPWR sky130_fd_sc_hd__fill_2
XFILLER_14_52 VGND VGND VPWR VPWR sky130_fd_sc_hd__decap_3
XFILLER_10_710 VGND VGND VPWR VPWR sky130_fd_sc_hd__decap_3
XFILLER_22_592 VGND VGND VPWR VPWR sky130_fd_sc_hd__fill_1
XFILLER_14_85 VGND VGND VPWR VPWR sky130_fd_sc_hd__decap_3
XFILLER_10_743 VGND VGND VPWR VPWR sky130_fd_sc_hd__decap_3
XFILLER_6_725 VGND VGND VPWR VPWR sky130_fd_sc_hd__decap_3
XFILLER_5_202 VGND VGND VPWR VPWR sky130_fd_sc_hd__decap_3
XTAP_TAPCELL_ROW_118_1873 VGND VPWR sky130_fd_sc_hd__tapvpwrvgnd_1
XFILLER_6_769 VGND VGND VPWR VPWR sky130_fd_sc_hd__decap_3
XFILLER_5_246 VGND VGND VPWR VPWR sky130_fd_sc_hd__decap_3
XFILLER_107_141 VGND VGND VPWR VPWR sky130_fd_sc_hd__fill_2
XFILLER_123_612 VGND VGND VPWR VPWR sky130_fd_sc_hd__decap_3
XFILLER_122_100 VGND VGND VPWR VPWR sky130_fd_sc_hd__decap_3
XFILLER_122_133 VGND VGND VPWR VPWR sky130_fd_sc_hd__decap_3
XFILLER_123_667 VGND VGND VPWR VPWR sky130_fd_sc_hd__decap_3
XFILLER_122_144 VGND VGND VPWR VPWR sky130_fd_sc_hd__decap_3
XFILLER_1_463 VGND VGND VPWR VPWR sky130_fd_sc_hd__decap_3
XFILLER_77_721 VGND VGND VPWR VPWR sky130_fd_sc_hd__decap_3
XFILLER_122_177 VGND VGND VPWR VPWR sky130_fd_sc_hd__decap_3
XFILLER_89_592 VGND VGND VPWR VPWR sky130_fd_sc_hd__fill_2
XFILLER_77_732 VGND VGND VPWR VPWR sky130_fd_sc_hd__decap_3
XFILLER_39_60 VGND VGND VPWR VPWR sky130_fd_sc_hd__decap_3
XFILLER_77_754 VGND VGND VPWR VPWR sky130_fd_sc_hd__decap_3
XFILLER_39_93 VGND VGND VPWR VPWR sky130_fd_sc_hd__decap_3
XFILLER_49_478 VGND VGND VPWR VPWR sky130_fd_sc_hd__decap_3
XTAP_TAPCELL_ROW_69_1216 VGND VPWR sky130_fd_sc_hd__tapvpwrvgnd_1
XFILLER_91_223 VGND VGND VPWR VPWR sky130_fd_sc_hd__fill_1
XFILLER_76_297 VGND VGND VPWR VPWR sky130_fd_sc_hd__fill_1
XFILLER_92_757 VGND VGND VPWR VPWR sky130_fd_sc_hd__fill_1
XFILLER_29_180 VGND VGND VPWR VPWR sky130_fd_sc_hd__decap_3
XFILLER_45_640 VGND VGND VPWR VPWR sky130_fd_sc_hd__decap_3
XFILLER_45_673 VGND VGND VPWR VPWR sky130_fd_sc_hd__decap_3
XFILLER_60_610 VGND VGND VPWR VPWR sky130_fd_sc_hd__fill_1
XFILLER_72_470 VGND VGND VPWR VPWR sky130_fd_sc_hd__decap_3
XFILLER_45_695 VGND VGND VPWR VPWR sky130_fd_sc_hd__decap_3
XFILLER_44_183 VGND VGND VPWR VPWR sky130_fd_sc_hd__decap_3
XTAP_TAPCELL_ROW_43_863 VGND VPWR sky130_fd_sc_hd__tapvpwrvgnd_1
XFILLER_60_698 VGND VGND VPWR VPWR sky130_fd_sc_hd__fill_2
X_5430_ _6685_/A _5698_/A VGND VGND VPWR VPWR _5434_/A sky130_fd_sc_hd__nand2_2
XFILLER_118_439 VGND VGND VPWR VPWR sky130_fd_sc_hd__decap_3
XFILLER_65_3 VGND VGND VPWR VPWR sky130_fd_sc_hd__decap_3
X_5361_ _5361_/A1 _5348_/X _5351_/X _8175_/A VGND VGND VPWR VPWR _7573_/B sky130_fd_sc_hd__a211o_2
XTAP_TAPCELL_ROW_93_1534 VGND VPWR sky130_fd_sc_hd__tapvpwrvgnd_1
X_7100_ _7098_/A _7095_/A _7093_/Y _7098_/X _7099_/X VGND VGND VPWR VPWR _7100_/X
+ sky130_fd_sc_hd__o311a_2
X_8080_ _8080_/A _8080_/B VGND VGND VPWR VPWR _8080_/X sky130_fd_sc_hd__or2_2
X_5292_ _7445_/A VGND VGND VPWR VPWR _8137_/A sky130_fd_sc_hd__clkbuf_2
XFILLER_114_645 VGND VGND VPWR VPWR sky130_fd_sc_hd__decap_3
X_7031_ _7031_/A VGND VGND VPWR VPWR _7133_/A sky130_fd_sc_hd__inv_2
XFILLER_59_209 VGND VGND VPWR VPWR sky130_fd_sc_hd__decap_3
XFILLER_114_689 VGND VGND VPWR VPWR sky130_fd_sc_hd__decap_3
XFILLER_99_389 VGND VGND VPWR VPWR sky130_fd_sc_hd__decap_3
XFILLER_68_710 VGND VGND VPWR VPWR sky130_fd_sc_hd__decap_3
XFILLER_67_231 VGND VGND VPWR VPWR sky130_fd_sc_hd__fill_1
XFILLER_28_607 VGND VGND VPWR VPWR sky130_fd_sc_hd__decap_3
XFILLER_28_618 VGND VGND VPWR VPWR sky130_fd_sc_hd__decap_3
X_8982_ _9332_/Q hold856/X _8988_/S VGND VGND VPWR VPWR _8982_/X sky130_fd_sc_hd__mux2_2
X_7933_ _7775_/A _7762_/Y _8222_/A VGND VGND VPWR VPWR _7933_/Y sky130_fd_sc_hd__a21oi_2
XFILLER_42_109 VGND VGND VPWR VPWR sky130_fd_sc_hd__decap_3
X_7864_ _7736_/A _7735_/A _7735_/B VGND VGND VPWR VPWR _7864_/X sky130_fd_sc_hd__o21a_2
XFILLER_23_312 VGND VGND VPWR VPWR sky130_fd_sc_hd__decap_3
XFILLER_51_632 VGND VGND VPWR VPWR sky130_fd_sc_hd__decap_3
XFILLER_23_334 VGND VGND VPWR VPWR sky130_fd_sc_hd__fill_2
X_6815_ _6811_/Y _6812_/X _6814_/X _6420_/A VGND VGND VPWR VPWR _6815_/X sky130_fd_sc_hd__a22o_2
XFILLER_51_654 VGND VGND VPWR VPWR sky130_fd_sc_hd__decap_3
XFILLER_50_131 VGND VGND VPWR VPWR sky130_fd_sc_hd__decap_3
XFILLER_23_345 VGND VGND VPWR VPWR sky130_fd_sc_hd__decap_3
X_7795_ _5446_/B _8066_/B _7794_/Y _8777_/B VGND VGND VPWR VPWR _7795_/Y sky130_fd_sc_hd__o211ai_2
XFILLER_50_153 VGND VGND VPWR VPWR sky130_fd_sc_hd__decap_3
XTAP_TAPCELL_ROW_102_1652 VGND VPWR sky130_fd_sc_hd__tapvpwrvgnd_1
XFILLER_11_518 VGND VGND VPWR VPWR sky130_fd_sc_hd__decap_3
XTAP_TAPCELL_ROW_102_1663 VGND VPWR sky130_fd_sc_hd__tapvpwrvgnd_1
X_6746_ _6746_/A _6746_/B VGND VGND VPWR VPWR _6747_/B sky130_fd_sc_hd__or2_2
XFILLER_50_197 VGND VGND VPWR VPWR sky130_fd_sc_hd__decap_3
X_6677_ _6665_/A _6675_/Y _6676_/Y VGND VGND VPWR VPWR _6924_/A sky130_fd_sc_hd__a21o_4
XTAP_TAPCELL_ROW_21_568 VGND VPWR sky130_fd_sc_hd__tapvpwrvgnd_1
X_8416_ _8416_/A _8416_/B _8416_/C VGND VGND VPWR VPWR _8416_/Y sky130_fd_sc_hd__nand3_2
X_5628_ _5387_/B _5613_/Y _5617_/Y _5626_/Y _5627_/Y VGND VGND VPWR VPWR _5629_/A
+ sky130_fd_sc_hd__a41o_4
XFILLER_3_706 VGND VGND VPWR VPWR sky130_fd_sc_hd__decap_3
X_8347_ _8441_/B _8343_/X _8346_/X VGND VGND VPWR VPWR _8348_/B sky130_fd_sc_hd__a21o_2
X_5559_ _5559_/A _5559_/B VGND VGND VPWR VPWR _5559_/Y sky130_fd_sc_hd__nand2_2
XFILLER_117_472 VGND VGND VPWR VPWR sky130_fd_sc_hd__decap_3
XFILLER_104_122 VGND VGND VPWR VPWR sky130_fd_sc_hd__fill_1
X_8278_ _8283_/A _8283_/C VGND VGND VPWR VPWR _8278_/X sky130_fd_sc_hd__and2_2
XFILLER_116_21 VGND VGND VPWR VPWR sky130_fd_sc_hd__decap_3
XFILLER_116_32 VGND VGND VPWR VPWR sky130_fd_sc_hd__decap_3
X_7229_ _7229_/A _7229_/B VGND VGND VPWR VPWR _7715_/B sky130_fd_sc_hd__xnor2_2
XFILLER_59_721 VGND VGND VPWR VPWR sky130_fd_sc_hd__decap_3
XFILLER_116_65 VGND VGND VPWR VPWR sky130_fd_sc_hd__decap_3
XFILLER_59_732 VGND VGND VPWR VPWR sky130_fd_sc_hd__decap_3
XFILLER_19_607 VGND VGND VPWR VPWR sky130_fd_sc_hd__decap_3
XFILLER_100_350 VGND VGND VPWR VPWR sky130_fd_sc_hd__decap_3
XFILLER_74_713 VGND VGND VPWR VPWR sky130_fd_sc_hd__decap_3
XFILLER_86_573 VGND VGND VPWR VPWR sky130_fd_sc_hd__fill_2
XFILLER_19_629 VGND VGND VPWR VPWR sky130_fd_sc_hd__decap_3
XFILLER_73_201 VGND VGND VPWR VPWR sky130_fd_sc_hd__decap_3
XFILLER_18_106 VGND VGND VPWR VPWR sky130_fd_sc_hd__decap_3
XFILLER_86_595 VGND VGND VPWR VPWR sky130_fd_sc_hd__decap_3
XFILLER_73_223 VGND VGND VPWR VPWR sky130_fd_sc_hd__fill_1
XFILLER_74_757 VGND VGND VPWR VPWR sky130_fd_sc_hd__decap_3
XFILLER_92_24 VGND VGND VPWR VPWR sky130_fd_sc_hd__decap_3
XFILLER_73_256 VGND VGND VPWR VPWR sky130_fd_sc_hd__decap_3
XTAP_TAPCELL_ROW_29_668 VGND VPWR sky130_fd_sc_hd__tapvpwrvgnd_1
XTAP_TAPCELL_ROW_29_679 VGND VPWR sky130_fd_sc_hd__tapvpwrvgnd_1
XFILLER_73_278 VGND VGND VPWR VPWR sky130_fd_sc_hd__fill_2
XFILLER_27_673 VGND VGND VPWR VPWR sky130_fd_sc_hd__decap_3
XFILLER_26_150 VGND VGND VPWR VPWR sky130_fd_sc_hd__decap_3
XFILLER_54_470 VGND VGND VPWR VPWR sky130_fd_sc_hd__fill_2
XTAP_TAPCELL_ROW_1_293 VGND VPWR sky130_fd_sc_hd__tapvpwrvgnd_1
XFILLER_14_312 VGND VGND VPWR VPWR sky130_fd_sc_hd__decap_3
XFILLER_92_79 VGND VGND VPWR VPWR sky130_fd_sc_hd__fill_1
XTAP_TAPCELL_ROW_64_1146 VGND VPWR sky130_fd_sc_hd__tapvpwrvgnd_1
XFILLER_42_654 VGND VGND VPWR VPWR sky130_fd_sc_hd__fill_1
XFILLER_41_131 VGND VGND VPWR VPWR sky130_fd_sc_hd__decap_3
XTAP_TAPCELL_ROW_40_822 VGND VPWR sky130_fd_sc_hd__tapvpwrvgnd_1
XFILLER_128_704 VGND VGND VPWR VPWR sky130_fd_sc_hd__decap_3
XFILLER_128_737 VGND VGND VPWR VPWR sky130_fd_sc_hd__decap_3
XFILLER_127_214 VGND VGND VPWR VPWR sky130_fd_sc_hd__decap_3
XFILLER_127_225 VGND VGND VPWR VPWR sky130_fd_sc_hd__decap_3
XFILLER_6_533 VGND VGND VPWR VPWR sky130_fd_sc_hd__decap_3
XFILLER_10_584 VGND VGND VPWR VPWR sky130_fd_sc_hd__decap_3
XFILLER_6_555 VGND VGND VPWR VPWR sky130_fd_sc_hd__decap_3
XFILLER_108_472 VGND VGND VPWR VPWR sky130_fd_sc_hd__decap_3
XFILLER_123_431 VGND VGND VPWR VPWR sky130_fd_sc_hd__decap_3
XFILLER_123_464 VGND VGND VPWR VPWR sky130_fd_sc_hd__decap_3
XTAP_TAPCELL_ROW_75_1297 VGND VPWR sky130_fd_sc_hd__tapvpwrvgnd_1
XFILLER_2_772 VGND VGND VPWR VPWR sky130_fd_sc_hd__decap_3
XFILLER_111_626 VGND VGND VPWR VPWR sky130_fd_sc_hd__fill_1
XFILLER_111_637 VGND VGND VPWR VPWR sky130_fd_sc_hd__decap_3
XFILLER_111_659 VGND VGND VPWR VPWR sky130_fd_sc_hd__decap_3
XFILLER_2_44 VGND VGND VPWR VPWR sky130_fd_sc_hd__decap_3
XFILLER_37_404 VGND VGND VPWR VPWR sky130_fd_sc_hd__fill_1
XFILLER_2_77 VGND VGND VPWR VPWR sky130_fd_sc_hd__decap_3
XFILLER_2_88 VGND VGND VPWR VPWR sky130_fd_sc_hd__decap_3
XTAP_TAPCELL_ROW_48_933 VGND VPWR sky130_fd_sc_hd__tapvpwrvgnd_1
XFILLER_92_521 VGND VGND VPWR VPWR sky130_fd_sc_hd__decap_3
XFILLER_92_543 VGND VGND VPWR VPWR sky130_fd_sc_hd__decap_3
XFILLER_65_757 VGND VGND VPWR VPWR sky130_fd_sc_hd__decap_3
XFILLER_66_91 VGND VGND VPWR VPWR sky130_fd_sc_hd__decap_3
XFILLER_80_716 VGND VGND VPWR VPWR sky130_fd_sc_hd__decap_3
XFILLER_18_673 VGND VGND VPWR VPWR sky130_fd_sc_hd__decap_3
X_4930_ _6342_/B _4930_/B_N VGND VGND VPWR VPWR _5457_/B sky130_fd_sc_hd__nor2b_2
XFILLER_80_738 VGND VGND VPWR VPWR sky130_fd_sc_hd__fill_2
XFILLER_18_695 VGND VGND VPWR VPWR sky130_fd_sc_hd__decap_3
X_4861_ _9175_/Q hold898/X _4861_/S VGND VGND VPWR VPWR _4861_/X sky130_fd_sc_hd__mux2_2
X_6600_ _6301_/S _6296_/C _6297_/B VGND VGND VPWR VPWR _6600_/X sky130_fd_sc_hd__o21ba_2
XFILLER_60_473 VGND VGND VPWR VPWR sky130_fd_sc_hd__decap_3
X_4792_ hold864/X _4792_/A1 _4798_/S VGND VGND VPWR VPWR _4793_/A sky130_fd_sc_hd__mux2_2
X_7580_ _7434_/A _7579_/X _7433_/A VGND VGND VPWR VPWR _7580_/X sky130_fd_sc_hd__o21ba_2
XPHY_EDGE_ROW_120_Right_120 VGND VGND VPWR VPWR sky130_fd_sc_hd__decap_3
XFILLER_60_484 VGND VGND VPWR VPWR sky130_fd_sc_hd__decap_3
XFILLER_32_197 VGND VGND VPWR VPWR sky130_fd_sc_hd__decap_3
X_6531_ _6369_/A _6369_/B _6363_/C _6363_/B _6363_/A VGND VGND VPWR VPWR _6534_/A
+ sky130_fd_sc_hd__a221o_2
XFILLER_119_726 VGND VGND VPWR VPWR sky130_fd_sc_hd__fill_2
X_9250_ clkload4/A _9250_/D load_slew374/X VGND VGND VPWR VPWR _9250_/Q sky130_fd_sc_hd__dfrtp_2
XFILLER_119_759 VGND VGND VPWR VPWR sky130_fd_sc_hd__decap_3
X_6462_ _6462_/A VGND VGND VPWR VPWR _9209_/D sky130_fd_sc_hd__buf_1
XFILLER_9_393 VGND VGND VPWR VPWR sky130_fd_sc_hd__fill_2
XFILLER_118_247 VGND VGND VPWR VPWR sky130_fd_sc_hd__decap_3
XFILLER_106_409 VGND VGND VPWR VPWR sky130_fd_sc_hd__decap_3
X_8201_ _8196_/C _8271_/D _8198_/X _8566_/A _8200_/X VGND VGND VPWR VPWR _8201_/X
+ sky130_fd_sc_hd__o221a_2
X_5413_ _5411_/Y _5412_/Y _5194_/A VGND VGND VPWR VPWR _5413_/X sky130_fd_sc_hd__o21a_2
X_6393_ _6137_/A _6136_/B _6392_/X VGND VGND VPWR VPWR _6394_/A sky130_fd_sc_hd__o21a_2
X_9181_ _9189_/CLK _9181_/D fanout413/X VGND VGND VPWR VPWR _9181_/Q sky130_fd_sc_hd__dfrtp_2
X_5344_ _5344_/A _6685_/A VGND VGND VPWR VPWR _5346_/A sky130_fd_sc_hd__nand2_2
X_8132_ _8127_/X _8131_/X _8094_/B VGND VGND VPWR VPWR _8132_/X sky130_fd_sc_hd__a21bo_2
XFILLER_126_280 VGND VGND VPWR VPWR sky130_fd_sc_hd__decap_3
XFILLER_102_604 VGND VGND VPWR VPWR sky130_fd_sc_hd__decap_3
XFILLER_99_164 VGND VGND VPWR VPWR sky130_fd_sc_hd__fill_1
X_5275_ _5275_/A VGND VGND VPWR VPWR _7404_/B sky130_fd_sc_hd__buf_6
X_8063_ _8063_/A _8063_/B VGND VGND VPWR VPWR _8074_/A sky130_fd_sc_hd__xnor2_2
XFILLER_114_486 VGND VGND VPWR VPWR sky130_fd_sc_hd__decap_3
XFILLER_102_648 VGND VGND VPWR VPWR sky130_fd_sc_hd__decap_3
XFILLER_101_125 VGND VGND VPWR VPWR sky130_fd_sc_hd__fill_1
X_7014_ _7014_/A _7014_/B VGND VGND VPWR VPWR _7014_/Y sky130_fd_sc_hd__xnor2_4
XFILLER_101_147 VGND VGND VPWR VPWR sky130_fd_sc_hd__fill_1
XFILLER_68_562 VGND VGND VPWR VPWR sky130_fd_sc_hd__decap_3
XFILLER_56_735 VGND VGND VPWR VPWR sky130_fd_sc_hd__decap_3
XFILLER_110_681 VGND VGND VPWR VPWR sky130_fd_sc_hd__fill_1
XFILLER_56_757 VGND VGND VPWR VPWR sky130_fd_sc_hd__decap_3
XFILLER_83_554 VGND VGND VPWR VPWR sky130_fd_sc_hd__decap_3
XFILLER_28_459 VGND VGND VPWR VPWR sky130_fd_sc_hd__decap_3
X_8965_ _8999_/A1 _8965_/A1 _8967_/S VGND VGND VPWR VPWR _8966_/A sky130_fd_sc_hd__mux2_2
XFILLER_102_12 VGND VGND VPWR VPWR sky130_fd_sc_hd__decap_3
XFILLER_43_407 VGND VGND VPWR VPWR sky130_fd_sc_hd__decap_3
XFILLER_83_587 VGND VGND VPWR VPWR sky130_fd_sc_hd__decap_3
XFILLER_71_727 VGND VGND VPWR VPWR sky130_fd_sc_hd__fill_1
X_7916_ _7924_/A _7916_/B VGND VGND VPWR VPWR _7916_/Y sky130_fd_sc_hd__nor2_2
XTAP_TAPCELL_ROW_26_627 VGND VPWR sky130_fd_sc_hd__tapvpwrvgnd_1
X_8896_ _8930_/A1 _9275_/Q _8904_/S VGND VGND VPWR VPWR _8896_/X sky130_fd_sc_hd__mux2_2
XTAP_TAPCELL_ROW_26_638 VGND VPWR sky130_fd_sc_hd__tapvpwrvgnd_1
X_7847_ _7847_/A _7847_/B VGND VGND VPWR VPWR _7899_/B sky130_fd_sc_hd__xnor2_2
XFILLER_62_27 VGND VGND VPWR VPWR sky130_fd_sc_hd__fill_1
XFILLER_51_440 VGND VGND VPWR VPWR sky130_fd_sc_hd__decap_3
XFILLER_24_654 VGND VGND VPWR VPWR sky130_fd_sc_hd__decap_3
XFILLER_62_38 VGND VGND VPWR VPWR sky130_fd_sc_hd__decap_3
XFILLER_24_665 VGND VGND VPWR VPWR sky130_fd_sc_hd__decap_3
XFILLER_11_315 VGND VGND VPWR VPWR sky130_fd_sc_hd__decap_3
X_7778_ _8170_/A wire88/A VGND VGND VPWR VPWR _7782_/A sky130_fd_sc_hd__nand2_2
XFILLER_11_337 VGND VGND VPWR VPWR sky130_fd_sc_hd__decap_3
X_6729_ _6730_/A _6730_/C _6730_/B VGND VGND VPWR VPWR _6732_/C sky130_fd_sc_hd__a21oi_2
Xwire228 wire228/A VGND VGND VPWR VPWR result_out[15] sky130_fd_sc_hd__buf_4
XFILLER_109_214 VGND VGND VPWR VPWR sky130_fd_sc_hd__decap_3
XFILLER_109_258 VGND VGND VPWR VPWR sky130_fd_sc_hd__decap_3
XFILLER_125_707 VGND VGND VPWR VPWR sky130_fd_sc_hd__decap_3
XFILLER_125_729 VGND VGND VPWR VPWR sky130_fd_sc_hd__decap_3
XFILLER_124_206 VGND VGND VPWR VPWR sky130_fd_sc_hd__decap_3
XFILLER_11_42 VGND VGND VPWR VPWR sky130_fd_sc_hd__decap_3
XTAP_TAPCELL_ROW_115_1832 VGND VPWR sky130_fd_sc_hd__tapvpwrvgnd_1
XFILLER_124_239 VGND VGND VPWR VPWR sky130_fd_sc_hd__decap_3
XFILLER_127_42 VGND VGND VPWR VPWR sky130_fd_sc_hd__decap_3
XFILLER_11_75 VGND VGND VPWR VPWR sky130_fd_sc_hd__decap_3
XFILLER_105_442 VGND VGND VPWR VPWR sky130_fd_sc_hd__decap_3
XFILLER_3_569 VGND VGND VPWR VPWR sky130_fd_sc_hd__decap_3
XFILLER_127_75 VGND VGND VPWR VPWR sky130_fd_sc_hd__decap_3
XFILLER_105_453 VGND VGND VPWR VPWR sky130_fd_sc_hd__decap_3
XFILLER_78_304 VGND VGND VPWR VPWR sky130_fd_sc_hd__decap_3
XFILLER_78_337 VGND VGND VPWR VPWR sky130_fd_sc_hd__fill_1
Xfanout350 _5674_/A VGND VGND VPWR VPWR fanout350/X sky130_fd_sc_hd__clkbuf_2
XFILLER_59_540 VGND VGND VPWR VPWR sky130_fd_sc_hd__decap_3
XTAP_TAPCELL_ROW_6_363 VGND VPWR sky130_fd_sc_hd__tapvpwrvgnd_1
XFILLER_47_702 VGND VGND VPWR VPWR sky130_fd_sc_hd__decap_3
Xfanout383 fanout385/X VGND VGND VPWR VPWR fanout383/X sky130_fd_sc_hd__clkdlybuf4s25_1
XFILLER_59_573 VGND VGND VPWR VPWR sky130_fd_sc_hd__decap_3
XFILLER_47_724 VGND VGND VPWR VPWR sky130_fd_sc_hd__decap_3
XFILLER_46_256 VGND VGND VPWR VPWR sky130_fd_sc_hd__decap_3
XFILLER_36_50 VGND VGND VPWR VPWR sky130_fd_sc_hd__decap_3
XFILLER_74_598 VGND VGND VPWR VPWR sky130_fd_sc_hd__decap_3
XTAP_TAPCELL_ROW_126_1983 VGND VPWR sky130_fd_sc_hd__tapvpwrvgnd_1
XFILLER_62_749 VGND VGND VPWR VPWR sky130_fd_sc_hd__decap_3
XFILLER_36_83 VGND VGND VPWR VPWR sky130_fd_sc_hd__fill_1
XFILLER_36_94 VGND VGND VPWR VPWR sky130_fd_sc_hd__decap_3
XFILLER_42_440 VGND VGND VPWR VPWR sky130_fd_sc_hd__decap_3
XFILLER_70_760 VGND VGND VPWR VPWR sky130_fd_sc_hd__decap_3
XFILLER_15_676 VGND VGND VPWR VPWR sky130_fd_sc_hd__fill_1
XFILLER_99_9 VGND VGND VPWR VPWR sky130_fd_sc_hd__decap_3
XFILLER_70_771 VGND VGND VPWR VPWR sky130_fd_sc_hd__decap_3
XFILLER_14_153 VGND VGND VPWR VPWR sky130_fd_sc_hd__fill_1
XFILLER_42_473 VGND VGND VPWR VPWR sky130_fd_sc_hd__decap_3
XFILLER_30_613 VGND VGND VPWR VPWR sky130_fd_sc_hd__decap_3
XTAP_TAPCELL_ROW_53_991 VGND VPWR sky130_fd_sc_hd__tapvpwrvgnd_1
XFILLER_52_82 VGND VGND VPWR VPWR sky130_fd_sc_hd__fill_2
Xinput14 sample_in[6] VGND VGND VPWR VPWR _6426_/A sky130_fd_sc_hd__buf_2
XTAP_TAPCELL_ROW_77_1315 VGND VPWR sky130_fd_sc_hd__tapvpwrvgnd_1
XFILLER_128_567 VGND VGND VPWR VPWR sky130_fd_sc_hd__decap_3
XTAP_TAPCELL_ROW_77_1326 VGND VPWR sky130_fd_sc_hd__tapvpwrvgnd_1
Xhold809 _9212_/Q VGND VGND VPWR VPWR hold809/X sky130_fd_sc_hd__dlygate4sd3_1
XFILLER_128_589 VGND VGND VPWR VPWR sky130_fd_sc_hd__decap_3
XFILLER_116_729 VGND VGND VPWR VPWR sky130_fd_sc_hd__fill_2
XFILLER_115_228 VGND VGND VPWR VPWR sky130_fd_sc_hd__decap_3
XFILLER_124_740 VGND VGND VPWR VPWR sky130_fd_sc_hd__decap_3
XFILLER_130_209 VGND VGND VPWR VPWR sky130_fd_sc_hd__decap_3
XFILLER_97_624 VGND VGND VPWR VPWR sky130_fd_sc_hd__fill_1
XFILLER_97_635 VGND VGND VPWR VPWR sky130_fd_sc_hd__decap_3
XFILLER_69_337 VGND VGND VPWR VPWR sky130_fd_sc_hd__decap_3
X_5060_ _9116_/Q wire172/X _5182_/B2 _5059_/X VGND VGND VPWR VPWR _5060_/X sky130_fd_sc_hd__a22o_2
XFILLER_97_679 VGND VGND VPWR VPWR sky130_fd_sc_hd__decap_3
XFILLER_28_3 VGND VGND VPWR VPWR sky130_fd_sc_hd__decap_3
XFILLER_111_467 VGND VGND VPWR VPWR sky130_fd_sc_hd__decap_3
XFILLER_77_90 VGND VGND VPWR VPWR sky130_fd_sc_hd__fill_1
XFILLER_111_489 VGND VGND VPWR VPWR sky130_fd_sc_hd__decap_3
XFILLER_37_212 VGND VGND VPWR VPWR sky130_fd_sc_hd__decap_3
XFILLER_38_746 VGND VGND VPWR VPWR sky130_fd_sc_hd__decap_3
XFILLER_65_532 VGND VGND VPWR VPWR sky130_fd_sc_hd__decap_3
XFILLER_38_757 VGND VGND VPWR VPWR sky130_fd_sc_hd__decap_3
XFILLER_65_543 VGND VGND VPWR VPWR sky130_fd_sc_hd__decap_3
XTAP_TAPCELL_ROW_88_1466 VGND VPWR sky130_fd_sc_hd__tapvpwrvgnd_1
XFILLER_53_727 VGND VGND VPWR VPWR sky130_fd_sc_hd__fill_1
X_8750_ _9230_/Q _8739_/B _8655_/B _8749_/X _9229_/Q VGND VGND VPWR VPWR _8750_/X
+ sky130_fd_sc_hd__a32o_2
X_5962_ _5962_/A _5962_/B VGND VGND VPWR VPWR _5963_/B sky130_fd_sc_hd__xor2_2
XFILLER_52_237 VGND VGND VPWR VPWR sky130_fd_sc_hd__decap_3
X_7701_ _7702_/A _7702_/B VGND VGND VPWR VPWR _7740_/A sky130_fd_sc_hd__nand2_2
X_4913_ _6206_/A _5446_/A VGND VGND VPWR VPWR _4916_/B sky130_fd_sc_hd__nand2_2
X_8681_ _8681_/A _8715_/A VGND VGND VPWR VPWR _8718_/A sky130_fd_sc_hd__nor2_2
XFILLER_80_579 VGND VGND VPWR VPWR sky130_fd_sc_hd__decap_3
XFILLER_33_440 VGND VGND VPWR VPWR sky130_fd_sc_hd__decap_3
X_5893_ _9205_/Q _5893_/B _6177_/B VGND VGND VPWR VPWR _5895_/B sky130_fd_sc_hd__and3_2
X_7632_ _7836_/C _7632_/B VGND VGND VPWR VPWR _7633_/A sky130_fd_sc_hd__xnor2_2
X_4844_ _4844_/A VGND VGND VPWR VPWR _9166_/D sky130_fd_sc_hd__buf_1
XFILLER_32_19 VGND VGND VPWR VPWR sky130_fd_sc_hd__decap_3
XFILLER_20_134 VGND VGND VPWR VPWR sky130_fd_sc_hd__decap_3
XFILLER_21_668 VGND VGND VPWR VPWR sky130_fd_sc_hd__decap_3
X_7563_ _7287_/Y _7564_/C _7393_/A VGND VGND VPWR VPWR _7563_/X sky130_fd_sc_hd__o21ba_2
XFILLER_21_679 VGND VGND VPWR VPWR sky130_fd_sc_hd__decap_3
X_4775_ hold843/X _4775_/A1 _4777_/S VGND VGND VPWR VPWR _4776_/A sky130_fd_sc_hd__mux2_2
XFILLER_20_156 VGND VGND VPWR VPWR sky130_fd_sc_hd__decap_3
XFILLER_119_512 VGND VGND VPWR VPWR sky130_fd_sc_hd__decap_3
X_9302_ _9334_/CLK _9302_/D fanout400/X VGND VGND VPWR VPWR _9302_/Q sky130_fd_sc_hd__dfrtp_2
X_6514_ _6514_/A _6514_/B _6524_/B _6385_/X VGND VGND VPWR VPWR _6514_/X sky130_fd_sc_hd__or4b_4
XFILLER_20_189 VGND VGND VPWR VPWR sky130_fd_sc_hd__decap_3
XFILLER_119_545 VGND VGND VPWR VPWR sky130_fd_sc_hd__decap_3
XTAP_TAPCELL_ROW_31_696 VGND VPWR sky130_fd_sc_hd__tapvpwrvgnd_1
XFILLER_107_707 VGND VGND VPWR VPWR sky130_fd_sc_hd__decap_3
X_7494_ _7491_/X _7494_/B VGND VGND VPWR VPWR _7495_/A sky130_fd_sc_hd__and2b_2
XFILLER_107_729 VGND VGND VPWR VPWR sky130_fd_sc_hd__decap_3
X_9233_ _9335_/CLK _9233_/D wire417/X VGND VGND VPWR VPWR _9233_/Q sky130_fd_sc_hd__dfrtp_2
X_6445_ _6125_/A _6125_/B _6444_/X VGND VGND VPWR VPWR _6455_/A sky130_fd_sc_hd__o21ai_2
XFILLER_106_228 VGND VGND VPWR VPWR sky130_fd_sc_hd__decap_3
X_9164_ clkload6/A _9164_/D load_slew376/X VGND VGND VPWR VPWR _9164_/Q sky130_fd_sc_hd__dfrtp_2
X_6376_ _6376_/A _6376_/B VGND VGND VPWR VPWR _6383_/B sky130_fd_sc_hd__and2_4
X_8115_ _7991_/A _7990_/A _7989_/Y VGND VGND VPWR VPWR _8116_/B sky130_fd_sc_hd__o21a_2
XFILLER_0_517 VGND VGND VPWR VPWR sky130_fd_sc_hd__decap_3
X_5327_ _6436_/B _6441_/A1 _5228_/Y _5326_/X _6083_/B VGND VGND VPWR VPWR _5330_/A
+ sky130_fd_sc_hd__o2111a_2
XFILLER_130_710 VGND VGND VPWR VPWR sky130_fd_sc_hd__decap_3
X_9095_ _9159_/CLK _9095_/D load_slew390/X VGND VGND VPWR VPWR _9095_/Q sky130_fd_sc_hd__dfrtp_2
XFILLER_0_539 VGND VGND VPWR VPWR sky130_fd_sc_hd__decap_3
XFILLER_130_732 VGND VGND VPWR VPWR sky130_fd_sc_hd__decap_3
XFILLER_114_283 VGND VGND VPWR VPWR sky130_fd_sc_hd__decap_3
X_8046_ _8233_/B2 _8047_/S _7949_/A VGND VGND VPWR VPWR _8046_/X sky130_fd_sc_hd__a21o_2
X_5258_ _9259_/Q _9055_/Q _5266_/S VGND VGND VPWR VPWR _5258_/X sky130_fd_sc_hd__mux2_2
XFILLER_88_679 VGND VGND VPWR VPWR sky130_fd_sc_hd__decap_3
XFILLER_57_27 VGND VGND VPWR VPWR sky130_fd_sc_hd__decap_3
XFILLER_102_467 VGND VGND VPWR VPWR sky130_fd_sc_hd__decap_3
XTAP_TAPCELL_ROW_110_1762 VGND VPWR sky130_fd_sc_hd__tapvpwrvgnd_1
XTAP_TAPCELL_ROW_110_1773 VGND VPWR sky130_fd_sc_hd__tapvpwrvgnd_1
XFILLER_87_167 VGND VGND VPWR VPWR sky130_fd_sc_hd__fill_1
XFILLER_87_178 VGND VGND VPWR VPWR sky130_fd_sc_hd__decap_3
XFILLER_102_489 VGND VGND VPWR VPWR sky130_fd_sc_hd__fill_1
XTAP_TAPCELL_ROW_3_322 VGND VPWR sky130_fd_sc_hd__tapvpwrvgnd_1
XFILLER_29_724 VGND VGND VPWR VPWR sky130_fd_sc_hd__decap_3
X_5189_ _9054_/Q _5457_/A _5875_/B VGND VGND VPWR VPWR _5189_/X sky130_fd_sc_hd__and3_2
XFILLER_29_735 VGND VGND VPWR VPWR sky130_fd_sc_hd__decap_3
XFILLER_29_757 VGND VGND VPWR VPWR sky130_fd_sc_hd__decap_3
XFILLER_28_245 VGND VGND VPWR VPWR sky130_fd_sc_hd__decap_3
XFILLER_113_33 VGND VGND VPWR VPWR sky130_fd_sc_hd__decap_3
XFILLER_28_256 VGND VGND VPWR VPWR sky130_fd_sc_hd__decap_3
XFILLER_71_502 VGND VGND VPWR VPWR sky130_fd_sc_hd__fill_2
XFILLER_28_267 VGND VGND VPWR VPWR sky130_fd_sc_hd__decap_3
XFILLER_113_66 VGND VGND VPWR VPWR sky130_fd_sc_hd__decap_3
XFILLER_16_418 VGND VGND VPWR VPWR sky130_fd_sc_hd__fill_2
XFILLER_56_598 VGND VGND VPWR VPWR sky130_fd_sc_hd__decap_3
X_8948_ _8969_/A VGND VGND VPWR VPWR _8967_/S sky130_fd_sc_hd__clkbuf_2
Xwire71 wire71/A VGND VGND VPWR VPWR wire71/X sky130_fd_sc_hd__clkbuf_4
XFILLER_43_259 VGND VGND VPWR VPWR sky130_fd_sc_hd__decap_3
X_8879_ _8913_/A1 _9267_/Q _8883_/S VGND VGND VPWR VPWR _8879_/X sky130_fd_sc_hd__mux2_2
XFILLER_71_579 VGND VGND VPWR VPWR sky130_fd_sc_hd__decap_3
XTAP_TAPCELL_ROW_61_1105 VGND VPWR sky130_fd_sc_hd__tapvpwrvgnd_1
XFILLER_51_281 VGND VGND VPWR VPWR sky130_fd_sc_hd__fill_2
XFILLER_12_635 VGND VGND VPWR VPWR sky130_fd_sc_hd__decap_3
XFILLER_8_606 VGND VGND VPWR VPWR sky130_fd_sc_hd__decap_3
XTAP_TAPCELL_ROW_50_950 VGND VPWR sky130_fd_sc_hd__tapvpwrvgnd_1
XTAP_TAPCELL_ROW_50_961 VGND VPWR sky130_fd_sc_hd__tapvpwrvgnd_1
XFILLER_7_116 VGND VGND VPWR VPWR sky130_fd_sc_hd__decap_3
XFILLER_11_167 VGND VGND VPWR VPWR sky130_fd_sc_hd__fill_1
XFILLER_7_138 VGND VGND VPWR VPWR sky130_fd_sc_hd__fill_1
XFILLER_22_52 VGND VGND VPWR VPWR sky130_fd_sc_hd__fill_2
XFILLER_22_85 VGND VGND VPWR VPWR sky130_fd_sc_hd__decap_3
XFILLER_125_559 VGND VGND VPWR VPWR sky130_fd_sc_hd__fill_1
XTAP_TAPCELL_ROW_59_1078 VGND VPWR sky130_fd_sc_hd__tapvpwrvgnd_1
XFILLER_3_333 VGND VGND VPWR VPWR sky130_fd_sc_hd__decap_3
XFILLER_105_250 VGND VGND VPWR VPWR sky130_fd_sc_hd__decap_3
XFILLER_79_635 VGND VGND VPWR VPWR sky130_fd_sc_hd__decap_3
XTAP_TAPCELL_ROW_72_1256 VGND VPWR sky130_fd_sc_hd__tapvpwrvgnd_1
XFILLER_3_399 VGND VGND VPWR VPWR sky130_fd_sc_hd__fill_2
XFILLER_121_732 VGND VGND VPWR VPWR sky130_fd_sc_hd__decap_3
XFILLER_79_668 VGND VGND VPWR VPWR sky130_fd_sc_hd__decap_3
XFILLER_121_765 VGND VGND VPWR VPWR sky130_fd_sc_hd__decap_3
XFILLER_78_156 VGND VGND VPWR VPWR sky130_fd_sc_hd__decap_3
XFILLER_94_616 VGND VGND VPWR VPWR sky130_fd_sc_hd__decap_3
XFILLER_120_253 VGND VGND VPWR VPWR sky130_fd_sc_hd__fill_2
XFILLER_78_178 VGND VGND VPWR VPWR sky130_fd_sc_hd__fill_1
XFILLER_66_318 VGND VGND VPWR VPWR sky130_fd_sc_hd__decap_3
XFILLER_59_381 VGND VGND VPWR VPWR sky130_fd_sc_hd__decap_3
XFILLER_47_521 VGND VGND VPWR VPWR sky130_fd_sc_hd__decap_3
XFILLER_14_9 VGND VGND VPWR VPWR sky130_fd_sc_hd__decap_3
XFILLER_47_60 VGND VGND VPWR VPWR sky130_fd_sc_hd__decap_3
XFILLER_47_543 VGND VGND VPWR VPWR sky130_fd_sc_hd__fill_1
XFILLER_93_159 VGND VGND VPWR VPWR sky130_fd_sc_hd__decap_3
XFILLER_47_554 VGND VGND VPWR VPWR sky130_fd_sc_hd__decap_3
XFILLER_74_351 VGND VGND VPWR VPWR sky130_fd_sc_hd__decap_3
XFILLER_62_502 VGND VGND VPWR VPWR sky130_fd_sc_hd__decap_3
XFILLER_47_576 VGND VGND VPWR VPWR sky130_fd_sc_hd__decap_3
XFILLER_62_524 VGND VGND VPWR VPWR sky130_fd_sc_hd__decap_3
XFILLER_62_557 VGND VGND VPWR VPWR sky130_fd_sc_hd__decap_3
XFILLER_50_708 VGND VGND VPWR VPWR sky130_fd_sc_hd__decap_3
XFILLER_34_259 VGND VGND VPWR VPWR sky130_fd_sc_hd__decap_3
XFILLER_15_473 VGND VGND VPWR VPWR sky130_fd_sc_hd__decap_3
XFILLER_97_6 VGND VGND VPWR VPWR sky130_fd_sc_hd__fill_1
XFILLER_63_81 VGND VGND VPWR VPWR sky130_fd_sc_hd__fill_1
XTAP_TAPCELL_ROW_83_1396 VGND VPWR sky130_fd_sc_hd__tapvpwrvgnd_1
XFILLER_15_495 VGND VGND VPWR VPWR sky130_fd_sc_hd__decap_3
XFILLER_8_21 VGND VGND VPWR VPWR sky130_fd_sc_hd__decap_3
XFILLER_30_443 VGND VGND VPWR VPWR sky130_fd_sc_hd__decap_3
XFILLER_8_32 VGND VGND VPWR VPWR sky130_fd_sc_hd__decap_3
XFILLER_8_65 VGND VGND VPWR VPWR sky130_fd_sc_hd__fill_1
XFILLER_128_320 VGND VGND VPWR VPWR sky130_fd_sc_hd__decap_3
X_4560_ hold972/X _4560_/A1 _4566_/S VGND VGND VPWR VPWR _4561_/A sky130_fd_sc_hd__mux2_2
XFILLER_11_690 VGND VGND VPWR VPWR sky130_fd_sc_hd__decap_3
XFILLER_8_98 VGND VGND VPWR VPWR sky130_fd_sc_hd__decap_3
XFILLER_128_386 VGND VGND VPWR VPWR sky130_fd_sc_hd__fill_2
XFILLER_116_526 VGND VGND VPWR VPWR sky130_fd_sc_hd__decap_3
XFILLER_7_683 VGND VGND VPWR VPWR sky130_fd_sc_hd__decap_3
X_6230_ _9346_/Q _5002_/X _5126_/X _9142_/Q _6229_/X VGND VGND VPWR VPWR _6230_/X
+ sky130_fd_sc_hd__a221o_2
XFILLER_116_559 VGND VGND VPWR VPWR sky130_fd_sc_hd__decap_3
X_6161_ wire76/X _6161_/B VGND VGND VPWR VPWR _6161_/Y sky130_fd_sc_hd__nand2_2
XFILLER_124_570 VGND VGND VPWR VPWR sky130_fd_sc_hd__decap_3
X_5112_ _9321_/Q _4992_/X _5259_/B1 _5111_/X VGND VGND VPWR VPWR _5123_/A sky130_fd_sc_hd__a22o_2
X_6092_ _4970_/X _6090_/X _6091_/X VGND VGND VPWR VPWR _6092_/X sky130_fd_sc_hd__a21bo_2
X_5043_ _9197_/Q _5043_/B VGND VGND VPWR VPWR _5044_/C sky130_fd_sc_hd__xnor2_2
XFILLER_111_275 VGND VGND VPWR VPWR sky130_fd_sc_hd__decap_3
XFILLER_65_340 VGND VGND VPWR VPWR sky130_fd_sc_hd__decap_3
XFILLER_26_716 VGND VGND VPWR VPWR sky130_fd_sc_hd__decap_3
X_8802_ _9246_/Q hold763/X _8812_/S VGND VGND VPWR VPWR _8802_/X sky130_fd_sc_hd__mux2_2
XFILLER_93_682 VGND VGND VPWR VPWR sky130_fd_sc_hd__decap_3
XFILLER_65_373 VGND VGND VPWR VPWR sky130_fd_sc_hd__decap_3
X_6994_ _7445_/A _7043_/B VGND VGND VPWR VPWR _6998_/A sky130_fd_sc_hd__nand2_2
X_8733_ _9229_/Q _8690_/Y _8758_/A VGND VGND VPWR VPWR _8734_/C sky130_fd_sc_hd__a21o_2
X_5945_ _6134_/B _5945_/B VGND VGND VPWR VPWR _5961_/B sky130_fd_sc_hd__xnor2_2
XTAP_TAPCELL_ROW_36_766 VGND VPWR sky130_fd_sc_hd__tapvpwrvgnd_1
XFILLER_80_365 VGND VGND VPWR VPWR sky130_fd_sc_hd__fill_1
XFILLER_34_760 VGND VGND VPWR VPWR sky130_fd_sc_hd__decap_3
XFILLER_80_376 VGND VGND VPWR VPWR sky130_fd_sc_hd__decap_3
X_8664_ _9226_/Q _8654_/X _8663_/X VGND VGND VPWR VPWR _8671_/A sky130_fd_sc_hd__o21ai_2
X_5876_ _9028_/Q _6336_/C _6604_/C VGND VGND VPWR VPWR _5876_/X sky130_fd_sc_hd__and3_2
XFILLER_21_432 VGND VGND VPWR VPWR sky130_fd_sc_hd__decap_3
XFILLER_21_443 VGND VGND VPWR VPWR sky130_fd_sc_hd__decap_3
X_7615_ _7590_/A _7413_/A _7764_/A VGND VGND VPWR VPWR _7617_/C sky130_fd_sc_hd__a21oi_2
X_4827_ _4827_/A VGND VGND VPWR VPWR _9158_/D sky130_fd_sc_hd__buf_1
X_8595_ _9225_/Q _8656_/A _8594_/Y _9226_/Q VGND VGND VPWR VPWR _8595_/X sky130_fd_sc_hd__o211a_2
XFILLER_21_465 VGND VGND VPWR VPWR sky130_fd_sc_hd__decap_3
XFILLER_21_498 VGND VGND VPWR VPWR sky130_fd_sc_hd__fill_2
X_7546_ _7545_/B _7689_/A VGND VGND VPWR VPWR _7547_/B sky130_fd_sc_hd__and2b_2
X_4758_ _4842_/A VGND VGND VPWR VPWR _4777_/S sky130_fd_sc_hd__clkbuf_2
X_7477_ _7836_/A _8083_/B VGND VGND VPWR VPWR _7478_/B sky130_fd_sc_hd__nand2_2
X_4689_ _4723_/A1 _4689_/A1 _4693_/S VGND VGND VPWR VPWR _4690_/A sky130_fd_sc_hd__mux2_2
X_9216_ _9219_/CLK _9216_/D fanout413/X VGND VGND VPWR VPWR _9216_/Q sky130_fd_sc_hd__dfrtp_2
X_6428_ _6428_/A1 _6120_/B _6427_/X _6116_/B VGND VGND VPWR VPWR _6500_/A sky130_fd_sc_hd__a22o_4
XFILLER_108_44 VGND VGND VPWR VPWR sky130_fd_sc_hd__decap_3
XFILLER_122_507 VGND VGND VPWR VPWR sky130_fd_sc_hd__decap_3
XFILLER_122_529 VGND VGND VPWR VPWR sky130_fd_sc_hd__decap_3
X_9147_ _9236_/CLK _9147_/D fanout398/X VGND VGND VPWR VPWR _9147_/Q sky130_fd_sc_hd__dfrtp_2
X_6359_ _9207_/Q _8315_/A _6356_/X _6357_/Y _6358_/X VGND VGND VPWR VPWR _6359_/X
+ sky130_fd_sc_hd__a32o_2
XFILLER_0_325 VGND VGND VPWR VPWR sky130_fd_sc_hd__decap_3
XFILLER_115_592 VGND VGND VPWR VPWR sky130_fd_sc_hd__decap_3
XTAP_TAPCELL_ROW_128_2009 VGND VPWR sky130_fd_sc_hd__tapvpwrvgnd_1
X_9078_ _9142_/CLK _9078_/D load_slew404/X VGND VGND VPWR VPWR _9078_/Q sky130_fd_sc_hd__dfrtp_2
XFILLER_130_551 VGND VGND VPWR VPWR sky130_fd_sc_hd__decap_3
XFILLER_124_21 VGND VGND VPWR VPWR sky130_fd_sc_hd__decap_3
XFILLER_76_627 VGND VGND VPWR VPWR sky130_fd_sc_hd__decap_3
XFILLER_130_573 VGND VGND VPWR VPWR sky130_fd_sc_hd__decap_3
XFILLER_124_32 VGND VGND VPWR VPWR sky130_fd_sc_hd__decap_3
X_8029_ _7668_/A _7534_/B _7670_/A _8028_/Y _5786_/Y VGND VGND VPWR VPWR _8029_/X
+ sky130_fd_sc_hd__o221a_2
XFILLER_130_595 VGND VGND VPWR VPWR sky130_fd_sc_hd__decap_3
XFILLER_124_65 VGND VGND VPWR VPWR sky130_fd_sc_hd__decap_3
XFILLER_75_137 VGND VGND VPWR VPWR sky130_fd_sc_hd__decap_3
XFILLER_56_362 VGND VGND VPWR VPWR sky130_fd_sc_hd__fill_2
XFILLER_17_716 VGND VGND VPWR VPWR sky130_fd_sc_hd__decap_3
XFILLER_90_118 VGND VGND VPWR VPWR sky130_fd_sc_hd__fill_1
XFILLER_17_30 VGND VGND VPWR VPWR sky130_fd_sc_hd__decap_3
XFILLER_44_524 VGND VGND VPWR VPWR sky130_fd_sc_hd__decap_3
XFILLER_17_738 VGND VGND VPWR VPWR sky130_fd_sc_hd__decap_3
XFILLER_16_226 VGND VGND VPWR VPWR sky130_fd_sc_hd__decap_3
XTAP_TAPCELL_ROW_123_1942 VGND VPWR sky130_fd_sc_hd__tapvpwrvgnd_1
XFILLER_16_259 VGND VGND VPWR VPWR sky130_fd_sc_hd__decap_3
XFILLER_44_579 VGND VGND VPWR VPWR sky130_fd_sc_hd__decap_3
XFILLER_31_207 VGND VGND VPWR VPWR sky130_fd_sc_hd__decap_3
XFILLER_25_771 VGND VGND VPWR VPWR sky130_fd_sc_hd__decap_3
XFILLER_129_128 VGND VGND VPWR VPWR sky130_fd_sc_hd__decap_3
XFILLER_4_642 VGND VGND VPWR VPWR sky130_fd_sc_hd__fill_2
XFILLER_99_719 VGND VGND VPWR VPWR sky130_fd_sc_hd__decap_3
XFILLER_4_664 VGND VGND VPWR VPWR sky130_fd_sc_hd__decap_3
XFILLER_106_581 VGND VGND VPWR VPWR sky130_fd_sc_hd__decap_3
XFILLER_4_697 VGND VGND VPWR VPWR sky130_fd_sc_hd__decap_3
XFILLER_121_540 VGND VGND VPWR VPWR sky130_fd_sc_hd__fill_2
XFILLER_121_551 VGND VGND VPWR VPWR sky130_fd_sc_hd__decap_3
XFILLER_39_318 VGND VGND VPWR VPWR sky130_fd_sc_hd__decap_3
XFILLER_79_498 VGND VGND VPWR VPWR sky130_fd_sc_hd__decap_3
XFILLER_58_70 VGND VGND VPWR VPWR sky130_fd_sc_hd__decap_3
XFILLER_12_6 VGND VGND VPWR VPWR sky130_fd_sc_hd__decap_3
XFILLER_82_608 VGND VGND VPWR VPWR sky130_fd_sc_hd__decap_3
XFILLER_47_351 VGND VGND VPWR VPWR sky130_fd_sc_hd__decap_3
XFILLER_35_513 VGND VGND VPWR VPWR sky130_fd_sc_hd__fill_1
XTAP_TAPCELL_ROW_85_1425 VGND VPWR sky130_fd_sc_hd__tapvpwrvgnd_1
XFILLER_75_693 VGND VGND VPWR VPWR sky130_fd_sc_hd__fill_1
XFILLER_47_384 VGND VGND VPWR VPWR sky130_fd_sc_hd__decap_3
XFILLER_90_630 VGND VGND VPWR VPWR sky130_fd_sc_hd__decap_3
XFILLER_62_321 VGND VGND VPWR VPWR sky130_fd_sc_hd__decap_3
XFILLER_62_343 VGND VGND VPWR VPWR sky130_fd_sc_hd__decap_3
XFILLER_90_674 VGND VGND VPWR VPWR sky130_fd_sc_hd__decap_3
XFILLER_62_365 VGND VGND VPWR VPWR sky130_fd_sc_hd__decap_3
XFILLER_35_579 VGND VGND VPWR VPWR sky130_fd_sc_hd__decap_3
XFILLER_23_719 VGND VGND VPWR VPWR sky130_fd_sc_hd__decap_3
XFILLER_16_760 VGND VGND VPWR VPWR sky130_fd_sc_hd__decap_3
XFILLER_50_516 VGND VGND VPWR VPWR sky130_fd_sc_hd__decap_3
XTAP_TAPCELL_ROW_33_725 VGND VPWR sky130_fd_sc_hd__tapvpwrvgnd_1
X_5730_ _5878_/B _6607_/B VGND VGND VPWR VPWR _5730_/X sky130_fd_sc_hd__and2_4
XFILLER_95_3 VGND VGND VPWR VPWR sky130_fd_sc_hd__decap_3
XFILLER_50_549 VGND VGND VPWR VPWR sky130_fd_sc_hd__decap_3
XFILLER_31_741 VGND VGND VPWR VPWR sky130_fd_sc_hd__decap_3
XFILLER_31_763 VGND VGND VPWR VPWR sky130_fd_sc_hd__decap_3
X_5661_ _5801_/B _5661_/B VGND VGND VPWR VPWR _5662_/A sky130_fd_sc_hd__xor2_2
XFILLER_30_251 VGND VGND VPWR VPWR sky130_fd_sc_hd__fill_1
XFILLER_30_262 VGND VGND VPWR VPWR sky130_fd_sc_hd__decap_3
X_7400_ _7369_/A _7369_/B _7399_/X VGND VGND VPWR VPWR _7492_/A sky130_fd_sc_hd__o21a_2
XTAP_TAPCELL_ROW_13_460 VGND VPWR sky130_fd_sc_hd__tapvpwrvgnd_1
X_4612_ _4612_/A VGND VGND VPWR VPWR _9056_/D sky130_fd_sc_hd__buf_1
X_8380_ _8378_/Y _8379_/X wire45/X VGND VGND VPWR VPWR _8380_/X sky130_fd_sc_hd__mux2_2
X_5592_ _5019_/X _5272_/X _6939_/A VGND VGND VPWR VPWR _5727_/A sky130_fd_sc_hd__a21o_2
XFILLER_30_295 VGND VGND VPWR VPWR sky130_fd_sc_hd__decap_3
XFILLER_129_662 VGND VGND VPWR VPWR sky130_fd_sc_hd__decap_3
XFILLER_129_673 VGND VGND VPWR VPWR sky130_fd_sc_hd__decap_3
XFILLER_128_150 VGND VGND VPWR VPWR sky130_fd_sc_hd__decap_3
X_7331_ _7332_/A _7332_/B _7443_/B VGND VGND VPWR VPWR _7333_/B sky130_fd_sc_hd__a21o_2
X_4543_ _4543_/A VGND VGND VPWR VPWR _9024_/D sky130_fd_sc_hd__buf_1
XFILLER_116_312 VGND VGND VPWR VPWR sky130_fd_sc_hd__decap_3
Xmax_cap111 _6705_/D VGND VGND VPWR VPWR _7095_/A sky130_fd_sc_hd__buf_4
XFILLER_128_183 VGND VGND VPWR VPWR sky130_fd_sc_hd__decap_3
XTAP_TAPCELL_ROW_96_1576 VGND VPWR sky130_fd_sc_hd__tapvpwrvgnd_1
Xmax_cap133 _8291_/S VGND VGND VPWR VPWR _7219_/S sky130_fd_sc_hd__buf_6
X_7262_ _7264_/B _7259_/A VGND VGND VPWR VPWR _7262_/X sky130_fd_sc_hd__or2b_2
XFILLER_104_518 VGND VGND VPWR VPWR sky130_fd_sc_hd__decap_3
X_9001_ _9001_/A0 _9001_/A1 _9009_/S VGND VGND VPWR VPWR _9002_/A sky130_fd_sc_hd__mux2_2
Xmax_cap166 _6762_/D VGND VGND VPWR VPWR _8443_/B sky130_fd_sc_hd__buf_2
XFILLER_89_218 VGND VGND VPWR VPWR sky130_fd_sc_hd__decap_3
XFILLER_104_529 VGND VGND VPWR VPWR sky130_fd_sc_hd__decap_3
X_6213_ _6366_/A _6366_/B VGND VGND VPWR VPWR _6215_/C sky130_fd_sc_hd__xor2_2
Xmax_cap177 _5273_/Y VGND VGND VPWR VPWR _6313_/B1 sky130_fd_sc_hd__buf_2
Xmax_cap188 _5442_/A VGND VGND VPWR VPWR _6607_/B sky130_fd_sc_hd__buf_4
X_7193_ _7193_/A _7193_/B VGND VGND VPWR VPWR _7194_/B sky130_fd_sc_hd__xnor2_2
Xmax_cap199 _6418_/B VGND VGND VPWR VPWR _7668_/B sky130_fd_sc_hd__buf_2
X_6144_ _6065_/A _6145_/B _6064_/A1 VGND VGND VPWR VPWR _6144_/X sky130_fd_sc_hd__a21bo_2
XFILLER_112_551 VGND VGND VPWR VPWR sky130_fd_sc_hd__decap_3
XFILLER_85_402 VGND VGND VPWR VPWR sky130_fd_sc_hd__decap_3
Xload_slew361 rebuffer655/A VGND VGND VPWR VPWR _6113_/A sky130_fd_sc_hd__buf_6
Xhold1103 _9069_/Q VGND VGND VPWR VPWR _4672_/A1 sky130_fd_sc_hd__dlygate4sd3_1
Xhold1114 _9333_/Q VGND VGND VPWR VPWR _4528_/A1 sky130_fd_sc_hd__dlygate4sd3_1
XFILLER_97_284 VGND VGND VPWR VPWR sky130_fd_sc_hd__decap_3
X_6075_ _7676_/C _6091_/A _7528_/B2 VGND VGND VPWR VPWR _6075_/X sky130_fd_sc_hd__a21o_2
XFILLER_85_435 VGND VGND VPWR VPWR sky130_fd_sc_hd__decap_3
XFILLER_112_595 VGND VGND VPWR VPWR sky130_fd_sc_hd__decap_3
Xhold1125 _9052_/Q VGND VGND VPWR VPWR _4636_/A1 sky130_fd_sc_hd__dlygate4sd3_1
XFILLER_100_757 VGND VGND VPWR VPWR sky130_fd_sc_hd__fill_1
Xload_slew394 fanout392/X VGND VGND VPWR VPWR load_slew394/X sky130_fd_sc_hd__buf_4
Xhold1136 _9326_/Q VGND VGND VPWR VPWR _9003_/A1 sky130_fd_sc_hd__dlygate4sd3_1
Xhold1147 _9274_/Q VGND VGND VPWR VPWR _8894_/A1 sky130_fd_sc_hd__dlygate4sd3_1
X_5026_ _6942_/A VGND VGND VPWR VPWR _6765_/A sky130_fd_sc_hd__clkbuf_2
Xhold1158 _9348_/Q VGND VGND VPWR VPWR _4560_/A1 sky130_fd_sc_hd__dlygate4sd3_1
Xhold1169 _9241_/Q VGND VGND VPWR VPWR _8825_/A1 sky130_fd_sc_hd__dlygate4sd3_1
XFILLER_81_652 VGND VGND VPWR VPWR sky130_fd_sc_hd__fill_1
XFILLER_53_343 VGND VGND VPWR VPWR sky130_fd_sc_hd__decap_3
XFILLER_41_505 VGND VGND VPWR VPWR sky130_fd_sc_hd__decap_3
XFILLER_14_719 VGND VGND VPWR VPWR sky130_fd_sc_hd__decap_3
X_6977_ _5146_/A _4975_/B _6976_/X _6954_/X _7099_/C VGND VGND VPWR VPWR _7034_/A
+ sky130_fd_sc_hd__o311a_2
XFILLER_13_207 VGND VGND VPWR VPWR sky130_fd_sc_hd__decap_3
XFILLER_110_12 VGND VGND VPWR VPWR sky130_fd_sc_hd__decap_3
X_8716_ _8737_/A _8716_/B _8721_/B VGND VGND VPWR VPWR _8716_/Y sky130_fd_sc_hd__nand3_2
XFILLER_41_538 VGND VGND VPWR VPWR sky130_fd_sc_hd__fill_1
X_5928_ _7174_/B VGND VGND VPWR VPWR _7195_/A sky130_fd_sc_hd__inv_2
XTAP_TAPCELL_ROW_105_1694 VGND VPWR sky130_fd_sc_hd__tapvpwrvgnd_1
XFILLER_22_752 VGND VGND VPWR VPWR sky130_fd_sc_hd__decap_3
XFILLER_22_763 VGND VGND VPWR VPWR sky130_fd_sc_hd__decap_3
X_8647_ _8516_/Y _8643_/X _8649_/C _8625_/Y _8678_/A VGND VGND VPWR VPWR _8647_/X
+ sky130_fd_sc_hd__a221o_2
XFILLER_70_27 VGND VGND VPWR VPWR sky130_fd_sc_hd__fill_1
X_5859_ wire62/X _5859_/B VGND VGND VPWR VPWR _5860_/B sky130_fd_sc_hd__xnor2_2
XFILLER_21_251 VGND VGND VPWR VPWR sky130_fd_sc_hd__fill_2
Xrebuffer500 _7093_/A VGND VGND VPWR VPWR _6210_/A sky130_fd_sc_hd__buf_2
Xrebuffer511 _6588_/A VGND VGND VPWR VPWR _6039_/A sky130_fd_sc_hd__buf_2
XFILLER_21_284 VGND VGND VPWR VPWR sky130_fd_sc_hd__fill_2
X_8578_ _8578_/A _8578_/B VGND VGND VPWR VPWR _8578_/Y sky130_fd_sc_hd__nand2_2
Xrebuffer522 _7564_/A VGND VGND VPWR VPWR _7566_/A1 sky130_fd_sc_hd__buf_2
XFILLER_21_295 VGND VGND VPWR VPWR sky130_fd_sc_hd__decap_3
Xrebuffer533 _5766_/A VGND VGND VPWR VPWR _5765_/A sky130_fd_sc_hd__buf_2
XFILLER_126_109 VGND VGND VPWR VPWR sky130_fd_sc_hd__decap_3
XFILLER_119_21 VGND VGND VPWR VPWR sky130_fd_sc_hd__decap_3
Xrebuffer544 _6288_/Y VGND VGND VPWR VPWR _6296_/A sky130_fd_sc_hd__buf_2
XFILLER_119_150 VGND VGND VPWR VPWR sky130_fd_sc_hd__decap_3
X_7529_ _6084_/A _7526_/X _7528_/X VGND VGND VPWR VPWR _7539_/A sky130_fd_sc_hd__o21ai_2
Xrebuffer555 _7564_/D VGND VGND VPWR VPWR _7288_/A1 sky130_fd_sc_hd__buf_2
Xrebuffer566 _7634_/Y VGND VGND VPWR VPWR _7648_/B sky130_fd_sc_hd__buf_4
XFILLER_119_54 VGND VGND VPWR VPWR sky130_fd_sc_hd__fill_2
XFILLER_119_172 VGND VGND VPWR VPWR sky130_fd_sc_hd__decap_3
Xrebuffer577 _4953_/A VGND VGND VPWR VPWR _5273_/B sky130_fd_sc_hd__buf_2
Xrebuffer588 _6174_/B VGND VGND VPWR VPWR _6013_/B sky130_fd_sc_hd__buf_2
Xrebuffer599 _7467_/A VGND VGND VPWR VPWR _7468_/A sky130_fd_sc_hd__buf_2
XFILLER_119_87 VGND VGND VPWR VPWR sky130_fd_sc_hd__decap_3
XTAP_TAPCELL_ROW_56_1037 VGND VPWR sky130_fd_sc_hd__tapvpwrvgnd_1
XFILLER_122_304 VGND VGND VPWR VPWR sky130_fd_sc_hd__decap_3
XFILLER_79_69 VGND VGND VPWR VPWR sky130_fd_sc_hd__decap_3
XFILLER_1_612 VGND VGND VPWR VPWR sky130_fd_sc_hd__decap_3
Xhold970 _9272_/Q VGND VGND VPWR VPWR hold970/X sky130_fd_sc_hd__dlygate4sd3_1
XFILLER_1_623 VGND VGND VPWR VPWR sky130_fd_sc_hd__decap_3
Xhold981 _9280_/Q VGND VGND VPWR VPWR hold981/X sky130_fd_sc_hd__dlygate4sd3_1
XFILLER_122_337 VGND VGND VPWR VPWR sky130_fd_sc_hd__decap_3
XFILLER_0_122 VGND VGND VPWR VPWR sky130_fd_sc_hd__decap_3
Xhold992 _8980_/X VGND VGND VPWR VPWR _8981_/A sky130_fd_sc_hd__dlygate4sd3_1
XFILLER_1_656 VGND VGND VPWR VPWR sky130_fd_sc_hd__decap_3
XFILLER_0_144 VGND VGND VPWR VPWR sky130_fd_sc_hd__decap_3
XFILLER_49_605 VGND VGND VPWR VPWR sky130_fd_sc_hd__fill_2
XFILLER_95_13 VGND VGND VPWR VPWR sky130_fd_sc_hd__decap_3
XFILLER_103_573 VGND VGND VPWR VPWR sky130_fd_sc_hd__decap_3
XFILLER_95_46 VGND VGND VPWR VPWR sky130_fd_sc_hd__fill_2
XFILLER_48_115 VGND VGND VPWR VPWR sky130_fd_sc_hd__decap_3
XFILLER_95_57 VGND VGND VPWR VPWR sky130_fd_sc_hd__fill_1
XFILLER_76_457 VGND VGND VPWR VPWR sky130_fd_sc_hd__decap_3
XFILLER_48_159 VGND VGND VPWR VPWR sky130_fd_sc_hd__fill_2
XFILLER_91_405 VGND VGND VPWR VPWR sky130_fd_sc_hd__decap_3
XFILLER_29_340 VGND VGND VPWR VPWR sky130_fd_sc_hd__decap_3
XFILLER_28_62 VGND VGND VPWR VPWR sky130_fd_sc_hd__decap_3
XFILLER_29_362 VGND VGND VPWR VPWR sky130_fd_sc_hd__decap_3
XFILLER_72_641 VGND VGND VPWR VPWR sky130_fd_sc_hd__decap_3
XFILLER_44_354 VGND VGND VPWR VPWR sky130_fd_sc_hd__decap_3
XFILLER_44_365 VGND VGND VPWR VPWR sky130_fd_sc_hd__decap_3
XFILLER_72_685 VGND VGND VPWR VPWR sky130_fd_sc_hd__decap_3
XFILLER_32_516 VGND VGND VPWR VPWR sky130_fd_sc_hd__decap_3
XTAP_TAPCELL_ROW_67_1188 VGND VPWR sky130_fd_sc_hd__tapvpwrvgnd_1
XFILLER_44_83 VGND VGND VPWR VPWR sky130_fd_sc_hd__fill_1
XFILLER_13_741 VGND VGND VPWR VPWR sky130_fd_sc_hd__decap_3
XTAP_TAPCELL_ROW_80_1355 VGND VPWR sky130_fd_sc_hd__tapvpwrvgnd_1
XFILLER_9_712 VGND VGND VPWR VPWR sky130_fd_sc_hd__decap_3
XTAP_TAPCELL_ROW_80_1366 VGND VPWR sky130_fd_sc_hd__tapvpwrvgnd_1
XFILLER_8_200 VGND VGND VPWR VPWR sky130_fd_sc_hd__decap_3
XFILLER_13_774 VGND VGND VPWR VPWR sky130_fd_sc_hd__decap_3
XFILLER_12_262 VGND VGND VPWR VPWR sky130_fd_sc_hd__decap_3
XFILLER_8_222 VGND VGND VPWR VPWR sky130_fd_sc_hd__decap_3
XFILLER_9_756 VGND VGND VPWR VPWR sky130_fd_sc_hd__decap_3
XFILLER_12_284 VGND VGND VPWR VPWR sky130_fd_sc_hd__decap_3
XFILLER_12_295 VGND VGND VPWR VPWR sky130_fd_sc_hd__decap_3
XFILLER_8_277 VGND VGND VPWR VPWR sky130_fd_sc_hd__decap_3
XFILLER_60_82 VGND VGND VPWR VPWR sky130_fd_sc_hd__fill_2
XFILLER_126_621 VGND VGND VPWR VPWR sky130_fd_sc_hd__decap_3
XFILLER_126_654 VGND VGND VPWR VPWR sky130_fd_sc_hd__decap_3
XFILLER_125_131 VGND VGND VPWR VPWR sky130_fd_sc_hd__decap_3
XFILLER_99_505 VGND VGND VPWR VPWR sky130_fd_sc_hd__decap_3
XFILLER_5_33 VGND VGND VPWR VPWR sky130_fd_sc_hd__decap_3
XFILLER_126_687 VGND VGND VPWR VPWR sky130_fd_sc_hd__decap_3
XFILLER_125_164 VGND VGND VPWR VPWR sky130_fd_sc_hd__decap_3
XFILLER_125_175 VGND VGND VPWR VPWR sky130_fd_sc_hd__decap_3
XFILLER_113_337 VGND VGND VPWR VPWR sky130_fd_sc_hd__fill_2
XFILLER_95_722 VGND VGND VPWR VPWR sky130_fd_sc_hd__decap_3
XFILLER_121_370 VGND VGND VPWR VPWR sky130_fd_sc_hd__fill_2
XFILLER_94_221 VGND VGND VPWR VPWR sky130_fd_sc_hd__decap_3
XFILLER_95_766 VGND VGND VPWR VPWR sky130_fd_sc_hd__fill_2
XFILLER_39_148 VGND VGND VPWR VPWR sky130_fd_sc_hd__decap_3
XFILLER_10_3 VGND VGND VPWR VPWR sky130_fd_sc_hd__decap_3
XFILLER_82_427 VGND VGND VPWR VPWR sky130_fd_sc_hd__decap_3
X_6900_ _6900_/A _6900_/B VGND VGND VPWR VPWR _6900_/X sky130_fd_sc_hd__or2_2
X_7880_ _8011_/B _8011_/C VGND VGND VPWR VPWR _7880_/Y sky130_fd_sc_hd__nand2_2
XFILLER_82_449 VGND VGND VPWR VPWR sky130_fd_sc_hd__decap_3
XTAP_TAPCELL_ROW_18_530 VGND VPWR sky130_fd_sc_hd__tapvpwrvgnd_1
X_6831_ _6880_/A _6880_/B VGND VGND VPWR VPWR _6832_/B sky130_fd_sc_hd__xnor2_2
XFILLER_23_505 VGND VGND VPWR VPWR sky130_fd_sc_hd__decap_3
XFILLER_35_387 VGND VGND VPWR VPWR sky130_fd_sc_hd__decap_3
XFILLER_23_527 VGND VGND VPWR VPWR sky130_fd_sc_hd__decap_3
X_6762_ _6755_/X _6759_/X _6762_/C _6762_/D VGND VGND VPWR VPWR _6929_/B sky130_fd_sc_hd__and4bb_2
XFILLER_62_195 VGND VGND VPWR VPWR sky130_fd_sc_hd__fill_1
X_8501_ _8547_/A _8501_/B VGND VGND VPWR VPWR _8502_/B sky130_fd_sc_hd__xnor2_2
XFILLER_50_357 VGND VGND VPWR VPWR sky130_fd_sc_hd__decap_3
X_5713_ _5713_/A _7952_/A VGND VGND VPWR VPWR _5713_/Y sky130_fd_sc_hd__nor2_2
XFILLER_50_368 VGND VGND VPWR VPWR sky130_fd_sc_hd__decap_3
X_6693_ _6692_/A _6692_/B _6556_/Y VGND VGND VPWR VPWR _6926_/B sky130_fd_sc_hd__a21o_2
XFILLER_31_571 VGND VGND VPWR VPWR sky130_fd_sc_hd__decap_3
XTAP_TAPCELL_ROW_98_1605 VGND VPWR sky130_fd_sc_hd__tapvpwrvgnd_1
X_8432_ _8432_/A _8467_/A VGND VGND VPWR VPWR _8433_/B sky130_fd_sc_hd__xor2_2
X_5644_ _5773_/B _5644_/B VGND VGND VPWR VPWR _5648_/B sky130_fd_sc_hd__xnor2_2
XFILLER_117_610 VGND VGND VPWR VPWR sky130_fd_sc_hd__decap_3
X_8363_ _9221_/Q _8257_/Y _8361_/Y VGND VGND VPWR VPWR _8363_/Y sky130_fd_sc_hd__a21oi_2
X_5575_ _5768_/A _5768_/B VGND VGND VPWR VPWR _5637_/A sky130_fd_sc_hd__xnor2_2
XFILLER_129_492 VGND VGND VPWR VPWR sky130_fd_sc_hd__decap_3
X_7314_ _7764_/A _7088_/A _7088_/B _7313_/X VGND VGND VPWR VPWR _7314_/X sky130_fd_sc_hd__a31o_2
X_4526_ _4526_/A VGND VGND VPWR VPWR _8990_/A sky130_fd_sc_hd__buf_1
X_8294_ _8278_/X _8293_/Y _8295_/S VGND VGND VPWR VPWR _8294_/X sky130_fd_sc_hd__mux2_2
X_7245_ input16/X _7532_/B1 _7702_/A _6797_/B VGND VGND VPWR VPWR _7245_/X sky130_fd_sc_hd__a31o_2
XFILLER_49_28 VGND VGND VPWR VPWR sky130_fd_sc_hd__decap_3
XFILLER_116_197 VGND VGND VPWR VPWR sky130_fd_sc_hd__fill_2
X_7176_ _7176_/A _7176_/B VGND VGND VPWR VPWR _7679_/B sky130_fd_sc_hd__xnor2_2
XFILLER_98_571 VGND VGND VPWR VPWR sky130_fd_sc_hd__decap_3
XFILLER_105_12 VGND VGND VPWR VPWR sky130_fd_sc_hd__decap_3
X_6127_ _5960_/A _5960_/B _5961_/B VGND VGND VPWR VPWR _6127_/X sky130_fd_sc_hd__a21bo_2
XFILLER_58_424 VGND VGND VPWR VPWR sky130_fd_sc_hd__decap_3
XFILLER_58_468 VGND VGND VPWR VPWR sky130_fd_sc_hd__fill_1
X_6058_ _6053_/B _6055_/X _6056_/X _6057_/X VGND VGND VPWR VPWR _6058_/X sky130_fd_sc_hd__a31o_2
XFILLER_73_405 VGND VGND VPWR VPWR sky130_fd_sc_hd__decap_3
XFILLER_100_576 VGND VGND VPWR VPWR sky130_fd_sc_hd__decap_3
XFILLER_85_276 VGND VGND VPWR VPWR sky130_fd_sc_hd__decap_3
XFILLER_45_107 VGND VGND VPWR VPWR sky130_fd_sc_hd__decap_3
X_5009_ _5103_/A _5103_/B _5103_/C _5743_/B _9239_/Q VGND VGND VPWR VPWR _6976_/A
+ sky130_fd_sc_hd__o32ai_4
XTAP_TAPCELL_ROW_107_1723 VGND VPWR sky130_fd_sc_hd__tapvpwrvgnd_1
XFILLER_73_449 VGND VGND VPWR VPWR sky130_fd_sc_hd__decap_3
XFILLER_54_630 VGND VGND VPWR VPWR sky130_fd_sc_hd__decap_3
XFILLER_26_321 VGND VGND VPWR VPWR sky130_fd_sc_hd__decap_3
XFILLER_121_33 VGND VGND VPWR VPWR sky130_fd_sc_hd__decap_3
XFILLER_26_365 VGND VGND VPWR VPWR sky130_fd_sc_hd__fill_2
XFILLER_14_516 VGND VGND VPWR VPWR sky130_fd_sc_hd__decap_3
XFILLER_81_471 VGND VGND VPWR VPWR sky130_fd_sc_hd__decap_3
XFILLER_53_162 VGND VGND VPWR VPWR sky130_fd_sc_hd__decap_3
XTAP_TAPCELL_ROW_120_1901 VGND VPWR sky130_fd_sc_hd__tapvpwrvgnd_1
XFILLER_81_15 VGND VGND VPWR VPWR sky130_fd_sc_hd__fill_2
XFILLER_54_696 VGND VGND VPWR VPWR sky130_fd_sc_hd__decap_3
XFILLER_121_66 VGND VGND VPWR VPWR sky130_fd_sc_hd__decap_3
XFILLER_26_398 VGND VGND VPWR VPWR sky130_fd_sc_hd__decap_3
XFILLER_121_99 VGND VGND VPWR VPWR sky130_fd_sc_hd__decap_3
XFILLER_41_346 VGND VGND VPWR VPWR sky130_fd_sc_hd__decap_3
XFILLER_22_571 VGND VGND VPWR VPWR sky130_fd_sc_hd__decap_3
XFILLER_10_722 VGND VGND VPWR VPWR sky130_fd_sc_hd__decap_3
XTAP_TAPCELL_ROW_24_599 VGND VPWR sky130_fd_sc_hd__tapvpwrvgnd_1
XFILLER_6_704 VGND VGND VPWR VPWR sky130_fd_sc_hd__decap_3
XFILLER_10_755 VGND VGND VPWR VPWR sky130_fd_sc_hd__fill_1
XFILLER_127_418 VGND VGND VPWR VPWR sky130_fd_sc_hd__fill_2
XFILLER_10_766 VGND VGND VPWR VPWR sky130_fd_sc_hd__decap_3
XFILLER_127_429 VGND VGND VPWR VPWR sky130_fd_sc_hd__decap_3
XFILLER_6_737 VGND VGND VPWR VPWR sky130_fd_sc_hd__decap_3
XFILLER_5_225 VGND VGND VPWR VPWR sky130_fd_sc_hd__decap_3
XFILLER_108_643 VGND VGND VPWR VPWR sky130_fd_sc_hd__fill_1
XTAP_TAPCELL_ROW_118_1874 VGND VPWR sky130_fd_sc_hd__tapvpwrvgnd_1
XFILLER_5_269 VGND VGND VPWR VPWR sky130_fd_sc_hd__decap_3
XFILLER_108_698 VGND VGND VPWR VPWR sky130_fd_sc_hd__fill_2
XFILLER_122_112 VGND VGND VPWR VPWR sky130_fd_sc_hd__decap_3
XFILLER_1_420 VGND VGND VPWR VPWR sky130_fd_sc_hd__decap_3
XFILLER_123_657 VGND VGND VPWR VPWR sky130_fd_sc_hd__fill_2
XFILLER_77_700 VGND VGND VPWR VPWR sky130_fd_sc_hd__decap_3
XFILLER_122_156 VGND VGND VPWR VPWR sky130_fd_sc_hd__decap_3
XFILLER_110_307 VGND VGND VPWR VPWR sky130_fd_sc_hd__fill_1
XFILLER_49_424 VGND VGND VPWR VPWR sky130_fd_sc_hd__decap_3
XFILLER_39_50 VGND VGND VPWR VPWR sky130_fd_sc_hd__decap_3
XFILLER_122_189 VGND VGND VPWR VPWR sky130_fd_sc_hd__decap_3
XFILLER_103_381 VGND VGND VPWR VPWR sky130_fd_sc_hd__decap_3
XFILLER_1_497 VGND VGND VPWR VPWR sky130_fd_sc_hd__decap_3
XFILLER_39_72 VGND VGND VPWR VPWR sky130_fd_sc_hd__decap_3
XFILLER_64_405 VGND VGND VPWR VPWR sky130_fd_sc_hd__decap_3
XTAP_TAPCELL_ROW_69_1217 VGND VPWR sky130_fd_sc_hd__tapvpwrvgnd_1
XFILLER_76_287 VGND VGND VPWR VPWR sky130_fd_sc_hd__fill_2
XFILLER_36_118 VGND VGND VPWR VPWR sky130_fd_sc_hd__decap_3
XPHY_EDGE_ROW_101_Right_101 VGND VGND VPWR VPWR sky130_fd_sc_hd__decap_3
XFILLER_17_310 VGND VGND VPWR VPWR sky130_fd_sc_hd__decap_3
XFILLER_92_769 VGND VGND VPWR VPWR sky130_fd_sc_hd__decap_3
XFILLER_17_332 VGND VGND VPWR VPWR sky130_fd_sc_hd__decap_3
XFILLER_17_343 VGND VGND VPWR VPWR sky130_fd_sc_hd__fill_1
XFILLER_55_60 VGND VGND VPWR VPWR sky130_fd_sc_hd__fill_2
XFILLER_45_685 VGND VGND VPWR VPWR sky130_fd_sc_hd__fill_2
XFILLER_44_162 VGND VGND VPWR VPWR sky130_fd_sc_hd__decap_3
XFILLER_17_387 VGND VGND VPWR VPWR sky130_fd_sc_hd__decap_3
XFILLER_44_195 VGND VGND VPWR VPWR sky130_fd_sc_hd__fill_1
XTAP_TAPCELL_ROW_43_864 VGND VPWR sky130_fd_sc_hd__tapvpwrvgnd_1
XFILLER_32_368 VGND VGND VPWR VPWR sky130_fd_sc_hd__decap_3
XFILLER_20_519 VGND VGND VPWR VPWR sky130_fd_sc_hd__decap_3
XFILLER_9_520 VGND VGND VPWR VPWR sky130_fd_sc_hd__decap_3
XFILLER_118_407 VGND VGND VPWR VPWR sky130_fd_sc_hd__fill_1
XFILLER_9_586 VGND VGND VPWR VPWR sky130_fd_sc_hd__decap_3
XFILLER_126_440 VGND VGND VPWR VPWR sky130_fd_sc_hd__decap_3
X_5360_ _6160_/A1 _5439_/S _5357_/X _5359_/X VGND VGND VPWR VPWR _5360_/Y sky130_fd_sc_hd__o31ai_2
XFILLER_58_3 VGND VGND VPWR VPWR sky130_fd_sc_hd__decap_3
XFILLER_126_462 VGND VGND VPWR VPWR sky130_fd_sc_hd__decap_3
XFILLER_114_602 VGND VGND VPWR VPWR sky130_fd_sc_hd__decap_3
XTAP_TAPCELL_ROW_93_1535 VGND VPWR sky130_fd_sc_hd__tapvpwrvgnd_1
XFILLER_99_324 VGND VGND VPWR VPWR sky130_fd_sc_hd__fill_2
X_5291_ _5707_/A VGND VGND VPWR VPWR _7445_/A sky130_fd_sc_hd__clkbuf_2
XFILLER_99_346 VGND VGND VPWR VPWR sky130_fd_sc_hd__decap_3
XFILLER_114_657 VGND VGND VPWR VPWR sky130_fd_sc_hd__decap_3
XFILLER_4_291 VGND VGND VPWR VPWR sky130_fd_sc_hd__fill_2
X_7030_ _6950_/A _7028_/Y _7029_/Y VGND VGND VPWR VPWR _7031_/A sky130_fd_sc_hd__a21o_2
XFILLER_87_508 VGND VGND VPWR VPWR sky130_fd_sc_hd__decap_3
XFILLER_87_519 VGND VGND VPWR VPWR sky130_fd_sc_hd__decap_3
XFILLER_68_722 VGND VGND VPWR VPWR sky130_fd_sc_hd__decap_3
XFILLER_113_178 VGND VGND VPWR VPWR sky130_fd_sc_hd__decap_3
XFILLER_113_189 VGND VGND VPWR VPWR sky130_fd_sc_hd__decap_3
XFILLER_122_690 VGND VGND VPWR VPWR sky130_fd_sc_hd__decap_3
XFILLER_95_541 VGND VGND VPWR VPWR sky130_fd_sc_hd__decap_3
XFILLER_68_755 VGND VGND VPWR VPWR sky130_fd_sc_hd__fill_1
X_8981_ _8981_/A VGND VGND VPWR VPWR _9331_/D sky130_fd_sc_hd__buf_1
XFILLER_95_596 VGND VGND VPWR VPWR sky130_fd_sc_hd__decap_3
XFILLER_67_287 VGND VGND VPWR VPWR sky130_fd_sc_hd__decap_3
X_7932_ _8155_/A _7772_/A _7772_/B _7931_/Y wire84/X VGND VGND VPWR VPWR _7932_/X
+ sky130_fd_sc_hd__o32a_2
XFILLER_82_235 VGND VGND VPWR VPWR sky130_fd_sc_hd__fill_2
XFILLER_55_449 VGND VGND VPWR VPWR sky130_fd_sc_hd__decap_3
XFILLER_36_641 VGND VGND VPWR VPWR sky130_fd_sc_hd__decap_3
X_7863_ _7739_/A _7738_/A _7862_/X VGND VGND VPWR VPWR _7895_/A sky130_fd_sc_hd__o21ai_2
XFILLER_51_611 VGND VGND VPWR VPWR sky130_fd_sc_hd__decap_3
XFILLER_63_482 VGND VGND VPWR VPWR sky130_fd_sc_hd__decap_3
X_6814_ _6807_/A _5034_/A _6812_/S _6813_/X _6808_/S VGND VGND VPWR VPWR _6814_/X
+ sky130_fd_sc_hd__a32o_2
XFILLER_23_324 VGND VGND VPWR VPWR sky130_fd_sc_hd__decap_3
X_7794_ _7794_/A _7794_/B VGND VGND VPWR VPWR _7794_/Y sky130_fd_sc_hd__nand2_2
XTAP_TAPCELL_ROW_102_1653 VGND VPWR sky130_fd_sc_hd__tapvpwrvgnd_1
X_6745_ _6745_/A _6745_/B VGND VGND VPWR VPWR _6747_/A sky130_fd_sc_hd__or2_2
XFILLER_51_688 VGND VGND VPWR VPWR sky130_fd_sc_hd__decap_3
XTAP_TAPCELL_ROW_102_1664 VGND VPWR sky130_fd_sc_hd__tapvpwrvgnd_1
X_6676_ _6676_/A _6676_/B VGND VGND VPWR VPWR _6676_/Y sky130_fd_sc_hd__nor2_2
XTAP_TAPCELL_ROW_21_569 VGND VPWR sky130_fd_sc_hd__tapvpwrvgnd_1
XFILLER_129_9 VGND VGND VPWR VPWR sky130_fd_sc_hd__decap_3
XFILLER_109_429 VGND VGND VPWR VPWR sky130_fd_sc_hd__decap_3
X_8415_ _7593_/X _8411_/Y _8496_/S _8414_/Y VGND VGND VPWR VPWR _8514_/A sky130_fd_sc_hd__o22a_2
X_5627_ _9246_/Q _5627_/B VGND VGND VPWR VPWR _5627_/Y sky130_fd_sc_hd__nor2_2
X_8346_ _9220_/Q _9221_/Q _8398_/B _8398_/A VGND VGND VPWR VPWR _8346_/X sky130_fd_sc_hd__a31o_2
X_5558_ _5559_/A _5559_/B VGND VGND VPWR VPWR _5560_/A sky130_fd_sc_hd__nor2_2
XFILLER_3_718 VGND VGND VPWR VPWR sky130_fd_sc_hd__decap_3
XFILLER_105_602 VGND VGND VPWR VPWR sky130_fd_sc_hd__fill_2
XFILLER_3_729 VGND VGND VPWR VPWR sky130_fd_sc_hd__decap_3
XFILLER_117_484 VGND VGND VPWR VPWR sky130_fd_sc_hd__decap_3
X_8277_ _8277_/A VGND VGND VPWR VPWR _8277_/Y sky130_fd_sc_hd__inv_2
X_5489_ _5489_/A _5489_/B VGND VGND VPWR VPWR _5490_/B sky130_fd_sc_hd__xnor2_2
XFILLER_2_239 VGND VGND VPWR VPWR sky130_fd_sc_hd__decap_3
XFILLER_105_668 VGND VGND VPWR VPWR sky130_fd_sc_hd__decap_3
X_7228_ _7228_/A _7228_/B VGND VGND VPWR VPWR _7881_/C sky130_fd_sc_hd__nand2_2
XFILLER_120_605 VGND VGND VPWR VPWR sky130_fd_sc_hd__decap_3
XFILLER_116_44 VGND VGND VPWR VPWR sky130_fd_sc_hd__decap_3
XFILLER_120_627 VGND VGND VPWR VPWR sky130_fd_sc_hd__decap_3
XFILLER_116_77 VGND VGND VPWR VPWR sky130_fd_sc_hd__decap_3
X_7159_ _7159_/A wire91/X VGND VGND VPWR VPWR _7159_/Y sky130_fd_sc_hd__nor2_2
XFILLER_86_530 VGND VGND VPWR VPWR sky130_fd_sc_hd__fill_2
XFILLER_116_88 VGND VGND VPWR VPWR sky130_fd_sc_hd__decap_3
XFILLER_59_755 VGND VGND VPWR VPWR sky130_fd_sc_hd__fill_1
XFILLER_86_552 VGND VGND VPWR VPWR sky130_fd_sc_hd__decap_3
XFILLER_76_59 VGND VGND VPWR VPWR sky130_fd_sc_hd__decap_3
XFILLER_18_118 VGND VGND VPWR VPWR sky130_fd_sc_hd__decap_3
Xclkbuf_leaf_38_clk clkload0/A VGND VGND VPWR VPWR clkload8/A sky130_fd_sc_hd__clkbuf_8
XTAP_TAPCELL_ROW_29_669 VGND VPWR sky130_fd_sc_hd__tapvpwrvgnd_1
XFILLER_27_652 VGND VGND VPWR VPWR sky130_fd_sc_hd__decap_3
XFILLER_73_268 VGND VGND VPWR VPWR sky130_fd_sc_hd__fill_1
XFILLER_14_302 VGND VGND VPWR VPWR sky130_fd_sc_hd__decap_3
XTAP_TAPCELL_ROW_1_294 VGND VPWR sky130_fd_sc_hd__tapvpwrvgnd_1
XFILLER_14_324 VGND VGND VPWR VPWR sky130_fd_sc_hd__decap_3
XFILLER_14_335 VGND VGND VPWR VPWR sky130_fd_sc_hd__decap_3
XTAP_TAPCELL_ROW_64_1147 VGND VPWR sky130_fd_sc_hd__tapvpwrvgnd_1
XFILLER_25_52 VGND VGND VPWR VPWR sky130_fd_sc_hd__decap_3
XFILLER_41_154 VGND VGND VPWR VPWR sky130_fd_sc_hd__fill_1
XFILLER_25_85 VGND VGND VPWR VPWR sky130_fd_sc_hd__decap_3
XFILLER_14_368 VGND VGND VPWR VPWR sky130_fd_sc_hd__decap_3
XTAP_TAPCELL_ROW_40_823 VGND VPWR sky130_fd_sc_hd__tapvpwrvgnd_1
XFILLER_41_187 VGND VGND VPWR VPWR sky130_fd_sc_hd__decap_3
XFILLER_22_390 VGND VGND VPWR VPWR sky130_fd_sc_hd__decap_3
XFILLER_128_716 VGND VGND VPWR VPWR sky130_fd_sc_hd__decap_3
XFILLER_41_51 VGND VGND VPWR VPWR sky130_fd_sc_hd__decap_3
XFILLER_128_749 VGND VGND VPWR VPWR sky130_fd_sc_hd__decap_3
XFILLER_127_237 VGND VGND VPWR VPWR sky130_fd_sc_hd__decap_3
XFILLER_6_567 VGND VGND VPWR VPWR sky130_fd_sc_hd__decap_3
XFILLER_108_484 VGND VGND VPWR VPWR sky130_fd_sc_hd__decap_3
XFILLER_123_410 VGND VGND VPWR VPWR sky130_fd_sc_hd__decap_3
XFILLER_2_740 VGND VGND VPWR VPWR sky130_fd_sc_hd__decap_3
XFILLER_69_508 VGND VGND VPWR VPWR sky130_fd_sc_hd__decap_3
XTAP_TAPCELL_ROW_75_1298 VGND VPWR sky130_fd_sc_hd__tapvpwrvgnd_1
XFILLER_96_305 VGND VGND VPWR VPWR sky130_fd_sc_hd__decap_3
XFILLER_2_12 VGND VGND VPWR VPWR sky130_fd_sc_hd__decap_3
XFILLER_77_530 VGND VGND VPWR VPWR sky130_fd_sc_hd__decap_3
XFILLER_49_243 VGND VGND VPWR VPWR sky130_fd_sc_hd__decap_3
XFILLER_2_56 VGND VGND VPWR VPWR sky130_fd_sc_hd__decap_3
XFILLER_65_725 VGND VGND VPWR VPWR sky130_fd_sc_hd__decap_3
XFILLER_49_276 VGND VGND VPWR VPWR sky130_fd_sc_hd__decap_3
XTAP_TAPCELL_ROW_48_923 VGND VPWR sky130_fd_sc_hd__tapvpwrvgnd_1
XTAP_TAPCELL_ROW_48_934 VGND VPWR sky130_fd_sc_hd__tapvpwrvgnd_1
XFILLER_37_449 VGND VGND VPWR VPWR sky130_fd_sc_hd__fill_1
Xclkbuf_leaf_29_clk clkload1/A VGND VGND VPWR VPWR _9333_/CLK sky130_fd_sc_hd__clkbuf_8
XFILLER_65_769 VGND VGND VPWR VPWR sky130_fd_sc_hd__decap_3
XFILLER_64_235 VGND VGND VPWR VPWR sky130_fd_sc_hd__decap_3
XFILLER_92_555 VGND VGND VPWR VPWR sky130_fd_sc_hd__fill_2
XFILLER_18_641 VGND VGND VPWR VPWR sky130_fd_sc_hd__decap_3
XFILLER_92_577 VGND VGND VPWR VPWR sky130_fd_sc_hd__decap_3
XFILLER_52_419 VGND VGND VPWR VPWR sky130_fd_sc_hd__fill_1
XFILLER_17_140 VGND VGND VPWR VPWR sky130_fd_sc_hd__decap_3
XFILLER_17_184 VGND VGND VPWR VPWR sky130_fd_sc_hd__decap_3
X_4860_ _4860_/A VGND VGND VPWR VPWR _9174_/D sky130_fd_sc_hd__buf_1
XFILLER_33_644 VGND VGND VPWR VPWR sky130_fd_sc_hd__fill_1
XFILLER_32_132 VGND VGND VPWR VPWR sky130_fd_sc_hd__decap_3
XFILLER_60_452 VGND VGND VPWR VPWR sky130_fd_sc_hd__decap_3
XFILLER_32_165 VGND VGND VPWR VPWR sky130_fd_sc_hd__decap_3
X_4791_ _4791_/A VGND VGND VPWR VPWR _9141_/D sky130_fd_sc_hd__buf_1
XFILLER_60_496 VGND VGND VPWR VPWR sky130_fd_sc_hd__decap_3
X_6530_ _6533_/A1 _6363_/B _6526_/Y _6527_/X _6529_/X VGND VGND VPWR VPWR _6530_/X
+ sky130_fd_sc_hd__a32o_2
XFILLER_119_705 VGND VGND VPWR VPWR sky130_fd_sc_hd__decap_3
XFILLER_13_390 VGND VGND VPWR VPWR sky130_fd_sc_hd__fill_2
XFILLER_119_738 VGND VGND VPWR VPWR sky130_fd_sc_hd__decap_3
X_6461_ _6390_/Y _6460_/X _7219_/S VGND VGND VPWR VPWR _6462_/A sky130_fd_sc_hd__mux2_2
X_8200_ _8271_/A _8200_/B VGND VGND VPWR VPWR _8200_/X sky130_fd_sc_hd__or2_2
X_5412_ _5412_/A _5412_/B VGND VGND VPWR VPWR _5412_/Y sky130_fd_sc_hd__nor2_2
X_9180_ _9189_/CLK _9180_/D load_slew414/X VGND VGND VPWR VPWR _9180_/Q sky130_fd_sc_hd__dfrtp_2
X_6392_ _6137_/A _6136_/B _6136_/A VGND VGND VPWR VPWR _6392_/X sky130_fd_sc_hd__a21bo_2
XFILLER_127_771 VGND VGND VPWR VPWR sky130_fd_sc_hd__decap_3
X_8131_ _8131_/A _8131_/B VGND VGND VPWR VPWR _8131_/X sky130_fd_sc_hd__xor2_2
XFILLER_114_410 VGND VGND VPWR VPWR sky130_fd_sc_hd__decap_3
X_5343_ _5343_/A _7408_/B VGND VGND VPWR VPWR _5347_/A sky130_fd_sc_hd__nor2_2
XFILLER_99_110 VGND VGND VPWR VPWR sky130_fd_sc_hd__fill_2
XFILLER_114_421 VGND VGND VPWR VPWR sky130_fd_sc_hd__decap_3
XFILLER_99_121 VGND VGND VPWR VPWR sky130_fd_sc_hd__decap_3
XFILLER_126_292 VGND VGND VPWR VPWR sky130_fd_sc_hd__decap_3
X_8062_ _8421_/A _8062_/B VGND VGND VPWR VPWR _8063_/B sky130_fd_sc_hd__nand2_2
XFILLER_102_616 VGND VGND VPWR VPWR sky130_fd_sc_hd__decap_3
X_5274_ _5743_/B _5272_/X _5273_/Y VGND VGND VPWR VPWR _5275_/A sky130_fd_sc_hd__a21oi_2
XFILLER_102_638 VGND VGND VPWR VPWR sky130_fd_sc_hd__decap_3
X_7013_ _7117_/A _7013_/B _7013_/C VGND VGND VPWR VPWR _7014_/A sky130_fd_sc_hd__or3_4
XFILLER_68_530 VGND VGND VPWR VPWR sky130_fd_sc_hd__fill_2
XFILLER_56_714 VGND VGND VPWR VPWR sky130_fd_sc_hd__decap_3
XFILLER_28_405 VGND VGND VPWR VPWR sky130_fd_sc_hd__decap_3
XFILLER_46_29 VGND VGND VPWR VPWR sky130_fd_sc_hd__decap_3
XFILLER_28_427 VGND VGND VPWR VPWR sky130_fd_sc_hd__decap_3
XFILLER_83_533 VGND VGND VPWR VPWR sky130_fd_sc_hd__decap_3
X_8964_ _8964_/A VGND VGND VPWR VPWR _9323_/D sky130_fd_sc_hd__buf_1
X_7915_ _9217_/Q _7915_/B VGND VGND VPWR VPWR _7915_/Y sky130_fd_sc_hd__nand2_2
XFILLER_36_460 VGND VGND VPWR VPWR sky130_fd_sc_hd__decap_3
X_8895_ _8895_/A VGND VGND VPWR VPWR _9290_/D sky130_fd_sc_hd__buf_1
XFILLER_83_599 VGND VGND VPWR VPWR sky130_fd_sc_hd__decap_3
XFILLER_24_611 VGND VGND VPWR VPWR sky130_fd_sc_hd__decap_3
XTAP_TAPCELL_ROW_26_628 VGND VPWR sky130_fd_sc_hd__tapvpwrvgnd_1
XTAP_TAPCELL_ROW_26_639 VGND VPWR sky130_fd_sc_hd__tapvpwrvgnd_1
XFILLER_36_493 VGND VGND VPWR VPWR sky130_fd_sc_hd__decap_3
X_7846_ _7846_/A _7846_/B VGND VGND VPWR VPWR _7847_/B sky130_fd_sc_hd__xnor2_2
XFILLER_70_249 VGND VGND VPWR VPWR sky130_fd_sc_hd__decap_3
XFILLER_23_132 VGND VGND VPWR VPWR sky130_fd_sc_hd__decap_3
XFILLER_51_452 VGND VGND VPWR VPWR sky130_fd_sc_hd__decap_3
XFILLER_24_677 VGND VGND VPWR VPWR sky130_fd_sc_hd__decap_3
XFILLER_51_474 VGND VGND VPWR VPWR sky130_fd_sc_hd__decap_3
XFILLER_11_305 VGND VGND VPWR VPWR sky130_fd_sc_hd__decap_3
X_7777_ _7777_/A _7777_/B VGND VGND VPWR VPWR _7791_/A sky130_fd_sc_hd__xnor2_2
XFILLER_24_699 VGND VGND VPWR VPWR sky130_fd_sc_hd__fill_1
X_4989_ _4935_/X _4987_/X _4988_/X _4916_/A VGND VGND VPWR VPWR _4989_/X sky130_fd_sc_hd__a22o_2
XFILLER_51_496 VGND VGND VPWR VPWR sky130_fd_sc_hd__decap_3
X_6728_ _6732_/A _7016_/A _7016_/B _7016_/C VGND VGND VPWR VPWR _6733_/B sky130_fd_sc_hd__nand4_2
XFILLER_11_349 VGND VGND VPWR VPWR sky130_fd_sc_hd__decap_3
Xwire218 wire218/A VGND VGND VPWR VPWR result_valid sky130_fd_sc_hd__buf_4
Xwire229 wire229/A VGND VGND VPWR VPWR result_out[14] sky130_fd_sc_hd__buf_4
XFILLER_127_6 VGND VGND VPWR VPWR sky130_fd_sc_hd__decap_3
X_6659_ _6658_/A _6658_/B _6643_/B VGND VGND VPWR VPWR _6664_/B sky130_fd_sc_hd__a21o_2
XFILLER_11_21 VGND VGND VPWR VPWR sky130_fd_sc_hd__decap_3
XFILLER_125_719 VGND VGND VPWR VPWR sky130_fd_sc_hd__decap_3
XFILLER_118_760 VGND VGND VPWR VPWR sky130_fd_sc_hd__decap_3
XTAP_TAPCELL_ROW_115_1833 VGND VPWR sky130_fd_sc_hd__tapvpwrvgnd_1
XFILLER_127_21 VGND VGND VPWR VPWR sky130_fd_sc_hd__decap_3
XFILLER_124_218 VGND VGND VPWR VPWR sky130_fd_sc_hd__decap_3
XFILLER_11_54 VGND VGND VPWR VPWR sky130_fd_sc_hd__fill_2
X_8329_ _8329_/A VGND VGND VPWR VPWR _8329_/Y sky130_fd_sc_hd__inv_2
XFILLER_117_270 VGND VGND VPWR VPWR sky130_fd_sc_hd__fill_1
XFILLER_105_421 VGND VGND VPWR VPWR sky130_fd_sc_hd__decap_3
XFILLER_127_54 VGND VGND VPWR VPWR sky130_fd_sc_hd__fill_2
XFILLER_117_292 VGND VGND VPWR VPWR sky130_fd_sc_hd__decap_3
XFILLER_3_559 VGND VGND VPWR VPWR sky130_fd_sc_hd__fill_1
XFILLER_11_98 VGND VGND VPWR VPWR sky130_fd_sc_hd__fill_1
XFILLER_87_25 VGND VGND VPWR VPWR sky130_fd_sc_hd__fill_1
XFILLER_105_465 VGND VGND VPWR VPWR sky130_fd_sc_hd__decap_3
XFILLER_127_87 VGND VGND VPWR VPWR sky130_fd_sc_hd__decap_3
XFILLER_105_476 VGND VGND VPWR VPWR sky130_fd_sc_hd__decap_3
XFILLER_105_498 VGND VGND VPWR VPWR sky130_fd_sc_hd__decap_3
XFILLER_120_457 VGND VGND VPWR VPWR sky130_fd_sc_hd__decap_3
XTAP_TAPCELL_ROW_6_364 VGND VPWR sky130_fd_sc_hd__tapvpwrvgnd_1
XFILLER_93_308 VGND VGND VPWR VPWR sky130_fd_sc_hd__fill_2
Xfanout373 fanout375/X VGND VGND VPWR VPWR fanout373/X sky130_fd_sc_hd__clkdlybuf4s25_1
XFILLER_59_585 VGND VGND VPWR VPWR sky130_fd_sc_hd__decap_3
Xfanout395 fanout402/X VGND VGND VPWR VPWR fanout395/X sky130_fd_sc_hd__clkdlybuf4s25_1
XFILLER_86_371 VGND VGND VPWR VPWR sky130_fd_sc_hd__decap_3
XFILLER_101_693 VGND VGND VPWR VPWR sky130_fd_sc_hd__decap_3
XFILLER_74_533 VGND VGND VPWR VPWR sky130_fd_sc_hd__decap_3
XFILLER_47_747 VGND VGND VPWR VPWR sky130_fd_sc_hd__decap_3
XFILLER_19_449 VGND VGND VPWR VPWR sky130_fd_sc_hd__decap_3
XFILLER_47_769 VGND VGND VPWR VPWR sky130_fd_sc_hd__decap_3
XFILLER_62_728 VGND VGND VPWR VPWR sky130_fd_sc_hd__decap_3
XFILLER_46_279 VGND VGND VPWR VPWR sky130_fd_sc_hd__decap_3
XTAP_TAPCELL_ROW_126_1984 VGND VPWR sky130_fd_sc_hd__tapvpwrvgnd_1
XFILLER_15_644 VGND VGND VPWR VPWR sky130_fd_sc_hd__decap_3
XFILLER_14_121 VGND VGND VPWR VPWR sky130_fd_sc_hd__decap_3
XFILLER_15_688 VGND VGND VPWR VPWR sky130_fd_sc_hd__decap_3
XTAP_TAPCELL_ROW_53_992 VGND VPWR sky130_fd_sc_hd__tapvpwrvgnd_1
Xinput15 sample_in[7] VGND VGND VPWR VPWR _5803_/C sky130_fd_sc_hd__clkbuf_2
XTAP_TAPCELL_ROW_77_1316 VGND VPWR sky130_fd_sc_hd__tapvpwrvgnd_1
XTAP_TAPCELL_ROW_77_1327 VGND VPWR sky130_fd_sc_hd__tapvpwrvgnd_1
XFILLER_6_342 VGND VGND VPWR VPWR sky130_fd_sc_hd__decap_3
XFILLER_128_579 VGND VGND VPWR VPWR sky130_fd_sc_hd__decap_3
XFILLER_6_386 VGND VGND VPWR VPWR sky130_fd_sc_hd__fill_2
XFILLER_124_752 VGND VGND VPWR VPWR sky130_fd_sc_hd__decap_3
XFILLER_124_763 VGND VGND VPWR VPWR sky130_fd_sc_hd__decap_3
XFILLER_96_124 VGND VGND VPWR VPWR sky130_fd_sc_hd__decap_3
XFILLER_2_581 VGND VGND VPWR VPWR sky130_fd_sc_hd__decap_3
XFILLER_2_592 VGND VGND VPWR VPWR sky130_fd_sc_hd__decap_3
XFILLER_123_295 VGND VGND VPWR VPWR sky130_fd_sc_hd__decap_3
XFILLER_97_669 VGND VGND VPWR VPWR sky130_fd_sc_hd__decap_3
XFILLER_65_511 VGND VGND VPWR VPWR sky130_fd_sc_hd__decap_3
XFILLER_38_736 VGND VGND VPWR VPWR sky130_fd_sc_hd__decap_3
XFILLER_77_393 VGND VGND VPWR VPWR sky130_fd_sc_hd__decap_3
XFILLER_92_330 VGND VGND VPWR VPWR sky130_fd_sc_hd__decap_3
XFILLER_38_769 VGND VGND VPWR VPWR sky130_fd_sc_hd__decap_3
XFILLER_65_555 VGND VGND VPWR VPWR sky130_fd_sc_hd__decap_3
XTAP_TAPCELL_ROW_88_1467 VGND VPWR sky130_fd_sc_hd__tapvpwrvgnd_1
XFILLER_80_503 VGND VGND VPWR VPWR sky130_fd_sc_hd__decap_3
XFILLER_37_279 VGND VGND VPWR VPWR sky130_fd_sc_hd__fill_1
X_5961_ _5961_/A _5961_/B VGND VGND VPWR VPWR _5962_/B sky130_fd_sc_hd__xnor2_2
XFILLER_80_514 VGND VGND VPWR VPWR sky130_fd_sc_hd__decap_3
XFILLER_53_739 VGND VGND VPWR VPWR sky130_fd_sc_hd__fill_1
XFILLER_18_471 VGND VGND VPWR VPWR sky130_fd_sc_hd__decap_3
XFILLER_80_536 VGND VGND VPWR VPWR sky130_fd_sc_hd__decap_3
X_7700_ _7700_/A VGND VGND VPWR VPWR _9216_/D sky130_fd_sc_hd__buf_1
X_4912_ _5737_/B VGND VGND VPWR VPWR _5446_/A sky130_fd_sc_hd__inv_2
XFILLER_80_558 VGND VGND VPWR VPWR sky130_fd_sc_hd__decap_3
X_8680_ _8622_/B _8675_/X _8677_/X _8679_/Y VGND VGND VPWR VPWR _8706_/C sky130_fd_sc_hd__a2bb2o_2
XFILLER_45_290 VGND VGND VPWR VPWR sky130_fd_sc_hd__fill_1
X_5892_ _5892_/A VGND VGND VPWR VPWR _6177_/B sky130_fd_sc_hd__buf_8
XFILLER_61_750 VGND VGND VPWR VPWR sky130_fd_sc_hd__decap_3
X_7631_ _7924_/A _7631_/B VGND VGND VPWR VPWR _7632_/B sky130_fd_sc_hd__xnor2_2
XFILLER_33_463 VGND VGND VPWR VPWR sky130_fd_sc_hd__decap_3
X_4843_ hold985/X _9150_/Q _4861_/S VGND VGND VPWR VPWR _4843_/X sky130_fd_sc_hd__mux2_2
XFILLER_33_485 VGND VGND VPWR VPWR sky130_fd_sc_hd__decap_3
X_7562_ _5094_/X _7506_/Y _7507_/X _7561_/X VGND VGND VPWR VPWR _9215_/D sky130_fd_sc_hd__a31o_2
X_4774_ _4774_/A VGND VGND VPWR VPWR _9133_/D sky130_fd_sc_hd__buf_1
XFILLER_119_502 VGND VGND VPWR VPWR sky130_fd_sc_hd__fill_2
X_9301_ _9317_/CLK _9301_/D wire406/X VGND VGND VPWR VPWR _9301_/Q sky130_fd_sc_hd__dfrtp_2
X_6513_ hold816/X _6512_/X _7560_/S VGND VGND VPWR VPWR _6513_/X sky130_fd_sc_hd__mux2_2
XFILLER_20_168 VGND VGND VPWR VPWR sky130_fd_sc_hd__decap_3
X_7493_ _7492_/A _7490_/B _7487_/Y _7492_/X VGND VGND VPWR VPWR _7494_/B sky130_fd_sc_hd__o31a_4
XTAP_TAPCELL_ROW_31_697 VGND VPWR sky130_fd_sc_hd__tapvpwrvgnd_1
XFILLER_9_180 VGND VGND VPWR VPWR sky130_fd_sc_hd__decap_3
XFILLER_119_557 VGND VGND VPWR VPWR sky130_fd_sc_hd__decap_3
X_9232_ _9232_/CLK _9232_/D fanout405/A VGND VGND VPWR VPWR _9232_/Q sky130_fd_sc_hd__dfrtp_2
X_6444_ _6125_/A _6125_/B _6126_/A VGND VGND VPWR VPWR _6444_/X sky130_fd_sc_hd__a21bo_2
Xclkbuf_leaf_9_clk clkbuf_leaf_9_clk/A VGND VGND VPWR VPWR _9135_/CLK sky130_fd_sc_hd__clkbuf_8
X_9163_ _9236_/CLK _9163_/D fanout398/X VGND VGND VPWR VPWR _9163_/Q sky130_fd_sc_hd__dfrtp_2
X_6375_ _6375_/A1 _6374_/B _6374_/C VGND VGND VPWR VPWR _6376_/B sky130_fd_sc_hd__o21ai_2
XFILLER_115_752 VGND VGND VPWR VPWR sky130_fd_sc_hd__decap_3
X_8114_ _8121_/A _8114_/B VGND VGND VPWR VPWR _8116_/A sky130_fd_sc_hd__or2_2
XFILLER_88_603 VGND VGND VPWR VPWR sky130_fd_sc_hd__decap_3
X_5326_ _6084_/A _6415_/A VGND VGND VPWR VPWR _5326_/X sky130_fd_sc_hd__or2_2
XFILLER_102_402 VGND VGND VPWR VPWR sky130_fd_sc_hd__decap_3
X_9094_ _9142_/CLK _9094_/D load_slew408/X VGND VGND VPWR VPWR _9094_/Q sky130_fd_sc_hd__dfrtp_2
XFILLER_0_529 VGND VGND VPWR VPWR sky130_fd_sc_hd__decap_3
XFILLER_114_262 VGND VGND VPWR VPWR sky130_fd_sc_hd__decap_3
XFILLER_87_113 VGND VGND VPWR VPWR sky130_fd_sc_hd__decap_3
XFILLER_130_722 VGND VGND VPWR VPWR sky130_fd_sc_hd__decap_3
XFILLER_102_424 VGND VGND VPWR VPWR sky130_fd_sc_hd__decap_3
X_8045_ _9219_/Q _8044_/Y _8045_/S VGND VGND VPWR VPWR _8045_/X sky130_fd_sc_hd__mux2_2
XFILLER_130_744 VGND VGND VPWR VPWR sky130_fd_sc_hd__decap_3
XFILLER_114_295 VGND VGND VPWR VPWR sky130_fd_sc_hd__decap_3
X_5257_ _5878_/C VGND VGND VPWR VPWR _5442_/B sky130_fd_sc_hd__buf_4
XTAP_TAPCELL_ROW_110_1763 VGND VPWR sky130_fd_sc_hd__tapvpwrvgnd_1
XFILLER_130_766 VGND VGND VPWR VPWR sky130_fd_sc_hd__decap_3
XFILLER_75_308 VGND VGND VPWR VPWR sky130_fd_sc_hd__decap_3
XFILLER_57_39 VGND VGND VPWR VPWR sky130_fd_sc_hd__decap_3
X_5188_ _5186_/X _5187_/X _6336_/B VGND VGND VPWR VPWR _5188_/X sky130_fd_sc_hd__o21a_2
XTAP_TAPCELL_ROW_3_323 VGND VPWR sky130_fd_sc_hd__tapvpwrvgnd_1
XFILLER_56_522 VGND VGND VPWR VPWR sky130_fd_sc_hd__decap_3
XFILLER_113_12 VGND VGND VPWR VPWR sky130_fd_sc_hd__decap_3
XFILLER_28_224 VGND VGND VPWR VPWR sky130_fd_sc_hd__decap_3
XFILLER_56_544 VGND VGND VPWR VPWR sky130_fd_sc_hd__decap_3
XFILLER_110_490 VGND VGND VPWR VPWR sky130_fd_sc_hd__decap_3
XFILLER_29_769 VGND VGND VPWR VPWR sky130_fd_sc_hd__decap_3
XFILLER_113_45 VGND VGND VPWR VPWR sky130_fd_sc_hd__decap_3
XFILLER_44_717 VGND VGND VPWR VPWR sky130_fd_sc_hd__decap_3
X_8947_ _8947_/A VGND VGND VPWR VPWR _9315_/D sky130_fd_sc_hd__buf_1
XFILLER_71_536 VGND VGND VPWR VPWR sky130_fd_sc_hd__decap_3
XFILLER_43_238 VGND VGND VPWR VPWR sky130_fd_sc_hd__decap_3
Xwire61 wire61/A VGND VGND VPWR VPWR wire61/X sky130_fd_sc_hd__buf_2
XFILLER_71_558 VGND VGND VPWR VPWR sky130_fd_sc_hd__fill_2
XFILLER_24_430 VGND VGND VPWR VPWR sky130_fd_sc_hd__fill_1
X_8878_ _8878_/A VGND VGND VPWR VPWR _9282_/D sky130_fd_sc_hd__buf_1
XFILLER_52_750 VGND VGND VPWR VPWR sky130_fd_sc_hd__decap_3
XFILLER_24_441 VGND VGND VPWR VPWR sky130_fd_sc_hd__decap_3
XFILLER_24_463 VGND VGND VPWR VPWR sky130_fd_sc_hd__decap_3
XFILLER_12_603 VGND VGND VPWR VPWR sky130_fd_sc_hd__decap_3
XTAP_TAPCELL_ROW_61_1106 VGND VPWR sky130_fd_sc_hd__tapvpwrvgnd_1
X_7829_ _8099_/C VGND VGND VPWR VPWR wire67/A sky130_fd_sc_hd__clkbuf_1
XFILLER_11_113 VGND VGND VPWR VPWR sky130_fd_sc_hd__decap_3
XTAP_TAPCELL_ROW_50_951 VGND VPWR sky130_fd_sc_hd__tapvpwrvgnd_1
XTAP_TAPCELL_ROW_50_962 VGND VPWR sky130_fd_sc_hd__tapvpwrvgnd_1
XFILLER_7_128 VGND VGND VPWR VPWR sky130_fd_sc_hd__fill_2
XFILLER_125_3 VGND VGND VPWR VPWR sky130_fd_sc_hd__decap_3
XFILLER_125_505 VGND VGND VPWR VPWR sky130_fd_sc_hd__decap_3
XFILLER_22_97 VGND VGND VPWR VPWR sky130_fd_sc_hd__decap_3
XFILLER_125_538 VGND VGND VPWR VPWR sky130_fd_sc_hd__decap_3
XFILLER_106_730 VGND VGND VPWR VPWR sky130_fd_sc_hd__decap_3
XTAP_TAPCELL_ROW_59_1079 VGND VPWR sky130_fd_sc_hd__tapvpwrvgnd_1
XFILLER_79_603 VGND VGND VPWR VPWR sky130_fd_sc_hd__decap_3
XFILLER_79_647 VGND VGND VPWR VPWR sky130_fd_sc_hd__fill_1
XFILLER_78_113 VGND VGND VPWR VPWR sky130_fd_sc_hd__decap_3
XTAP_TAPCELL_ROW_72_1257 VGND VPWR sky130_fd_sc_hd__tapvpwrvgnd_1
XFILLER_121_744 VGND VGND VPWR VPWR sky130_fd_sc_hd__decap_3
XFILLER_120_210 VGND VGND VPWR VPWR sky130_fd_sc_hd__decap_3
XFILLER_59_360 VGND VGND VPWR VPWR sky130_fd_sc_hd__decap_3
XFILLER_47_500 VGND VGND VPWR VPWR sky130_fd_sc_hd__decap_3
XFILLER_93_116 VGND VGND VPWR VPWR sky130_fd_sc_hd__fill_1
XFILLER_47_511 VGND VGND VPWR VPWR sky130_fd_sc_hd__decap_3
XFILLER_120_276 VGND VGND VPWR VPWR sky130_fd_sc_hd__decap_3
XFILLER_59_393 VGND VGND VPWR VPWR sky130_fd_sc_hd__decap_3
XFILLER_47_533 VGND VGND VPWR VPWR sky130_fd_sc_hd__fill_2
XFILLER_47_50 VGND VGND VPWR VPWR sky130_fd_sc_hd__decap_3
XFILLER_93_149 VGND VGND VPWR VPWR sky130_fd_sc_hd__fill_2
XFILLER_74_374 VGND VGND VPWR VPWR sky130_fd_sc_hd__decap_3
XFILLER_62_514 VGND VGND VPWR VPWR sky130_fd_sc_hd__decap_3
XFILLER_47_588 VGND VGND VPWR VPWR sky130_fd_sc_hd__fill_1
XFILLER_34_216 VGND VGND VPWR VPWR sky130_fd_sc_hd__fill_2
XFILLER_74_385 VGND VGND VPWR VPWR sky130_fd_sc_hd__decap_3
XFILLER_62_569 VGND VGND VPWR VPWR sky130_fd_sc_hd__fill_1
XFILLER_15_430 VGND VGND VPWR VPWR sky130_fd_sc_hd__decap_3
XFILLER_43_761 VGND VGND VPWR VPWR sky130_fd_sc_hd__decap_3
XFILLER_15_452 VGND VGND VPWR VPWR sky130_fd_sc_hd__decap_3
XTAP_TAPCELL_ROW_83_1397 VGND VPWR sky130_fd_sc_hd__tapvpwrvgnd_1
XFILLER_30_455 VGND VGND VPWR VPWR sky130_fd_sc_hd__decap_3
XFILLER_8_44 VGND VGND VPWR VPWR sky130_fd_sc_hd__decap_3
XFILLER_30_477 VGND VGND VPWR VPWR sky130_fd_sc_hd__decap_3
XFILLER_7_640 VGND VGND VPWR VPWR sky130_fd_sc_hd__decap_3
XFILLER_7_662 VGND VGND VPWR VPWR sky130_fd_sc_hd__decap_3
XFILLER_128_365 VGND VGND VPWR VPWR sky130_fd_sc_hd__decap_3
XFILLER_7_695 VGND VGND VPWR VPWR sky130_fd_sc_hd__decap_3
X_6160_ _6160_/A1 _8405_/A _6159_/Y _6050_/A VGND VGND VPWR VPWR _6163_/B sky130_fd_sc_hd__a31o_2
XFILLER_40_3 VGND VGND VPWR VPWR sky130_fd_sc_hd__decap_3
XFILLER_69_113 VGND VGND VPWR VPWR sky130_fd_sc_hd__decap_3
X_5111_ _9257_/Q _9053_/Q _5384_/A VGND VGND VPWR VPWR _5111_/X sky130_fd_sc_hd__mux2_2
XFILLER_111_221 VGND VGND VPWR VPWR sky130_fd_sc_hd__decap_3
X_6091_ _6091_/A _6094_/B _5328_/B VGND VGND VPWR VPWR _6091_/X sky130_fd_sc_hd__or3b_2
XFILLER_85_617 VGND VGND VPWR VPWR sky130_fd_sc_hd__decap_3
X_5042_ _5042_/A _5042_/B VGND VGND VPWR VPWR _5045_/A sky130_fd_sc_hd__xnor2_2
XFILLER_97_488 VGND VGND VPWR VPWR sky130_fd_sc_hd__decap_3
XFILLER_78_680 VGND VGND VPWR VPWR sky130_fd_sc_hd__decap_3
XFILLER_38_511 VGND VGND VPWR VPWR sky130_fd_sc_hd__decap_3
XFILLER_111_287 VGND VGND VPWR VPWR sky130_fd_sc_hd__decap_3
XFILLER_84_138 VGND VGND VPWR VPWR sky130_fd_sc_hd__fill_2
XFILLER_38_533 VGND VGND VPWR VPWR sky130_fd_sc_hd__decap_3
XFILLER_38_555 VGND VGND VPWR VPWR sky130_fd_sc_hd__decap_3
XFILLER_93_661 VGND VGND VPWR VPWR sky130_fd_sc_hd__decap_3
XFILLER_53_503 VGND VGND VPWR VPWR sky130_fd_sc_hd__fill_1
X_8801_ _8969_/A VGND VGND VPWR VPWR _8812_/S sky130_fd_sc_hd__clkbuf_1
XFILLER_53_514 VGND VGND VPWR VPWR sky130_fd_sc_hd__decap_3
XFILLER_92_160 VGND VGND VPWR VPWR sky130_fd_sc_hd__decap_3
X_6993_ _6684_/A _6991_/Y _6992_/X VGND VGND VPWR VPWR _7056_/A sky130_fd_sc_hd__o21a_4
XFILLER_93_694 VGND VGND VPWR VPWR sky130_fd_sc_hd__decap_3
XFILLER_65_396 VGND VGND VPWR VPWR sky130_fd_sc_hd__decap_3
XFILLER_53_558 VGND VGND VPWR VPWR sky130_fd_sc_hd__fill_2
X_5944_ _6790_/A _5944_/B VGND VGND VPWR VPWR _5945_/B sky130_fd_sc_hd__xnor2_2
X_8732_ _9229_/Q _8732_/B _8731_/Y VGND VGND VPWR VPWR _8753_/B sky130_fd_sc_hd__nor3b_2
XFILLER_41_709 VGND VGND VPWR VPWR sky130_fd_sc_hd__decap_3
XTAP_TAPCELL_ROW_36_767 VGND VPWR sky130_fd_sc_hd__tapvpwrvgnd_1
XFILLER_40_219 VGND VGND VPWR VPWR sky130_fd_sc_hd__decap_3
XFILLER_34_772 VGND VGND VPWR VPWR sky130_fd_sc_hd__decap_3
X_8663_ _8700_/B _8666_/A _8666_/B _8659_/X _8662_/X VGND VGND VPWR VPWR _8663_/X
+ sky130_fd_sc_hd__a311o_2
XFILLER_80_388 VGND VGND VPWR VPWR sky130_fd_sc_hd__decap_3
X_5875_ _9108_/Q _5875_/B _5875_/C VGND VGND VPWR VPWR _5875_/X sky130_fd_sc_hd__and3_2
X_4826_ hold850/X hold864/X _4840_/S VGND VGND VPWR VPWR _4827_/A sky130_fd_sc_hd__mux2_2
X_7614_ _7614_/A _7614_/B VGND VGND VPWR VPWR _7619_/A sky130_fd_sc_hd__xnor2_2
XTAP_TAPCELL_ROW_16_491 VGND VPWR sky130_fd_sc_hd__tapvpwrvgnd_1
X_8594_ _9224_/Q _8566_/Y _8695_/B VGND VGND VPWR VPWR _8594_/Y sky130_fd_sc_hd__o21ai_2
XFILLER_21_477 VGND VGND VPWR VPWR sky130_fd_sc_hd__decap_3
X_7545_ _7689_/A _7545_/B VGND VGND VPWR VPWR _7547_/A sky130_fd_sc_hd__and2b_2
X_4757_ _4757_/A VGND VGND VPWR VPWR _9125_/D sky130_fd_sc_hd__buf_1
XFILLER_119_343 VGND VGND VPWR VPWR sky130_fd_sc_hd__decap_3
XFILLER_119_354 VGND VGND VPWR VPWR sky130_fd_sc_hd__fill_2
XFILLER_107_505 VGND VGND VPWR VPWR sky130_fd_sc_hd__decap_3
XFILLER_119_365 VGND VGND VPWR VPWR sky130_fd_sc_hd__decap_3
X_7476_ _7836_/A _8083_/B VGND VGND VPWR VPWR _7476_/Y sky130_fd_sc_hd__nor2_2
XFILLER_4_109 VGND VGND VPWR VPWR sky130_fd_sc_hd__decap_3
X_4688_ _4688_/A VGND VGND VPWR VPWR _9092_/D sky130_fd_sc_hd__buf_1
XFILLER_111_9 VGND VGND VPWR VPWR sky130_fd_sc_hd__decap_3
XFILLER_107_549 VGND VGND VPWR VPWR sky130_fd_sc_hd__decap_3
XFILLER_108_12 VGND VGND VPWR VPWR sky130_fd_sc_hd__decap_3
X_6427_ _6424_/X _6425_/X _6427_/S VGND VGND VPWR VPWR _6427_/X sky130_fd_sc_hd__mux2_4
X_9215_ _9215_/CLK _9215_/D load_slew420/X VGND VGND VPWR VPWR _9215_/Q sky130_fd_sc_hd__dfrtp_2
X_9146_ _9334_/CLK _9146_/D fanout400/X VGND VGND VPWR VPWR _9146_/Q sky130_fd_sc_hd__dfrtp_2
X_6358_ _9207_/Q _6680_/B _6224_/A _6224_/B VGND VGND VPWR VPWR _6358_/X sky130_fd_sc_hd__a22o_2
XFILLER_68_27 VGND VGND VPWR VPWR sky130_fd_sc_hd__fill_1
XFILLER_103_722 VGND VGND VPWR VPWR sky130_fd_sc_hd__decap_3
XFILLER_0_337 VGND VGND VPWR VPWR sky130_fd_sc_hd__decap_3
X_5309_ _5310_/A _5310_/B VGND VGND VPWR VPWR _5311_/A sky130_fd_sc_hd__nor2_2
X_9077_ _9313_/CLK _9077_/D fanout387/X VGND VGND VPWR VPWR _9077_/Q sky130_fd_sc_hd__dfrtp_2
X_6289_ _6290_/A _6289_/A2 _6203_/B VGND VGND VPWR VPWR _6291_/A sky130_fd_sc_hd__o21ai_2
XFILLER_0_359 VGND VGND VPWR VPWR sky130_fd_sc_hd__decap_3
X_8028_ _8028_/A VGND VGND VPWR VPWR _8028_/Y sky130_fd_sc_hd__inv_2
XFILLER_88_488 VGND VGND VPWR VPWR sky130_fd_sc_hd__decap_3
XFILLER_76_639 VGND VGND VPWR VPWR sky130_fd_sc_hd__decap_3
XFILLER_130_585 VGND VGND VPWR VPWR sky130_fd_sc_hd__decap_3
XFILLER_69_680 VGND VGND VPWR VPWR sky130_fd_sc_hd__fill_1
XFILLER_29_511 VGND VGND VPWR VPWR sky130_fd_sc_hd__decap_3
XFILLER_124_44 VGND VGND VPWR VPWR sky130_fd_sc_hd__decap_3
XFILLER_102_298 VGND VGND VPWR VPWR sky130_fd_sc_hd__fill_1
XFILLER_69_691 VGND VGND VPWR VPWR sky130_fd_sc_hd__decap_3
XFILLER_84_26 VGND VGND VPWR VPWR sky130_fd_sc_hd__fill_2
XFILLER_124_77 VGND VGND VPWR VPWR sky130_fd_sc_hd__decap_3
XFILLER_75_149 VGND VGND VPWR VPWR sky130_fd_sc_hd__fill_2
XFILLER_124_88 VGND VGND VPWR VPWR sky130_fd_sc_hd__decap_3
XFILLER_91_609 VGND VGND VPWR VPWR sky130_fd_sc_hd__decap_3
XFILLER_84_37 VGND VGND VPWR VPWR sky130_fd_sc_hd__fill_2
XFILLER_56_341 VGND VGND VPWR VPWR sky130_fd_sc_hd__decap_3
XFILLER_44_503 VGND VGND VPWR VPWR sky130_fd_sc_hd__decap_3
XFILLER_56_374 VGND VGND VPWR VPWR sky130_fd_sc_hd__decap_3
XFILLER_17_42 VGND VGND VPWR VPWR sky130_fd_sc_hd__decap_3
XFILLER_44_536 VGND VGND VPWR VPWR sky130_fd_sc_hd__decap_3
XFILLER_16_238 VGND VGND VPWR VPWR sky130_fd_sc_hd__decap_3
XFILLER_44_558 VGND VGND VPWR VPWR sky130_fd_sc_hd__decap_3
XTAP_TAPCELL_ROW_123_1943 VGND VPWR sky130_fd_sc_hd__tapvpwrvgnd_1
XFILLER_32_709 VGND VGND VPWR VPWR sky130_fd_sc_hd__decap_3
XFILLER_25_750 VGND VGND VPWR VPWR sky130_fd_sc_hd__decap_3
XFILLER_31_219 VGND VGND VPWR VPWR sky130_fd_sc_hd__decap_3
XFILLER_24_271 VGND VGND VPWR VPWR sky130_fd_sc_hd__decap_3
XFILLER_33_41 VGND VGND VPWR VPWR sky130_fd_sc_hd__decap_3
XFILLER_8_404 VGND VGND VPWR VPWR sky130_fd_sc_hd__decap_3
XFILLER_33_63 VGND VGND VPWR VPWR sky130_fd_sc_hd__decap_3
XFILLER_40_775 VGND VGND VPWR VPWR sky130_fd_sc_hd__fill_2
XFILLER_12_477 VGND VGND VPWR VPWR sky130_fd_sc_hd__fill_2
XFILLER_33_85 VGND VGND VPWR VPWR sky130_fd_sc_hd__fill_1
XFILLER_125_335 VGND VGND VPWR VPWR sky130_fd_sc_hd__fill_1
XFILLER_125_346 VGND VGND VPWR VPWR sky130_fd_sc_hd__fill_2
XFILLER_3_131 VGND VGND VPWR VPWR sky130_fd_sc_hd__fill_1
XFILLER_125_368 VGND VGND VPWR VPWR sky130_fd_sc_hd__decap_3
XFILLER_113_508 VGND VGND VPWR VPWR sky130_fd_sc_hd__decap_3
XFILLER_4_676 VGND VGND VPWR VPWR sky130_fd_sc_hd__decap_3
XFILLER_79_411 VGND VGND VPWR VPWR sky130_fd_sc_hd__decap_3
XFILLER_67_639 VGND VGND VPWR VPWR sky130_fd_sc_hd__fill_1
XFILLER_94_436 VGND VGND VPWR VPWR sky130_fd_sc_hd__decap_3
XFILLER_94_458 VGND VGND VPWR VPWR sky130_fd_sc_hd__decap_3
XFILLER_47_363 VGND VGND VPWR VPWR sky130_fd_sc_hd__decap_3
XFILLER_75_683 VGND VGND VPWR VPWR sky130_fd_sc_hd__fill_2
XTAP_TAPCELL_ROW_85_1426 VGND VPWR sky130_fd_sc_hd__tapvpwrvgnd_1
XFILLER_47_396 VGND VGND VPWR VPWR sky130_fd_sc_hd__decap_3
XFILLER_90_642 VGND VGND VPWR VPWR sky130_fd_sc_hd__fill_2
XFILLER_62_333 VGND VGND VPWR VPWR sky130_fd_sc_hd__fill_2
XFILLER_35_547 VGND VGND VPWR VPWR sky130_fd_sc_hd__decap_3
XFILLER_74_81 VGND VGND VPWR VPWR sky130_fd_sc_hd__decap_3
XFILLER_62_355 VGND VGND VPWR VPWR sky130_fd_sc_hd__decap_3
XFILLER_90_686 VGND VGND VPWR VPWR sky130_fd_sc_hd__decap_3
XFILLER_62_377 VGND VGND VPWR VPWR sky130_fd_sc_hd__decap_3
XFILLER_22_208 VGND VGND VPWR VPWR sky130_fd_sc_hd__decap_3
XFILLER_16_772 VGND VGND VPWR VPWR sky130_fd_sc_hd__decap_3
XFILLER_50_528 VGND VGND VPWR VPWR sky130_fd_sc_hd__fill_1
XTAP_TAPCELL_ROW_33_726 VGND VPWR sky130_fd_sc_hd__tapvpwrvgnd_1
XFILLER_43_591 VGND VGND VPWR VPWR sky130_fd_sc_hd__decap_3
X_5660_ _5949_/B _5658_/X _5659_/Y _5319_/Y VGND VGND VPWR VPWR _5661_/B sky130_fd_sc_hd__a22o_2
XFILLER_31_775 VGND VGND VPWR VPWR sky130_fd_sc_hd__fill_2
XFILLER_90_80 VGND VGND VPWR VPWR sky130_fd_sc_hd__decap_3
X_4611_ _9056_/Q hold865/X _4629_/S VGND VGND VPWR VPWR _4611_/X sky130_fd_sc_hd__mux2_2
XFILLER_90_91 VGND VGND VPWR VPWR sky130_fd_sc_hd__decap_3
XTAP_TAPCELL_ROW_13_461 VGND VPWR sky130_fd_sc_hd__tapvpwrvgnd_1
XFILLER_30_274 VGND VGND VPWR VPWR sky130_fd_sc_hd__decap_3
X_5591_ _5591_/A _5591_/B VGND VGND VPWR VPWR _5760_/C sky130_fd_sc_hd__nand2_2
XFILLER_129_641 VGND VGND VPWR VPWR sky130_fd_sc_hd__decap_3
X_7330_ _7330_/A1 _7416_/B _7328_/X _7329_/X VGND VGND VPWR VPWR _7443_/B sky130_fd_sc_hd__a31o_2
X_4542_ _4577_/A1 _4542_/A1 _4544_/S VGND VGND VPWR VPWR _4543_/A sky130_fd_sc_hd__mux2_2
XFILLER_129_685 VGND VGND VPWR VPWR sky130_fd_sc_hd__decap_3
XFILLER_128_162 VGND VGND VPWR VPWR sky130_fd_sc_hd__decap_3
Xmax_cap101 _5167_/B VGND VGND VPWR VPWR _7407_/A sky130_fd_sc_hd__buf_2
Xmax_cap112 _7096_/A VGND VGND VPWR VPWR _5855_/A sky130_fd_sc_hd__buf_4
X_7261_ _7510_/B VGND VGND VPWR VPWR _7261_/Y sky130_fd_sc_hd__inv_2
XFILLER_128_195 VGND VGND VPWR VPWR sky130_fd_sc_hd__fill_1
XTAP_TAPCELL_ROW_96_1577 VGND VPWR sky130_fd_sc_hd__tapvpwrvgnd_1
Xmax_cap134 max_cap135/X VGND VGND VPWR VPWR _5137_/A sky130_fd_sc_hd__clkbuf_2
X_9000_ _9000_/A VGND VGND VPWR VPWR _9340_/D sky130_fd_sc_hd__buf_1
XFILLER_116_368 VGND VGND VPWR VPWR sky130_fd_sc_hd__decap_3
X_6212_ _6212_/A _6212_/B VGND VGND VPWR VPWR _6366_/B sky130_fd_sc_hd__xnor2_2
Xmax_cap167 _6963_/C VGND VGND VPWR VPWR _6196_/B sky130_fd_sc_hd__buf_4
X_7192_ _7243_/B _7192_/B VGND VGND VPWR VPWR _7193_/B sky130_fd_sc_hd__xnor2_2
Xmax_cap178 _5345_/A VGND VGND VPWR VPWR _7114_/C sky130_fd_sc_hd__buf_2
Xmax_cap189 _4952_/Y VGND VGND VPWR VPWR _5627_/B sky130_fd_sc_hd__buf_6
XPHY_EDGE_ROW_115_Right_115 VGND VGND VPWR VPWR sky130_fd_sc_hd__decap_3
XFILLER_98_742 VGND VGND VPWR VPWR sky130_fd_sc_hd__decap_3
X_6143_ _6143_/A _6143_/B VGND VGND VPWR VPWR _6145_/B sky130_fd_sc_hd__or2_2
XFILLER_124_390 VGND VGND VPWR VPWR sky130_fd_sc_hd__fill_1
Xload_slew351 _6807_/A VGND VGND VPWR VPWR _5538_/A sky130_fd_sc_hd__buf_4
XFILLER_112_574 VGND VGND VPWR VPWR sky130_fd_sc_hd__decap_3
X_6074_ _5967_/A _5966_/A _5965_/X VGND VGND VPWR VPWR _6074_/X sky130_fd_sc_hd__o21a_4
Xload_slew362 _5940_/A1 VGND VGND VPWR VPWR rebuffer655/A sky130_fd_sc_hd__buf_6
Xhold1104 _4672_/X VGND VGND VPWR VPWR _4673_/A sky130_fd_sc_hd__dlygate4sd3_1
XFILLER_85_425 VGND VGND VPWR VPWR sky130_fd_sc_hd__decap_3
XFILLER_58_639 VGND VGND VPWR VPWR sky130_fd_sc_hd__decap_3
Xhold1115 _9340_/Q VGND VGND VPWR VPWR _4542_/A1 sky130_fd_sc_hd__dlygate4sd3_1
Xload_slew384 fanout383/X VGND VGND VPWR VPWR load_slew384/X sky130_fd_sc_hd__clkbuf_4
Xhold1126 _4636_/X VGND VGND VPWR VPWR _4637_/A sky130_fd_sc_hd__dlygate4sd3_1
XFILLER_97_296 VGND VGND VPWR VPWR sky130_fd_sc_hd__decap_3
Xhold1137 _9077_/Q VGND VGND VPWR VPWR _4689_/A1 sky130_fd_sc_hd__dlygate4sd3_1
XFILLER_85_447 VGND VGND VPWR VPWR sky130_fd_sc_hd__fill_1
X_5025_ _5197_/A _5106_/A1 _4914_/Y _4916_/X _6302_/A VGND VGND VPWR VPWR _6942_/A
+ sky130_fd_sc_hd__a311o_2
Xhold1148 _9155_/Q VGND VGND VPWR VPWR _4819_/A0 sky130_fd_sc_hd__dlygate4sd3_1
XFILLER_85_469 VGND VGND VPWR VPWR sky130_fd_sc_hd__fill_1
Xhold1159 _9338_/Q VGND VGND VPWR VPWR _4538_/A1 sky130_fd_sc_hd__dlygate4sd3_1
XFILLER_38_352 VGND VGND VPWR VPWR sky130_fd_sc_hd__decap_3
XFILLER_26_514 VGND VGND VPWR VPWR sky130_fd_sc_hd__decap_3
XFILLER_38_374 VGND VGND VPWR VPWR sky130_fd_sc_hd__decap_3
XFILLER_66_694 VGND VGND VPWR VPWR sky130_fd_sc_hd__decap_3
XFILLER_93_491 VGND VGND VPWR VPWR sky130_fd_sc_hd__decap_3
XFILLER_38_396 VGND VGND VPWR VPWR sky130_fd_sc_hd__decap_3
XFILLER_26_536 VGND VGND VPWR VPWR sky130_fd_sc_hd__fill_2
XFILLER_54_29 VGND VGND VPWR VPWR sky130_fd_sc_hd__decap_3
XFILLER_80_130 VGND VGND VPWR VPWR sky130_fd_sc_hd__fill_2
XFILLER_80_141 VGND VGND VPWR VPWR sky130_fd_sc_hd__decap_3
X_6976_ _6976_/A _6976_/B _6976_/C VGND VGND VPWR VPWR _6976_/X sky130_fd_sc_hd__and3_2
XFILLER_53_366 VGND VGND VPWR VPWR sky130_fd_sc_hd__decap_3
XFILLER_41_517 VGND VGND VPWR VPWR sky130_fd_sc_hd__decap_3
XFILLER_13_219 VGND VGND VPWR VPWR sky130_fd_sc_hd__decap_3
X_8715_ _8715_/A VGND VGND VPWR VPWR _8715_/Y sky130_fd_sc_hd__inv_2
XFILLER_110_24 VGND VGND VPWR VPWR sky130_fd_sc_hd__decap_3
X_5927_ _6868_/A _8020_/A _5930_/C VGND VGND VPWR VPWR _5927_/X sky130_fd_sc_hd__mux2_2
XFILLER_53_399 VGND VGND VPWR VPWR sky130_fd_sc_hd__decap_3
XFILLER_110_35 VGND VGND VPWR VPWR sky130_fd_sc_hd__decap_3
XFILLER_22_731 VGND VGND VPWR VPWR sky130_fd_sc_hd__decap_3
XTAP_TAPCELL_ROW_105_1695 VGND VPWR sky130_fd_sc_hd__tapvpwrvgnd_1
X_5858_ _5858_/A wire76/X VGND VGND VPWR VPWR _5859_/B sky130_fd_sc_hd__xnor2_2
X_8646_ _8649_/B _8643_/X _8649_/C _8516_/Y _8674_/A VGND VGND VPWR VPWR _8646_/X
+ sky130_fd_sc_hd__a221o_2
XFILLER_22_775 VGND VGND VPWR VPWR sky130_fd_sc_hd__fill_2
XFILLER_21_263 VGND VGND VPWR VPWR sky130_fd_sc_hd__decap_3
X_4809_ _9150_/Q hold843/X _4819_/S VGND VGND VPWR VPWR _4809_/X sky130_fd_sc_hd__mux2_2
Xrebuffer501 _7098_/C VGND VGND VPWR VPWR _7093_/A sky130_fd_sc_hd__buf_4
XFILLER_21_274 VGND VGND VPWR VPWR sky130_fd_sc_hd__decap_3
XPHY_EDGE_ROW_17_Right_17 VGND VGND VPWR VPWR sky130_fd_sc_hd__decap_3
X_5789_ input3/X _5789_/B VGND VGND VPWR VPWR _5791_/B sky130_fd_sc_hd__xnor2_2
X_8577_ _8578_/A _8578_/B VGND VGND VPWR VPWR _8577_/Y sky130_fd_sc_hd__nor2_2
Xrebuffer512 _5249_/A VGND VGND VPWR VPWR _7412_/A1 sky130_fd_sc_hd__buf_2
Xrebuffer523 _7489_/A VGND VGND VPWR VPWR _7487_/A sky130_fd_sc_hd__buf_2
Xrebuffer534 _6363_/A VGND VGND VPWR VPWR _6535_/A sky130_fd_sc_hd__buf_2
Xrebuffer545 _6924_/C VGND VGND VPWR VPWR _6910_/B sky130_fd_sc_hd__buf_2
X_7528_ _6406_/B _5503_/C _7525_/B _7527_/X _7528_/B2 VGND VGND VPWR VPWR _7528_/X
+ sky130_fd_sc_hd__o32a_2
Xrebuffer556 _7033_/X VGND VGND VPWR VPWR _7132_/C1 sky130_fd_sc_hd__buf_2
XFILLER_119_33 VGND VGND VPWR VPWR sky130_fd_sc_hd__decap_3
XFILLER_119_162 VGND VGND VPWR VPWR sky130_fd_sc_hd__decap_3
Xrebuffer567 _7571_/A VGND VGND VPWR VPWR _6619_/B sky130_fd_sc_hd__buf_2
Xrebuffer578 _6363_/C VGND VGND VPWR VPWR _6533_/A1 sky130_fd_sc_hd__buf_2
XFILLER_119_66 VGND VGND VPWR VPWR sky130_fd_sc_hd__decap_3
XFILLER_119_184 VGND VGND VPWR VPWR sky130_fd_sc_hd__decap_3
Xrebuffer589 _5145_/A VGND VGND VPWR VPWR _6939_/A sky130_fd_sc_hd__buf_2
X_7459_ _7458_/B _7458_/C _7458_/A VGND VGND VPWR VPWR _7626_/D sky130_fd_sc_hd__a21oi_2
XFILLER_107_357 VGND VGND VPWR VPWR sky130_fd_sc_hd__decap_3
XFILLER_119_99 VGND VGND VPWR VPWR sky130_fd_sc_hd__decap_3
XFILLER_107_379 VGND VGND VPWR VPWR sky130_fd_sc_hd__decap_3
XTAP_TAPCELL_ROW_56_1038 VGND VPWR sky130_fd_sc_hd__tapvpwrvgnd_1
XFILLER_122_316 VGND VGND VPWR VPWR sky130_fd_sc_hd__decap_3
Xhold960 _9268_/Q VGND VGND VPWR VPWR hold960/X sky130_fd_sc_hd__dlygate4sd3_1
XFILLER_0_101 VGND VGND VPWR VPWR sky130_fd_sc_hd__decap_3
Xhold971 _8890_/X VGND VGND VPWR VPWR _8891_/A sky130_fd_sc_hd__dlygate4sd3_1
Xhold982 _8873_/X VGND VGND VPWR VPWR _8874_/A sky130_fd_sc_hd__dlygate4sd3_1
XFILLER_1_635 VGND VGND VPWR VPWR sky130_fd_sc_hd__decap_3
Xhold993 _9176_/Q VGND VGND VPWR VPWR hold993/X sky130_fd_sc_hd__dlygate4sd3_1
X_9129_ _9317_/CLK _9129_/D wire406/X VGND VGND VPWR VPWR _9129_/Q sky130_fd_sc_hd__dfrtp_2
XFILLER_103_541 VGND VGND VPWR VPWR sky130_fd_sc_hd__decap_3
XFILLER_1_668 VGND VGND VPWR VPWR sky130_fd_sc_hd__decap_3
XFILLER_0_156 VGND VGND VPWR VPWR sky130_fd_sc_hd__decap_3
XFILLER_49_617 VGND VGND VPWR VPWR sky130_fd_sc_hd__decap_3
XFILLER_1_679 VGND VGND VPWR VPWR sky130_fd_sc_hd__decap_3
XPHY_EDGE_ROW_26_Right_26 VGND VGND VPWR VPWR sky130_fd_sc_hd__decap_3
XFILLER_103_596 VGND VGND VPWR VPWR sky130_fd_sc_hd__decap_3
XFILLER_130_393 VGND VGND VPWR VPWR sky130_fd_sc_hd__fill_2
XFILLER_64_609 VGND VGND VPWR VPWR sky130_fd_sc_hd__decap_3
XFILLER_76_469 VGND VGND VPWR VPWR sky130_fd_sc_hd__decap_3
XFILLER_57_650 VGND VGND VPWR VPWR sky130_fd_sc_hd__decap_3
XFILLER_91_417 VGND VGND VPWR VPWR sky130_fd_sc_hd__decap_3
XFILLER_28_74 VGND VGND VPWR VPWR sky130_fd_sc_hd__decap_3
XFILLER_29_374 VGND VGND VPWR VPWR sky130_fd_sc_hd__decap_3
XFILLER_28_85 VGND VGND VPWR VPWR sky130_fd_sc_hd__decap_3
XFILLER_17_514 VGND VGND VPWR VPWR sky130_fd_sc_hd__decap_3
XFILLER_72_664 VGND VGND VPWR VPWR sky130_fd_sc_hd__decap_3
XTAP_TAPCELL_ROW_67_1189 VGND VPWR sky130_fd_sc_hd__tapvpwrvgnd_1
XFILLER_44_51 VGND VGND VPWR VPWR sky130_fd_sc_hd__decap_3
XFILLER_13_753 VGND VGND VPWR VPWR sky130_fd_sc_hd__decap_3
XTAP_TAPCELL_ROW_80_1356 VGND VPWR sky130_fd_sc_hd__tapvpwrvgnd_1
XPHY_EDGE_ROW_35_Right_35 VGND VGND VPWR VPWR sky130_fd_sc_hd__decap_3
XTAP_TAPCELL_ROW_80_1367 VGND VPWR sky130_fd_sc_hd__tapvpwrvgnd_1
XFILLER_9_724 VGND VGND VPWR VPWR sky130_fd_sc_hd__decap_3
XFILLER_9_735 VGND VGND VPWR VPWR sky130_fd_sc_hd__decap_3
XFILLER_12_274 VGND VGND VPWR VPWR sky130_fd_sc_hd__fill_2
XFILLER_9_768 VGND VGND VPWR VPWR sky130_fd_sc_hd__decap_3
XFILLER_8_245 VGND VGND VPWR VPWR sky130_fd_sc_hd__decap_3
XFILLER_74_9 VGND VGND VPWR VPWR sky130_fd_sc_hd__decap_3
XTAP_TAPCELL_ROW_10_420 VGND VPWR sky130_fd_sc_hd__tapvpwrvgnd_1
XFILLER_8_256 VGND VGND VPWR VPWR sky130_fd_sc_hd__decap_3
XFILLER_126_600 VGND VGND VPWR VPWR sky130_fd_sc_hd__decap_3
XFILLER_8_289 VGND VGND VPWR VPWR sky130_fd_sc_hd__decap_3
XFILLER_60_94 VGND VGND VPWR VPWR sky130_fd_sc_hd__decap_3
XFILLER_126_633 VGND VGND VPWR VPWR sky130_fd_sc_hd__decap_3
XFILLER_5_12 VGND VGND VPWR VPWR sky130_fd_sc_hd__decap_3
XFILLER_126_666 VGND VGND VPWR VPWR sky130_fd_sc_hd__decap_3
XFILLER_125_143 VGND VGND VPWR VPWR sky130_fd_sc_hd__decap_3
XFILLER_99_517 VGND VGND VPWR VPWR sky130_fd_sc_hd__decap_3
XFILLER_5_45 VGND VGND VPWR VPWR sky130_fd_sc_hd__decap_3
XFILLER_4_451 VGND VGND VPWR VPWR sky130_fd_sc_hd__decap_3
XFILLER_126_699 VGND VGND VPWR VPWR sky130_fd_sc_hd__fill_1
XFILLER_99_539 VGND VGND VPWR VPWR sky130_fd_sc_hd__decap_3
XFILLER_5_78 VGND VGND VPWR VPWR sky130_fd_sc_hd__fill_2
XFILLER_125_187 VGND VGND VPWR VPWR sky130_fd_sc_hd__decap_3
XFILLER_5_89 VGND VGND VPWR VPWR sky130_fd_sc_hd__fill_2
XPHY_EDGE_ROW_44_Right_44 VGND VGND VPWR VPWR sky130_fd_sc_hd__decap_3
XFILLER_79_241 VGND VGND VPWR VPWR sky130_fd_sc_hd__decap_3
XFILLER_67_458 VGND VGND VPWR VPWR sky130_fd_sc_hd__fill_1
XFILLER_67_469 VGND VGND VPWR VPWR sky130_fd_sc_hd__fill_1
XFILLER_48_661 VGND VGND VPWR VPWR sky130_fd_sc_hd__decap_3
XFILLER_63_620 VGND VGND VPWR VPWR sky130_fd_sc_hd__decap_3
XFILLER_75_491 VGND VGND VPWR VPWR sky130_fd_sc_hd__decap_3
XTAP_TAPCELL_ROW_18_520 VGND VPWR sky130_fd_sc_hd__tapvpwrvgnd_1
XTAP_TAPCELL_ROW_18_531 VGND VPWR sky130_fd_sc_hd__tapvpwrvgnd_1
X_6830_ _7179_/A _6870_/A VGND VGND VPWR VPWR _6880_/B sky130_fd_sc_hd__xnor2_2
XFILLER_35_355 VGND VGND VPWR VPWR sky130_fd_sc_hd__decap_3
XFILLER_62_141 VGND VGND VPWR VPWR sky130_fd_sc_hd__decap_3
XFILLER_90_461 VGND VGND VPWR VPWR sky130_fd_sc_hd__decap_3
XFILLER_50_303 VGND VGND VPWR VPWR sky130_fd_sc_hd__decap_3
X_6761_ _9285_/Q _5065_/X _5126_/X _9145_/Q VGND VGND VPWR VPWR _6762_/D sky130_fd_sc_hd__a22oi_2
XFILLER_90_483 VGND VGND VPWR VPWR sky130_fd_sc_hd__decap_3
XPHY_EDGE_ROW_53_Right_53 VGND VGND VPWR VPWR sky130_fd_sc_hd__decap_3
X_5712_ _5356_/A _5707_/Y _7071_/D _5711_/Y _7096_/A VGND VGND VPWR VPWR _5712_/X
+ sky130_fd_sc_hd__a221o_2
X_8500_ _8547_/B _8500_/B VGND VGND VPWR VPWR _8501_/B sky130_fd_sc_hd__xnor2_2
X_6692_ _6692_/A _6692_/B VGND VGND VPWR VPWR _6926_/A sky130_fd_sc_hd__or2_4
XFILLER_31_561 VGND VGND VPWR VPWR sky130_fd_sc_hd__fill_2
XTAP_TAPCELL_ROW_98_1606 VGND VPWR sky130_fd_sc_hd__tapvpwrvgnd_1
X_5643_ _5773_/C _5643_/B VGND VGND VPWR VPWR _5644_/B sky130_fd_sc_hd__or2_2
X_8431_ _8431_/A _8431_/B VGND VGND VPWR VPWR _8467_/A sky130_fd_sc_hd__nor2_2
XFILLER_31_583 VGND VGND VPWR VPWR sky130_fd_sc_hd__decap_3
XPHY_EDGE_ROW_28_Left_159 VGND VGND VPWR VPWR sky130_fd_sc_hd__decap_3
X_8362_ _8441_/B _8367_/B _8361_/Y VGND VGND VPWR VPWR _8362_/X sky130_fd_sc_hd__o21ba_2
X_5574_ _5048_/B _5571_/X _5573_/X VGND VGND VPWR VPWR _5768_/B sky130_fd_sc_hd__o21a_2
X_7313_ _7313_/A _7313_/B _7313_/C VGND VGND VPWR VPWR _7313_/X sky130_fd_sc_hd__and3_2
X_4525_ _8210_/B _6758_/B _6757_/B VGND VGND VPWR VPWR _4526_/A sky130_fd_sc_hd__and3_2
XFILLER_116_121 VGND VGND VPWR VPWR sky130_fd_sc_hd__fill_2
X_8293_ _8299_/B VGND VGND VPWR VPWR _8293_/Y sky130_fd_sc_hd__inv_2
X_7244_ _8009_/A _7244_/B VGND VGND VPWR VPWR _7244_/Y sky130_fd_sc_hd__nand2_2
XFILLER_117_699 VGND VGND VPWR VPWR sky130_fd_sc_hd__decap_3
XPHY_EDGE_ROW_62_Right_62 VGND VGND VPWR VPWR sky130_fd_sc_hd__decap_3
X_7175_ _7867_/A _7229_/B VGND VGND VPWR VPWR _7176_/B sky130_fd_sc_hd__xnor2_2
XFILLER_86_701 VGND VGND VPWR VPWR sky130_fd_sc_hd__decap_3
X_6126_ _6126_/A _6126_/B VGND VGND VPWR VPWR _6137_/A sky130_fd_sc_hd__xnor2_2
XFILLER_98_583 VGND VGND VPWR VPWR sky130_fd_sc_hd__decap_3
XFILLER_85_200 VGND VGND VPWR VPWR sky130_fd_sc_hd__decap_3
XFILLER_100_522 VGND VGND VPWR VPWR sky130_fd_sc_hd__decap_3
XPHY_EDGE_ROW_0_Left_131 VGND VGND VPWR VPWR sky130_fd_sc_hd__decap_3
XFILLER_58_436 VGND VGND VPWR VPWR sky130_fd_sc_hd__decap_3
XFILLER_100_533 VGND VGND VPWR VPWR sky130_fd_sc_hd__decap_3
XPHY_EDGE_ROW_37_Left_168 VGND VGND VPWR VPWR sky130_fd_sc_hd__decap_3
X_6057_ _6057_/A _6057_/B wire62/X VGND VGND VPWR VPWR _6057_/X sky130_fd_sc_hd__and3_2
XFILLER_39_650 VGND VGND VPWR VPWR sky130_fd_sc_hd__decap_3
X_5008_ _9335_/Q _5002_/X _5003_/X _5006_/X _5007_/X VGND VGND VPWR VPWR _5103_/B
+ sky130_fd_sc_hd__a2111o_2
XFILLER_73_428 VGND VGND VPWR VPWR sky130_fd_sc_hd__decap_3
XFILLER_45_119 VGND VGND VPWR VPWR sky130_fd_sc_hd__decap_3
XFILLER_39_683 VGND VGND VPWR VPWR sky130_fd_sc_hd__decap_3
XTAP_TAPCELL_ROW_107_1724 VGND VPWR sky130_fd_sc_hd__tapvpwrvgnd_1
XFILLER_66_480 VGND VGND VPWR VPWR sky130_fd_sc_hd__decap_3
XFILLER_54_642 VGND VGND VPWR VPWR sky130_fd_sc_hd__fill_2
XFILLER_121_12 VGND VGND VPWR VPWR sky130_fd_sc_hd__decap_3
XFILLER_38_193 VGND VGND VPWR VPWR sky130_fd_sc_hd__decap_3
XFILLER_26_344 VGND VGND VPWR VPWR sky130_fd_sc_hd__decap_3
XFILLER_54_664 VGND VGND VPWR VPWR sky130_fd_sc_hd__decap_3
XPHY_EDGE_ROW_71_Right_71 VGND VGND VPWR VPWR sky130_fd_sc_hd__decap_3
XFILLER_121_45 VGND VGND VPWR VPWR sky130_fd_sc_hd__decap_3
XFILLER_26_377 VGND VGND VPWR VPWR sky130_fd_sc_hd__decap_3
XTAP_TAPCELL_ROW_120_1902 VGND VPWR sky130_fd_sc_hd__tapvpwrvgnd_1
XFILLER_14_528 VGND VGND VPWR VPWR sky130_fd_sc_hd__decap_3
XFILLER_81_483 VGND VGND VPWR VPWR sky130_fd_sc_hd__decap_3
XFILLER_121_78 VGND VGND VPWR VPWR sky130_fd_sc_hd__decap_3
X_6959_ _6196_/B _7430_/B _7071_/D _5897_/D VGND VGND VPWR VPWR _6960_/B sky130_fd_sc_hd__o211a_2
XFILLER_14_21 VGND VGND VPWR VPWR sky130_fd_sc_hd__decap_3
XFILLER_22_550 VGND VGND VPWR VPWR sky130_fd_sc_hd__decap_3
XFILLER_10_701 VGND VGND VPWR VPWR sky130_fd_sc_hd__decap_3
XPHY_EDGE_ROW_46_Left_177 VGND VGND VPWR VPWR sky130_fd_sc_hd__decap_3
X_8629_ _8625_/Y _8642_/A _8627_/Y _8628_/X _8674_/A VGND VGND VPWR VPWR _8629_/X
+ sky130_fd_sc_hd__a32o_2
XFILLER_10_734 VGND VGND VPWR VPWR sky130_fd_sc_hd__decap_3
XFILLER_6_716 VGND VGND VPWR VPWR sky130_fd_sc_hd__decap_3
XFILLER_108_622 VGND VGND VPWR VPWR sky130_fd_sc_hd__fill_1
XFILLER_6_749 VGND VGND VPWR VPWR sky130_fd_sc_hd__decap_3
XFILLER_5_237 VGND VGND VPWR VPWR sky130_fd_sc_hd__decap_3
XTAP_TAPCELL_ROW_118_1875 VGND VPWR sky130_fd_sc_hd__tapvpwrvgnd_1
XFILLER_108_666 VGND VGND VPWR VPWR sky130_fd_sc_hd__decap_3
XPHY_EDGE_ROW_80_Right_80 VGND VGND VPWR VPWR sky130_fd_sc_hd__decap_3
XFILLER_107_154 VGND VGND VPWR VPWR sky130_fd_sc_hd__decap_3
XFILLER_123_603 VGND VGND VPWR VPWR sky130_fd_sc_hd__decap_3
XFILLER_123_625 VGND VGND VPWR VPWR sky130_fd_sc_hd__decap_3
XFILLER_122_124 VGND VGND VPWR VPWR sky130_fd_sc_hd__decap_3
XFILLER_1_432 VGND VGND VPWR VPWR sky130_fd_sc_hd__decap_3
XFILLER_96_509 VGND VGND VPWR VPWR sky130_fd_sc_hd__decap_3
Xhold790 _4886_/X VGND VGND VPWR VPWR _9183_/D sky130_fd_sc_hd__dlygate4sd3_1
XFILLER_89_561 VGND VGND VPWR VPWR sky130_fd_sc_hd__fill_2
XFILLER_77_712 VGND VGND VPWR VPWR sky130_fd_sc_hd__decap_3
XFILLER_49_403 VGND VGND VPWR VPWR sky130_fd_sc_hd__decap_3
XFILLER_122_168 VGND VGND VPWR VPWR sky130_fd_sc_hd__decap_3
XPHY_EDGE_ROW_55_Left_186 VGND VGND VPWR VPWR sky130_fd_sc_hd__decap_3
XFILLER_89_583 VGND VGND VPWR VPWR sky130_fd_sc_hd__decap_3
XFILLER_103_393 VGND VGND VPWR VPWR sky130_fd_sc_hd__decap_3
XFILLER_39_84 VGND VGND VPWR VPWR sky130_fd_sc_hd__decap_3
XFILLER_37_609 VGND VGND VPWR VPWR sky130_fd_sc_hd__decap_3
XFILLER_130_190 VGND VGND VPWR VPWR sky130_fd_sc_hd__decap_3
XTAP_TAPCELL_ROW_69_1207 VGND VPWR sky130_fd_sc_hd__tapvpwrvgnd_1
XFILLER_92_715 VGND VGND VPWR VPWR sky130_fd_sc_hd__decap_3
XTAP_TAPCELL_ROW_69_1218 VGND VPWR sky130_fd_sc_hd__tapvpwrvgnd_1
XFILLER_29_160 VGND VGND VPWR VPWR sky130_fd_sc_hd__decap_3
XFILLER_91_225 VGND VGND VPWR VPWR sky130_fd_sc_hd__fill_1
XFILLER_45_620 VGND VGND VPWR VPWR sky130_fd_sc_hd__decap_3
XFILLER_44_141 VGND VGND VPWR VPWR sky130_fd_sc_hd__decap_3
XFILLER_72_461 VGND VGND VPWR VPWR sky130_fd_sc_hd__decap_3
XFILLER_72_483 VGND VGND VPWR VPWR sky130_fd_sc_hd__decap_3
XFILLER_44_174 VGND VGND VPWR VPWR sky130_fd_sc_hd__decap_3
XFILLER_60_645 VGND VGND VPWR VPWR sky130_fd_sc_hd__decap_3
XPHY_EDGE_ROW_64_Left_195 VGND VGND VPWR VPWR sky130_fd_sc_hd__decap_3
XFILLER_32_358 VGND VGND VPWR VPWR sky130_fd_sc_hd__decap_3
XTAP_TAPCELL_ROW_43_865 VGND VPWR sky130_fd_sc_hd__tapvpwrvgnd_1
XFILLER_13_561 VGND VGND VPWR VPWR sky130_fd_sc_hd__fill_2
XFILLER_9_543 VGND VGND VPWR VPWR sky130_fd_sc_hd__decap_3
XFILLER_118_419 VGND VGND VPWR VPWR sky130_fd_sc_hd__fill_1
XTAP_TAPCELL_ROW_93_1536 VGND VPWR sky130_fd_sc_hd__tapvpwrvgnd_1
XFILLER_126_474 VGND VGND VPWR VPWR sky130_fd_sc_hd__fill_2
X_5290_ _6206_/C _5197_/Y _5199_/X _5283_/A VGND VGND VPWR VPWR _5707_/A sky130_fd_sc_hd__a211oi_2
XFILLER_113_124 VGND VGND VPWR VPWR sky130_fd_sc_hd__fill_2
XFILLER_113_135 VGND VGND VPWR VPWR sky130_fd_sc_hd__decap_3
XFILLER_95_553 VGND VGND VPWR VPWR sky130_fd_sc_hd__decap_3
XFILLER_121_190 VGND VGND VPWR VPWR sky130_fd_sc_hd__decap_3
X_8980_ _9331_/Q hold991/X _8988_/S VGND VGND VPWR VPWR _8980_/X sky130_fd_sc_hd__mux2_2
XFILLER_95_575 VGND VGND VPWR VPWR sky130_fd_sc_hd__decap_3
XFILLER_83_726 VGND VGND VPWR VPWR sky130_fd_sc_hd__fill_2
X_7931_ _7931_/A _7931_/B VGND VGND VPWR VPWR _7931_/Y sky130_fd_sc_hd__nor2_2
XFILLER_55_439 VGND VGND VPWR VPWR sky130_fd_sc_hd__decap_3
X_7862_ _7739_/A _7738_/A _7738_/B VGND VGND VPWR VPWR _7862_/X sky130_fd_sc_hd__a21o_2
XFILLER_23_303 VGND VGND VPWR VPWR sky130_fd_sc_hd__fill_2
XFILLER_51_623 VGND VGND VPWR VPWR sky130_fd_sc_hd__decap_3
X_6813_ _5949_/A _6807_/A _6807_/X VGND VGND VPWR VPWR _6813_/X sky130_fd_sc_hd__a21bo_2
X_7793_ _6206_/A _5444_/Y _6028_/S _8066_/B _8777_/B VGND VGND VPWR VPWR _7793_/X
+ sky130_fd_sc_hd__a221o_2
XFILLER_50_144 VGND VGND VPWR VPWR sky130_fd_sc_hd__decap_3
X_6744_ _6765_/A _6740_/X _6742_/X _6743_/X VGND VGND VPWR VPWR _6768_/A sky130_fd_sc_hd__a31oi_2
XTAP_TAPCELL_ROW_102_1654 VGND VPWR sky130_fd_sc_hd__tapvpwrvgnd_1
XTAP_TAPCELL_ROW_102_1665 VGND VPWR sky130_fd_sc_hd__tapvpwrvgnd_1
XFILLER_50_177 VGND VGND VPWR VPWR sky130_fd_sc_hd__decap_3
X_6675_ _6676_/B _6676_/A VGND VGND VPWR VPWR _6675_/Y sky130_fd_sc_hd__nand2_2
XFILLER_31_391 VGND VGND VPWR VPWR sky130_fd_sc_hd__fill_1
XTAP_TAPCELL_ROW_21_559 VGND VPWR sky130_fd_sc_hd__tapvpwrvgnd_1
X_5626_ _5626_/A _5626_/B _5626_/C _5626_/D VGND VGND VPWR VPWR _5626_/Y sky130_fd_sc_hd__nor4_4
X_8414_ _8350_/B _8413_/X _7593_/X VGND VGND VPWR VPWR _8414_/Y sky130_fd_sc_hd__o21ai_2
XFILLER_117_430 VGND VGND VPWR VPWR sky130_fd_sc_hd__decap_3
X_5557_ _5546_/B _5535_/B _5521_/A _5556_/X _5538_/A VGND VGND VPWR VPWR _5559_/B
+ sky130_fd_sc_hd__a32oi_2
X_8345_ _8345_/A _8364_/B VGND VGND VPWR VPWR _8398_/A sky130_fd_sc_hd__nor2_2
XFILLER_117_463 VGND VGND VPWR VPWR sky130_fd_sc_hd__decap_3
X_8276_ _8276_/A _8276_/B VGND VGND VPWR VPWR _8276_/Y sky130_fd_sc_hd__xnor2_4
XFILLER_105_636 VGND VGND VPWR VPWR sky130_fd_sc_hd__fill_1
X_5488_ _8271_/B _5392_/B _5485_/Y _5487_/X _5395_/A VGND VGND VPWR VPWR _5489_/B
+ sky130_fd_sc_hd__a32o_2
XFILLER_117_496 VGND VGND VPWR VPWR sky130_fd_sc_hd__decap_3
XFILLER_4_9 VGND VGND VPWR VPWR sky130_fd_sc_hd__decap_3
XFILLER_116_12 VGND VGND VPWR VPWR sky130_fd_sc_hd__decap_3
X_7227_ _7532_/B1 _7174_/B _7227_/B1 VGND VGND VPWR VPWR _7228_/B sky130_fd_sc_hd__o21ai_2
XFILLER_59_712 VGND VGND VPWR VPWR sky130_fd_sc_hd__decap_3
XFILLER_116_56 VGND VGND VPWR VPWR sky130_fd_sc_hd__decap_3
X_7158_ _7702_/A _7154_/Y _6891_/A VGND VGND VPWR VPWR _7158_/Y sky130_fd_sc_hd__a21oi_2
XFILLER_98_380 VGND VGND VPWR VPWR sky130_fd_sc_hd__decap_3
XFILLER_76_27 VGND VGND VPWR VPWR sky130_fd_sc_hd__fill_1
XFILLER_76_38 VGND VGND VPWR VPWR sky130_fd_sc_hd__fill_1
XFILLER_113_691 VGND VGND VPWR VPWR sky130_fd_sc_hd__decap_3
X_6109_ _6449_/A _6109_/B VGND VGND VPWR VPWR _6125_/A sky130_fd_sc_hd__xnor2_4
XFILLER_74_704 VGND VGND VPWR VPWR sky130_fd_sc_hd__decap_3
X_7089_ _7090_/A _7090_/C _7090_/D _7090_/B VGND VGND VPWR VPWR _7089_/X sky130_fd_sc_hd__a31o_4
XFILLER_58_266 VGND VGND VPWR VPWR sky130_fd_sc_hd__fill_1
XFILLER_46_406 VGND VGND VPWR VPWR sky130_fd_sc_hd__decap_3
XFILLER_100_363 VGND VGND VPWR VPWR sky130_fd_sc_hd__fill_1
XFILLER_46_417 VGND VGND VPWR VPWR sky130_fd_sc_hd__decap_3
XFILLER_74_748 VGND VGND VPWR VPWR sky130_fd_sc_hd__fill_1
XFILLER_73_225 VGND VGND VPWR VPWR sky130_fd_sc_hd__fill_1
XFILLER_27_620 VGND VGND VPWR VPWR sky130_fd_sc_hd__decap_3
XFILLER_61_409 VGND VGND VPWR VPWR sky130_fd_sc_hd__fill_1
XFILLER_92_37 VGND VGND VPWR VPWR sky130_fd_sc_hd__decap_3
XFILLER_54_450 VGND VGND VPWR VPWR sky130_fd_sc_hd__fill_2
XFILLER_26_141 VGND VGND VPWR VPWR sky130_fd_sc_hd__fill_1
XFILLER_54_461 VGND VGND VPWR VPWR sky130_fd_sc_hd__decap_3
XFILLER_42_601 VGND VGND VPWR VPWR sky130_fd_sc_hd__decap_3
XFILLER_27_697 VGND VGND VPWR VPWR sky130_fd_sc_hd__fill_2
XTAP_TAPCELL_ROW_1_295 VGND VPWR sky130_fd_sc_hd__tapvpwrvgnd_1
XFILLER_42_645 VGND VGND VPWR VPWR sky130_fd_sc_hd__decap_3
XFILLER_41_122 VGND VGND VPWR VPWR sky130_fd_sc_hd__decap_3
XTAP_TAPCELL_ROW_64_1148 VGND VPWR sky130_fd_sc_hd__tapvpwrvgnd_1
XFILLER_81_291 VGND VGND VPWR VPWR sky130_fd_sc_hd__decap_3
XFILLER_25_97 VGND VGND VPWR VPWR sky130_fd_sc_hd__fill_2
XTAP_TAPCELL_ROW_40_824 VGND VPWR sky130_fd_sc_hd__tapvpwrvgnd_1
XFILLER_10_520 VGND VGND VPWR VPWR sky130_fd_sc_hd__decap_3
XFILLER_10_531 VGND VGND VPWR VPWR sky130_fd_sc_hd__fill_1
XFILLER_41_30 VGND VGND VPWR VPWR sky130_fd_sc_hd__decap_3
XFILLER_128_728 VGND VGND VPWR VPWR sky130_fd_sc_hd__decap_3
XFILLER_10_542 VGND VGND VPWR VPWR sky130_fd_sc_hd__decap_3
XFILLER_127_205 VGND VGND VPWR VPWR sky130_fd_sc_hd__decap_3
XFILLER_123_422 VGND VGND VPWR VPWR sky130_fd_sc_hd__decap_3
XFILLER_123_455 VGND VGND VPWR VPWR sky130_fd_sc_hd__decap_3
XTAP_TAPCELL_ROW_75_1288 VGND VPWR sky130_fd_sc_hd__tapvpwrvgnd_1
XFILLER_2_752 VGND VGND VPWR VPWR sky130_fd_sc_hd__decap_3
XFILLER_111_606 VGND VGND VPWR VPWR sky130_fd_sc_hd__fill_1
XTAP_TAPCELL_ROW_75_1299 VGND VPWR sky130_fd_sc_hd__tapvpwrvgnd_1
XFILLER_2_763 VGND VGND VPWR VPWR sky130_fd_sc_hd__decap_3
XFILLER_111_617 VGND VGND VPWR VPWR sky130_fd_sc_hd__decap_3
XFILLER_2_24 VGND VGND VPWR VPWR sky130_fd_sc_hd__decap_3
XFILLER_2_35 VGND VGND VPWR VPWR sky130_fd_sc_hd__decap_3
XFILLER_103_190 VGND VGND VPWR VPWR sky130_fd_sc_hd__decap_3
XFILLER_77_564 VGND VGND VPWR VPWR sky130_fd_sc_hd__fill_1
XFILLER_65_704 VGND VGND VPWR VPWR sky130_fd_sc_hd__decap_3
XFILLER_2_68 VGND VGND VPWR VPWR sky130_fd_sc_hd__decap_3
XFILLER_77_586 VGND VGND VPWR VPWR sky130_fd_sc_hd__decap_3
XTAP_TAPCELL_ROW_48_924 VGND VPWR sky130_fd_sc_hd__tapvpwrvgnd_1
XFILLER_65_737 VGND VGND VPWR VPWR sky130_fd_sc_hd__decap_3
XTAP_TAPCELL_ROW_48_935 VGND VPWR sky130_fd_sc_hd__tapvpwrvgnd_1
XFILLER_65_748 VGND VGND VPWR VPWR sky130_fd_sc_hd__decap_3
XFILLER_18_620 VGND VGND VPWR VPWR sky130_fd_sc_hd__decap_3
XFILLER_80_707 VGND VGND VPWR VPWR sky130_fd_sc_hd__decap_3
XFILLER_64_258 VGND VGND VPWR VPWR sky130_fd_sc_hd__decap_3
XFILLER_64_269 VGND VGND VPWR VPWR sky130_fd_sc_hd__fill_1
XFILLER_92_589 VGND VGND VPWR VPWR sky130_fd_sc_hd__decap_3
XFILLER_80_729 VGND VGND VPWR VPWR sky130_fd_sc_hd__decap_3
XFILLER_45_461 VGND VGND VPWR VPWR sky130_fd_sc_hd__decap_3
XPHY_EDGE_ROW_72_Left_203 VGND VGND VPWR VPWR sky130_fd_sc_hd__decap_3
XFILLER_72_280 VGND VGND VPWR VPWR sky130_fd_sc_hd__decap_3
XFILLER_60_464 VGND VGND VPWR VPWR sky130_fd_sc_hd__decap_3
X_4790_ hold902/X _4790_/A1 _4798_/S VGND VGND VPWR VPWR _4791_/A sky130_fd_sc_hd__mux2_2
XFILLER_33_689 VGND VGND VPWR VPWR sky130_fd_sc_hd__decap_3
XFILLER_32_188 VGND VGND VPWR VPWR sky130_fd_sc_hd__fill_1
XFILLER_20_328 VGND VGND VPWR VPWR sky130_fd_sc_hd__decap_3
XFILLER_119_717 VGND VGND VPWR VPWR sky130_fd_sc_hd__decap_3
X_6460_ _6460_/A0 _6459_/Y _6460_/S VGND VGND VPWR VPWR _6460_/X sky130_fd_sc_hd__mux2_2
XFILLER_9_362 VGND VGND VPWR VPWR sky130_fd_sc_hd__decap_3
XFILLER_9_384 VGND VGND VPWR VPWR sky130_fd_sc_hd__decap_3
X_5411_ _5412_/A _5412_/B _5306_/X VGND VGND VPWR VPWR _5411_/Y sky130_fd_sc_hd__a21oi_2
X_6391_ _6074_/X _6140_/B _6140_/A VGND VGND VPWR VPWR _6510_/S sky130_fd_sc_hd__o21a_4
XFILLER_127_750 VGND VGND VPWR VPWR sky130_fd_sc_hd__decap_3
X_8130_ _8215_/B _8218_/A VGND VGND VPWR VPWR _8131_/B sky130_fd_sc_hd__xnor2_2
XPHY_EDGE_ROW_81_Left_212 VGND VGND VPWR VPWR sky130_fd_sc_hd__decap_3
X_5342_ _5019_/X _5272_/X _6313_/B1 VGND VGND VPWR VPWR _7408_/B sky130_fd_sc_hd__a21o_4
XFILLER_126_271 VGND VGND VPWR VPWR sky130_fd_sc_hd__fill_1
XFILLER_114_433 VGND VGND VPWR VPWR sky130_fd_sc_hd__decap_3
XTAP_TAPCELL_ROW_130_2050 VGND VPWR sky130_fd_sc_hd__tapvpwrvgnd_1
XFILLER_99_133 VGND VGND VPWR VPWR sky130_fd_sc_hd__decap_3
X_8061_ _8231_/A _8061_/B VGND VGND VPWR VPWR _8062_/B sky130_fd_sc_hd__xnor2_2
X_5273_ _9243_/Q _5273_/B VGND VGND VPWR VPWR _5273_/Y sky130_fd_sc_hd__nor2_2
XFILLER_87_306 VGND VGND VPWR VPWR sky130_fd_sc_hd__decap_3
XFILLER_114_477 VGND VGND VPWR VPWR sky130_fd_sc_hd__decap_3
X_7012_ _7012_/A _7012_/B VGND VGND VPWR VPWR _7013_/B sky130_fd_sc_hd__and2_2
XFILLER_68_542 VGND VGND VPWR VPWR sky130_fd_sc_hd__decap_3
XFILLER_68_553 VGND VGND VPWR VPWR sky130_fd_sc_hd__decap_3
XFILLER_56_726 VGND VGND VPWR VPWR sky130_fd_sc_hd__decap_3
XFILLER_110_672 VGND VGND VPWR VPWR sky130_fd_sc_hd__decap_3
XFILLER_110_694 VGND VGND VPWR VPWR sky130_fd_sc_hd__decap_3
X_8963_ _8997_/A1 _8963_/A1 _8967_/S VGND VGND VPWR VPWR _8964_/A sky130_fd_sc_hd__mux2_2
XFILLER_83_545 VGND VGND VPWR VPWR sky130_fd_sc_hd__decap_3
XPHY_EDGE_ROW_90_Left_221 VGND VGND VPWR VPWR sky130_fd_sc_hd__decap_3
XFILLER_83_567 VGND VGND VPWR VPWR sky130_fd_sc_hd__fill_2
XFILLER_71_707 VGND VGND VPWR VPWR sky130_fd_sc_hd__decap_3
X_7914_ wire66/A _7824_/A _9217_/Q VGND VGND VPWR VPWR _7914_/X sky130_fd_sc_hd__mux2_2
XFILLER_83_578 VGND VGND VPWR VPWR sky130_fd_sc_hd__decap_3
X_8894_ _8928_/A1 _8894_/A1 _8904_/S VGND VGND VPWR VPWR _8895_/A sky130_fd_sc_hd__mux2_2
XFILLER_70_206 VGND VGND VPWR VPWR sky130_fd_sc_hd__decap_3
XTAP_TAPCELL_ROW_26_629 VGND VPWR sky130_fd_sc_hd__tapvpwrvgnd_1
XFILLER_36_472 VGND VGND VPWR VPWR sky130_fd_sc_hd__decap_3
XFILLER_102_69 VGND VGND VPWR VPWR sky130_fd_sc_hd__decap_3
X_7845_ _7845_/A _7845_/B VGND VGND VPWR VPWR _7846_/B sky130_fd_sc_hd__xnor2_2
XFILLER_51_431 VGND VGND VPWR VPWR sky130_fd_sc_hd__decap_3
XFILLER_24_645 VGND VGND VPWR VPWR sky130_fd_sc_hd__decap_3
XFILLER_51_464 VGND VGND VPWR VPWR sky130_fd_sc_hd__decap_3
X_7776_ _8421_/A _7776_/B VGND VGND VPWR VPWR _7777_/B sky130_fd_sc_hd__nand2_2
X_4988_ _9255_/Q _9287_/Q _6206_/B VGND VGND VPWR VPWR _4988_/X sky130_fd_sc_hd__mux2_2
XFILLER_23_177 VGND VGND VPWR VPWR sky130_fd_sc_hd__decap_3
X_6727_ _6727_/A _6727_/B VGND VGND VPWR VPWR _7016_/A sky130_fd_sc_hd__or2_4
Xwire219 wire219/A VGND VGND VPWR VPWR result_out[9] sky130_fd_sc_hd__buf_4
X_6658_ _6658_/A _6658_/B VGND VGND VPWR VPWR _6664_/C sky130_fd_sc_hd__or2_2
X_5609_ _5434_/A _5433_/B _5608_/X VGND VGND VPWR VPWR _5635_/A sky130_fd_sc_hd__o21ai_2
XFILLER_11_33 VGND VGND VPWR VPWR sky130_fd_sc_hd__decap_3
X_6589_ _5165_/A _5165_/B _6211_/B VGND VGND VPWR VPWR _6708_/B sky130_fd_sc_hd__a21o_2
XFILLER_3_505 VGND VGND VPWR VPWR sky130_fd_sc_hd__fill_2
XFILLER_118_772 VGND VGND VPWR VPWR sky130_fd_sc_hd__decap_3
XTAP_TAPCELL_ROW_115_1834 VGND VPWR sky130_fd_sc_hd__tapvpwrvgnd_1
X_8328_ _8416_/B _8328_/B VGND VGND VPWR VPWR _8328_/Y sky130_fd_sc_hd__xnor2_2
XFILLER_127_33 VGND VGND VPWR VPWR sky130_fd_sc_hd__decap_3
XFILLER_11_66 VGND VGND VPWR VPWR sky130_fd_sc_hd__decap_3
XFILLER_3_538 VGND VGND VPWR VPWR sky130_fd_sc_hd__decap_3
XFILLER_105_433 VGND VGND VPWR VPWR sky130_fd_sc_hd__decap_3
XFILLER_127_66 VGND VGND VPWR VPWR sky130_fd_sc_hd__decap_3
XFILLER_2_6 VGND VGND VPWR VPWR sky130_fd_sc_hd__decap_3
X_8259_ _9220_/Q _8257_/B _8258_/Y VGND VGND VPWR VPWR _8260_/B sky130_fd_sc_hd__a21oi_2
XFILLER_127_99 VGND VGND VPWR VPWR sky130_fd_sc_hd__decap_3
XFILLER_105_488 VGND VGND VPWR VPWR sky130_fd_sc_hd__decap_3
XFILLER_78_328 VGND VGND VPWR VPWR sky130_fd_sc_hd__decap_3
XFILLER_120_436 VGND VGND VPWR VPWR sky130_fd_sc_hd__decap_3
Xfanout341 wire347/A VGND VGND VPWR VPWR _7869_/A sky130_fd_sc_hd__buf_4
XTAP_TAPCELL_ROW_6_365 VGND VPWR sky130_fd_sc_hd__tapvpwrvgnd_1
XFILLER_101_650 VGND VGND VPWR VPWR sky130_fd_sc_hd__decap_3
Xfanout363 hold749/X VGND VGND VPWR VPWR _5667_/S sky130_fd_sc_hd__clkdlybuf4s25_1
XFILLER_86_350 VGND VGND VPWR VPWR sky130_fd_sc_hd__decap_3
XFILLER_59_564 VGND VGND VPWR VPWR sky130_fd_sc_hd__decap_3
Xfanout385 fanout391/A VGND VGND VPWR VPWR fanout385/X sky130_fd_sc_hd__clkdlybuf4s25_1
XFILLER_19_406 VGND VGND VPWR VPWR sky130_fd_sc_hd__decap_3
XPHY_EDGE_ROW_129_Left_260 VGND VGND VPWR VPWR sky130_fd_sc_hd__decap_3
XFILLER_19_428 VGND VGND VPWR VPWR sky130_fd_sc_hd__decap_3
XFILLER_86_383 VGND VGND VPWR VPWR sky130_fd_sc_hd__decap_3
XFILLER_62_707 VGND VGND VPWR VPWR sky130_fd_sc_hd__fill_2
XFILLER_36_41 VGND VGND VPWR VPWR sky130_fd_sc_hd__decap_3
XFILLER_34_409 VGND VGND VPWR VPWR sky130_fd_sc_hd__decap_3
XFILLER_74_589 VGND VGND VPWR VPWR sky130_fd_sc_hd__decap_3
XFILLER_61_206 VGND VGND VPWR VPWR sky130_fd_sc_hd__decap_3
XTAP_TAPCELL_ROW_126_1985 VGND VPWR sky130_fd_sc_hd__tapvpwrvgnd_1
XFILLER_61_228 VGND VGND VPWR VPWR sky130_fd_sc_hd__fill_2
XFILLER_36_74 VGND VGND VPWR VPWR sky130_fd_sc_hd__decap_3
XFILLER_15_623 VGND VGND VPWR VPWR sky130_fd_sc_hd__decap_3
XFILLER_36_85 VGND VGND VPWR VPWR sky130_fd_sc_hd__decap_3
XFILLER_70_740 VGND VGND VPWR VPWR sky130_fd_sc_hd__decap_3
XFILLER_42_431 VGND VGND VPWR VPWR sky130_fd_sc_hd__decap_3
XFILLER_54_291 VGND VGND VPWR VPWR sky130_fd_sc_hd__decap_3
XFILLER_14_133 VGND VGND VPWR VPWR sky130_fd_sc_hd__decap_3
XFILLER_14_144 VGND VGND VPWR VPWR sky130_fd_sc_hd__decap_3
XFILLER_42_464 VGND VGND VPWR VPWR sky130_fd_sc_hd__decap_3
XTAP_TAPCELL_ROW_53_993 VGND VPWR sky130_fd_sc_hd__tapvpwrvgnd_1
XFILLER_52_73 VGND VGND VPWR VPWR sky130_fd_sc_hd__decap_3
Xinput16 sample_in[8] VGND VGND VPWR VPWR input16/X sky130_fd_sc_hd__clkdlybuf4s25_1
XFILLER_128_547 VGND VGND VPWR VPWR sky130_fd_sc_hd__decap_3
XFILLER_10_361 VGND VGND VPWR VPWR sky130_fd_sc_hd__decap_3
XFILLER_6_321 VGND VGND VPWR VPWR sky130_fd_sc_hd__decap_3
XTAP_TAPCELL_ROW_77_1317 VGND VPWR sky130_fd_sc_hd__tapvpwrvgnd_1
XFILLER_115_208 VGND VGND VPWR VPWR sky130_fd_sc_hd__decap_3
XFILLER_124_731 VGND VGND VPWR VPWR sky130_fd_sc_hd__decap_3
XFILLER_124_775 VGND VGND VPWR VPWR sky130_fd_sc_hd__fill_2
XFILLER_97_615 VGND VGND VPWR VPWR sky130_fd_sc_hd__fill_1
XFILLER_35_6 VGND VGND VPWR VPWR sky130_fd_sc_hd__fill_1
XFILLER_38_704 VGND VGND VPWR VPWR sky130_fd_sc_hd__decap_3
XFILLER_65_501 VGND VGND VPWR VPWR sky130_fd_sc_hd__decap_3
XFILLER_37_203 VGND VGND VPWR VPWR sky130_fd_sc_hd__decap_3
XFILLER_37_225 VGND VGND VPWR VPWR sky130_fd_sc_hd__fill_2
XTAP_TAPCELL_ROW_88_1468 VGND VPWR sky130_fd_sc_hd__tapvpwrvgnd_1
XFILLER_65_567 VGND VGND VPWR VPWR sky130_fd_sc_hd__decap_3
X_5960_ _5960_/A _5960_/B VGND VGND VPWR VPWR _5961_/A sky130_fd_sc_hd__xnor2_2
XFILLER_65_589 VGND VGND VPWR VPWR sky130_fd_sc_hd__decap_3
XFILLER_18_461 VGND VGND VPWR VPWR sky130_fd_sc_hd__decap_3
X_4911_ _6206_/A _5196_/B VGND VGND VPWR VPWR _5350_/B sky130_fd_sc_hd__nand2b_2
X_5891_ _5975_/A _5975_/B VGND VGND VPWR VPWR _5892_/A sky130_fd_sc_hd__nand2_4
XFILLER_33_431 VGND VGND VPWR VPWR sky130_fd_sc_hd__decap_3
X_7630_ _9214_/Q _7924_/B _7476_/Y _7478_/B VGND VGND VPWR VPWR _7631_/B sky130_fd_sc_hd__o31a_2
XFILLER_61_773 VGND VGND VPWR VPWR sky130_fd_sc_hd__decap_3
X_4842_ _4842_/A VGND VGND VPWR VPWR _4861_/S sky130_fd_sc_hd__clkbuf_2
XFILLER_60_250 VGND VGND VPWR VPWR sky130_fd_sc_hd__fill_2
XFILLER_21_615 VGND VGND VPWR VPWR sky130_fd_sc_hd__fill_1
XFILLER_60_272 VGND VGND VPWR VPWR sky130_fd_sc_hd__decap_3
XFILLER_33_497 VGND VGND VPWR VPWR sky130_fd_sc_hd__decap_3
XFILLER_21_648 VGND VGND VPWR VPWR sky130_fd_sc_hd__fill_2
X_4773_ _9133_/Q hold928/X _4777_/S VGND VGND VPWR VPWR _4773_/X sky130_fd_sc_hd__mux2_2
X_7561_ _7561_/A _7561_/B VGND VGND VPWR VPWR _7561_/X sky130_fd_sc_hd__and2_2
XFILLER_20_147 VGND VGND VPWR VPWR sky130_fd_sc_hd__decap_3
X_9300_ _9331_/CLK _9300_/D load_slew386/X VGND VGND VPWR VPWR _9300_/Q sky130_fd_sc_hd__dfrtp_2
X_6512_ _6512_/A _6512_/B VGND VGND VPWR VPWR _6512_/X sky130_fd_sc_hd__xor2_2
XFILLER_119_536 VGND VGND VPWR VPWR sky130_fd_sc_hd__decap_3
X_7492_ _7492_/A _7492_/B _7490_/B VGND VGND VPWR VPWR _7492_/X sky130_fd_sc_hd__or3b_4
XTAP_TAPCELL_ROW_31_698 VGND VPWR sky130_fd_sc_hd__tapvpwrvgnd_1
X_9231_ _9232_/CLK _9231_/D fanout405/A VGND VGND VPWR VPWR _9231_/Q sky130_fd_sc_hd__dfrtp_2
XFILLER_9_192 VGND VGND VPWR VPWR sky130_fd_sc_hd__decap_3
X_6443_ _6443_/A _6443_/B VGND VGND VPWR VPWR _6443_/Y sky130_fd_sc_hd__xnor2_2
X_6374_ _6374_/A _6374_/B _6374_/C VGND VGND VPWR VPWR _6376_/A sky130_fd_sc_hd__or3_4
X_9162_ _9335_/CLK _9162_/D fanout400/X VGND VGND VPWR VPWR _9162_/Q sky130_fd_sc_hd__dfrtp_2
XFILLER_115_742 VGND VGND VPWR VPWR sky130_fd_sc_hd__fill_2
X_5325_ _5656_/A VGND VGND VPWR VPWR _5804_/A sky130_fd_sc_hd__clkbuf_1
X_8113_ _8112_/B _8112_/C _8112_/A VGND VGND VPWR VPWR _8114_/B sky130_fd_sc_hd__o21a_2
XFILLER_115_764 VGND VGND VPWR VPWR sky130_fd_sc_hd__fill_1
XFILLER_0_508 VGND VGND VPWR VPWR sky130_fd_sc_hd__decap_3
X_9093_ _9313_/CLK _9093_/D fanout387/X VGND VGND VPWR VPWR _9093_/Q sky130_fd_sc_hd__dfrtp_2
XFILLER_130_701 VGND VGND VPWR VPWR sky130_fd_sc_hd__decap_3
XFILLER_87_103 VGND VGND VPWR VPWR sky130_fd_sc_hd__fill_1
XFILLER_114_274 VGND VGND VPWR VPWR sky130_fd_sc_hd__decap_3
X_5256_ _5208_/A _5208_/B _5255_/X VGND VGND VPWR VPWR _5281_/A sky130_fd_sc_hd__o21ai_2
X_8044_ _8044_/A _8044_/B VGND VGND VPWR VPWR _8044_/Y sky130_fd_sc_hd__xnor2_4
XFILLER_87_125 VGND VGND VPWR VPWR sky130_fd_sc_hd__decap_3
XFILLER_57_18 VGND VGND VPWR VPWR sky130_fd_sc_hd__decap_3
XFILLER_102_458 VGND VGND VPWR VPWR sky130_fd_sc_hd__decap_3
XTAP_TAPCELL_ROW_110_1764 VGND VPWR sky130_fd_sc_hd__tapvpwrvgnd_1
X_5187_ _5266_/S _9274_/Q _5187_/C VGND VGND VPWR VPWR _5187_/X sky130_fd_sc_hd__and3b_2
XFILLER_68_350 VGND VGND VPWR VPWR sky130_fd_sc_hd__fill_2
XFILLER_29_715 VGND VGND VPWR VPWR sky130_fd_sc_hd__decap_3
XTAP_TAPCELL_ROW_3_324 VGND VPWR sky130_fd_sc_hd__tapvpwrvgnd_1
XFILLER_68_372 VGND VGND VPWR VPWR sky130_fd_sc_hd__decap_3
XFILLER_56_512 VGND VGND VPWR VPWR sky130_fd_sc_hd__decap_3
XFILLER_28_236 VGND VGND VPWR VPWR sky130_fd_sc_hd__decap_3
XFILLER_113_24 VGND VGND VPWR VPWR sky130_fd_sc_hd__decap_3
XFILLER_56_567 VGND VGND VPWR VPWR sky130_fd_sc_hd__fill_2
XFILLER_113_57 VGND VGND VPWR VPWR sky130_fd_sc_hd__decap_3
XFILLER_16_409 VGND VGND VPWR VPWR sky130_fd_sc_hd__decap_3
X_8946_ hold991/X _8946_/A1 _8946_/S VGND VGND VPWR VPWR _8947_/A sky130_fd_sc_hd__mux2_2
XFILLER_56_589 VGND VGND VPWR VPWR sky130_fd_sc_hd__decap_3
XFILLER_83_386 VGND VGND VPWR VPWR sky130_fd_sc_hd__decap_3
XFILLER_71_548 VGND VGND VPWR VPWR sky130_fd_sc_hd__fill_2
Xwire62 wire62/A VGND VGND VPWR VPWR wire62/X sky130_fd_sc_hd__buf_2
X_8877_ _8877_/A0 _8877_/A1 _8883_/S VGND VGND VPWR VPWR _8878_/A sky130_fd_sc_hd__mux2_2
Xwire84 wire84/A VGND VGND VPWR VPWR wire84/X sky130_fd_sc_hd__buf_2
X_7828_ _7634_/B _7633_/A _7827_/X VGND VGND VPWR VPWR _7845_/A sky130_fd_sc_hd__o21ai_2
XTAP_TAPCELL_ROW_61_1107 VGND VPWR sky130_fd_sc_hd__tapvpwrvgnd_1
XFILLER_12_615 VGND VGND VPWR VPWR sky130_fd_sc_hd__decap_3
XFILLER_24_497 VGND VGND VPWR VPWR sky130_fd_sc_hd__decap_3
XFILLER_12_648 VGND VGND VPWR VPWR sky130_fd_sc_hd__decap_3
X_7759_ _7619_/A _7931_/A _7408_/A VGND VGND VPWR VPWR _7759_/X sky130_fd_sc_hd__o21a_2
XTAP_TAPCELL_ROW_50_952 VGND VPWR sky130_fd_sc_hd__tapvpwrvgnd_1
XFILLER_11_147 VGND VGND VPWR VPWR sky130_fd_sc_hd__decap_3
XTAP_TAPCELL_ROW_50_963 VGND VPWR sky130_fd_sc_hd__tapvpwrvgnd_1
XFILLER_22_21 VGND VGND VPWR VPWR sky130_fd_sc_hd__decap_3
XFILLER_11_169 VGND VGND VPWR VPWR sky130_fd_sc_hd__fill_1
XFILLER_22_43 VGND VGND VPWR VPWR sky130_fd_sc_hd__decap_3
XPHY_EDGE_ROW_129_Right_129 VGND VGND VPWR VPWR sky130_fd_sc_hd__decap_3
XFILLER_20_681 VGND VGND VPWR VPWR sky130_fd_sc_hd__fill_1
XFILLER_22_76 VGND VGND VPWR VPWR sky130_fd_sc_hd__decap_3
XFILLER_118_3 VGND VGND VPWR VPWR sky130_fd_sc_hd__decap_3
XFILLER_106_742 VGND VGND VPWR VPWR sky130_fd_sc_hd__decap_3
XFILLER_3_346 VGND VGND VPWR VPWR sky130_fd_sc_hd__decap_3
XFILLER_0_3 VGND VGND VPWR VPWR sky130_fd_sc_hd__decap_3
XFILLER_79_615 VGND VGND VPWR VPWR sky130_fd_sc_hd__fill_1
XFILLER_79_626 VGND VGND VPWR VPWR sky130_fd_sc_hd__decap_3
XTAP_TAPCELL_ROW_72_1247 VGND VPWR sky130_fd_sc_hd__tapvpwrvgnd_1
XTAP_TAPCELL_ROW_72_1258 VGND VPWR sky130_fd_sc_hd__tapvpwrvgnd_1
XFILLER_105_296 VGND VGND VPWR VPWR sky130_fd_sc_hd__decap_3
XFILLER_121_756 VGND VGND VPWR VPWR sky130_fd_sc_hd__decap_3
XFILLER_120_233 VGND VGND VPWR VPWR sky130_fd_sc_hd__decap_3
XFILLER_94_607 VGND VGND VPWR VPWR sky130_fd_sc_hd__decap_3
XFILLER_66_309 VGND VGND VPWR VPWR sky130_fd_sc_hd__fill_1
XFILLER_94_629 VGND VGND VPWR VPWR sky130_fd_sc_hd__decap_3
XFILLER_87_670 VGND VGND VPWR VPWR sky130_fd_sc_hd__fill_2
XFILLER_59_372 VGND VGND VPWR VPWR sky130_fd_sc_hd__decap_3
XFILLER_86_180 VGND VGND VPWR VPWR sky130_fd_sc_hd__decap_3
XFILLER_74_331 VGND VGND VPWR VPWR sky130_fd_sc_hd__decap_3
XFILLER_47_567 VGND VGND VPWR VPWR sky130_fd_sc_hd__decap_3
XFILLER_35_729 VGND VGND VPWR VPWR sky130_fd_sc_hd__decap_3
XFILLER_74_397 VGND VGND VPWR VPWR sky130_fd_sc_hd__decap_3
XFILLER_62_548 VGND VGND VPWR VPWR sky130_fd_sc_hd__decap_3
XFILLER_27_291 VGND VGND VPWR VPWR sky130_fd_sc_hd__decap_3
XFILLER_43_773 VGND VGND VPWR VPWR sky130_fd_sc_hd__decap_3
XFILLER_30_412 VGND VGND VPWR VPWR sky130_fd_sc_hd__decap_3
XTAP_TAPCELL_ROW_83_1398 VGND VPWR sky130_fd_sc_hd__tapvpwrvgnd_1
XFILLER_42_283 VGND VGND VPWR VPWR sky130_fd_sc_hd__decap_3
XFILLER_8_12 VGND VGND VPWR VPWR sky130_fd_sc_hd__decap_3
XFILLER_30_434 VGND VGND VPWR VPWR sky130_fd_sc_hd__decap_3
XFILLER_128_300 VGND VGND VPWR VPWR sky130_fd_sc_hd__decap_3
XFILLER_8_56 VGND VGND VPWR VPWR sky130_fd_sc_hd__decap_3
XFILLER_30_489 VGND VGND VPWR VPWR sky130_fd_sc_hd__decap_3
XFILLER_11_670 VGND VGND VPWR VPWR sky130_fd_sc_hd__fill_2
XFILLER_116_517 VGND VGND VPWR VPWR sky130_fd_sc_hd__decap_3
XFILLER_6_162 VGND VGND VPWR VPWR sky130_fd_sc_hd__fill_2
XFILLER_6_195 VGND VGND VPWR VPWR sky130_fd_sc_hd__fill_1
XFILLER_112_701 VGND VGND VPWR VPWR sky130_fd_sc_hd__fill_1
XFILLER_97_401 VGND VGND VPWR VPWR sky130_fd_sc_hd__fill_1
XFILLER_69_103 VGND VGND VPWR VPWR sky130_fd_sc_hd__decap_3
X_5110_ _6232_/C _5463_/C _5462_/S _6231_/B VGND VGND VPWR VPWR _5110_/Y sky130_fd_sc_hd__nor4b_2
X_6090_ _6091_/A _6083_/X _6805_/A _6089_/Y VGND VGND VPWR VPWR _6090_/X sky130_fd_sc_hd__a31o_2
X_5041_ _6304_/A _5041_/B VGND VGND VPWR VPWR _5042_/B sky130_fd_sc_hd__nor2_2
XFILLER_85_629 VGND VGND VPWR VPWR sky130_fd_sc_hd__decap_3
XFILLER_84_128 VGND VGND VPWR VPWR sky130_fd_sc_hd__decap_3
XFILLER_38_523 VGND VGND VPWR VPWR sky130_fd_sc_hd__decap_3
XFILLER_111_299 VGND VGND VPWR VPWR sky130_fd_sc_hd__decap_3
XFILLER_38_567 VGND VGND VPWR VPWR sky130_fd_sc_hd__decap_3
X_8800_ _8800_/A VGND VGND VPWR VPWR _9245_/D sky130_fd_sc_hd__buf_1
XFILLER_93_673 VGND VGND VPWR VPWR sky130_fd_sc_hd__decap_3
XFILLER_65_364 VGND VGND VPWR VPWR sky130_fd_sc_hd__fill_1
XFILLER_80_301 VGND VGND VPWR VPWR sky130_fd_sc_hd__decap_3
XFILLER_38_589 VGND VGND VPWR VPWR sky130_fd_sc_hd__decap_3
X_6992_ _6992_/A _6992_/B _6992_/C VGND VGND VPWR VPWR _6992_/X sky130_fd_sc_hd__or3_2
XFILLER_53_526 VGND VGND VPWR VPWR sky130_fd_sc_hd__decap_3
XFILLER_25_217 VGND VGND VPWR VPWR sky130_fd_sc_hd__decap_3
XFILLER_80_312 VGND VGND VPWR VPWR sky130_fd_sc_hd__decap_3
X_8731_ _9230_/Q _8758_/A VGND VGND VPWR VPWR _8731_/Y sky130_fd_sc_hd__nand2_2
X_5943_ _6821_/S _5943_/B VGND VGND VPWR VPWR _5944_/B sky130_fd_sc_hd__and2_2
XTAP_TAPCELL_ROW_36_768 VGND VPWR sky130_fd_sc_hd__tapvpwrvgnd_1
X_8662_ _8657_/B _8660_/Y _8753_/A _9228_/Q VGND VGND VPWR VPWR _8662_/X sky130_fd_sc_hd__o211a_2
X_5874_ _9044_/Q _6336_/B _5875_/B VGND VGND VPWR VPWR _5874_/X sky130_fd_sc_hd__and3_2
XFILLER_61_592 VGND VGND VPWR VPWR sky130_fd_sc_hd__decap_3
XFILLER_21_423 VGND VGND VPWR VPWR sky130_fd_sc_hd__fill_1
X_7613_ _7613_/A _7787_/C VGND VGND VPWR VPWR _7614_/B sky130_fd_sc_hd__xnor2_2
XFILLER_33_294 VGND VGND VPWR VPWR sky130_fd_sc_hd__fill_1
X_4825_ _4825_/A VGND VGND VPWR VPWR _9157_/D sky130_fd_sc_hd__buf_1
XTAP_TAPCELL_ROW_16_492 VGND VPWR sky130_fd_sc_hd__tapvpwrvgnd_1
X_8593_ _9224_/Q _8443_/B _8592_/X VGND VGND VPWR VPWR _8593_/Y sky130_fd_sc_hd__o21ai_2
X_7544_ _7702_/B _7544_/B VGND VGND VPWR VPWR _7545_/B sky130_fd_sc_hd__nor2_2
X_4756_ _9125_/Q hold906/X _4756_/S VGND VGND VPWR VPWR _4756_/X sky130_fd_sc_hd__mux2_2
X_4687_ hold934/X _4687_/A1 _4693_/S VGND VGND VPWR VPWR _4688_/A sky130_fd_sc_hd__mux2_2
X_7475_ _7951_/B _7819_/B VGND VGND VPWR VPWR _8083_/B sky130_fd_sc_hd__nor2_2
X_9214_ _9215_/CLK _9214_/D load_slew420/X VGND VGND VPWR VPWR _9214_/Q sky130_fd_sc_hd__dfrtp_2
X_6426_ _6426_/A _6501_/A VGND VGND VPWR VPWR _6427_/S sky130_fd_sc_hd__xor2_2
XFILLER_108_24 VGND VGND VPWR VPWR sky130_fd_sc_hd__decap_3
XFILLER_104_9 VGND VGND VPWR VPWR sky130_fd_sc_hd__fill_2
XFILLER_108_35 VGND VGND VPWR VPWR sky130_fd_sc_hd__decap_3
X_9145_ _9317_/CLK _9145_/D wire406/X VGND VGND VPWR VPWR _9145_/Q sky130_fd_sc_hd__dfrtp_2
X_6357_ _9208_/Q _6939_/B VGND VGND VPWR VPWR _6357_/Y sky130_fd_sc_hd__nor2_2
XFILLER_0_305 VGND VGND VPWR VPWR sky130_fd_sc_hd__decap_3
XFILLER_88_412 VGND VGND VPWR VPWR sky130_fd_sc_hd__fill_1
XFILLER_115_583 VGND VGND VPWR VPWR sky130_fd_sc_hd__decap_3
XFILLER_102_211 VGND VGND VPWR VPWR sky130_fd_sc_hd__decap_3
X_5308_ _5308_/A _5308_/B VGND VGND VPWR VPWR _5310_/B sky130_fd_sc_hd__xnor2_2
XFILLER_130_520 VGND VGND VPWR VPWR sky130_fd_sc_hd__decap_3
X_6288_ _6288_/A _6288_/B VGND VGND VPWR VPWR _6288_/Y sky130_fd_sc_hd__xnor2_4
X_9076_ _9313_/CLK _9076_/D load_slew388/X VGND VGND VPWR VPWR _9076_/Q sky130_fd_sc_hd__dfrtp_2
XFILLER_124_12 VGND VGND VPWR VPWR sky130_fd_sc_hd__decap_3
X_8027_ _8023_/X _8024_/Y _8026_/Y VGND VGND VPWR VPWR _8039_/A sky130_fd_sc_hd__o21ai_2
XFILLER_48_309 VGND VGND VPWR VPWR sky130_fd_sc_hd__fill_1
XFILLER_130_564 VGND VGND VPWR VPWR sky130_fd_sc_hd__decap_3
X_5239_ _5135_/A _5149_/X _5237_/X _5238_/Y VGND VGND VPWR VPWR _5239_/X sky130_fd_sc_hd__o211a_2
XFILLER_29_501 VGND VGND VPWR VPWR sky130_fd_sc_hd__decap_3
XFILLER_69_670 VGND VGND VPWR VPWR sky130_fd_sc_hd__fill_2
XFILLER_124_56 VGND VGND VPWR VPWR sky130_fd_sc_hd__decap_3
XFILLER_29_523 VGND VGND VPWR VPWR sky130_fd_sc_hd__decap_3
XFILLER_29_556 VGND VGND VPWR VPWR sky130_fd_sc_hd__decap_3
XFILLER_56_353 VGND VGND VPWR VPWR sky130_fd_sc_hd__decap_3
XFILLER_17_707 VGND VGND VPWR VPWR sky130_fd_sc_hd__decap_3
XFILLER_90_109 VGND VGND VPWR VPWR sky130_fd_sc_hd__decap_3
XFILLER_17_21 VGND VGND VPWR VPWR sky130_fd_sc_hd__decap_3
XFILLER_44_515 VGND VGND VPWR VPWR sky130_fd_sc_hd__decap_3
XFILLER_17_729 VGND VGND VPWR VPWR sky130_fd_sc_hd__decap_3
XFILLER_16_217 VGND VGND VPWR VPWR sky130_fd_sc_hd__decap_3
XFILLER_17_54 VGND VGND VPWR VPWR sky130_fd_sc_hd__fill_2
X_8929_ _8929_/A VGND VGND VPWR VPWR _9306_/D sky130_fd_sc_hd__buf_1
XTAP_TAPCELL_ROW_123_1944 VGND VPWR sky130_fd_sc_hd__tapvpwrvgnd_1
XFILLER_25_762 VGND VGND VPWR VPWR sky130_fd_sc_hd__decap_3
XFILLER_12_412 VGND VGND VPWR VPWR sky130_fd_sc_hd__fill_1
XFILLER_52_592 VGND VGND VPWR VPWR sky130_fd_sc_hd__fill_1
XFILLER_24_294 VGND VGND VPWR VPWR sky130_fd_sc_hd__decap_3
XFILLER_12_434 VGND VGND VPWR VPWR sky130_fd_sc_hd__decap_3
XFILLER_129_108 VGND VGND VPWR VPWR sky130_fd_sc_hd__decap_3
XFILLER_129_119 VGND VGND VPWR VPWR sky130_fd_sc_hd__decap_3
XFILLER_4_655 VGND VGND VPWR VPWR sky130_fd_sc_hd__decap_3
XFILLER_106_572 VGND VGND VPWR VPWR sky130_fd_sc_hd__decap_3
XFILLER_4_688 VGND VGND VPWR VPWR sky130_fd_sc_hd__decap_3
XFILLER_121_520 VGND VGND VPWR VPWR sky130_fd_sc_hd__fill_2
XFILLER_121_564 VGND VGND VPWR VPWR sky130_fd_sc_hd__decap_3
XFILLER_121_575 VGND VGND VPWR VPWR sky130_fd_sc_hd__fill_2
XFILLER_47_331 VGND VGND VPWR VPWR sky130_fd_sc_hd__decap_3
XFILLER_75_673 VGND VGND VPWR VPWR sky130_fd_sc_hd__decap_3
XFILLER_74_150 VGND VGND VPWR VPWR sky130_fd_sc_hd__decap_3
XFILLER_90_610 VGND VGND VPWR VPWR sky130_fd_sc_hd__fill_2
XFILLER_47_375 VGND VGND VPWR VPWR sky130_fd_sc_hd__decap_3
XTAP_TAPCELL_ROW_85_1427 VGND VPWR sky130_fd_sc_hd__tapvpwrvgnd_1
XFILLER_62_312 VGND VGND VPWR VPWR sky130_fd_sc_hd__decap_3
XFILLER_90_654 VGND VGND VPWR VPWR sky130_fd_sc_hd__decap_3
XFILLER_35_559 VGND VGND VPWR VPWR sky130_fd_sc_hd__fill_1
XFILLER_16_740 VGND VGND VPWR VPWR sky130_fd_sc_hd__decap_3
XFILLER_90_698 VGND VGND VPWR VPWR sky130_fd_sc_hd__fill_2
XFILLER_62_389 VGND VGND VPWR VPWR sky130_fd_sc_hd__decap_3
XFILLER_31_710 VGND VGND VPWR VPWR sky130_fd_sc_hd__decap_3
XFILLER_15_261 VGND VGND VPWR VPWR sky130_fd_sc_hd__decap_3
XTAP_TAPCELL_ROW_33_727 VGND VPWR sky130_fd_sc_hd__tapvpwrvgnd_1
XFILLER_31_732 VGND VGND VPWR VPWR sky130_fd_sc_hd__decap_3
XFILLER_15_294 VGND VGND VPWR VPWR sky130_fd_sc_hd__decap_3
XFILLER_30_231 VGND VGND VPWR VPWR sky130_fd_sc_hd__fill_1
XFILLER_30_242 VGND VGND VPWR VPWR sky130_fd_sc_hd__decap_3
X_4610_ _9015_/S VGND VGND VPWR VPWR _4629_/S sky130_fd_sc_hd__clkbuf_2
XTAP_TAPCELL_ROW_13_451 VGND VPWR sky130_fd_sc_hd__tapvpwrvgnd_1
XFILLER_129_620 VGND VGND VPWR VPWR sky130_fd_sc_hd__decap_3
X_5590_ _7317_/A _8309_/A _7952_/A _6304_/A VGND VGND VPWR VPWR _5591_/B sky130_fd_sc_hd__a211o_2
XTAP_TAPCELL_ROW_13_462 VGND VPWR sky130_fd_sc_hd__tapvpwrvgnd_1
XFILLER_30_286 VGND VGND VPWR VPWR sky130_fd_sc_hd__decap_3
XFILLER_129_653 VGND VGND VPWR VPWR sky130_fd_sc_hd__decap_3
XFILLER_128_130 VGND VGND VPWR VPWR sky130_fd_sc_hd__decap_3
X_4541_ _4541_/A VGND VGND VPWR VPWR _9023_/D sky130_fd_sc_hd__buf_1
XFILLER_128_141 VGND VGND VPWR VPWR sky130_fd_sc_hd__decap_3
XFILLER_116_303 VGND VGND VPWR VPWR sky130_fd_sc_hd__decap_3
Xmax_cap102 _5011_/X VGND VGND VPWR VPWR _5043_/B sky130_fd_sc_hd__buf_4
XFILLER_129_697 VGND VGND VPWR VPWR sky130_fd_sc_hd__decap_3
XFILLER_128_174 VGND VGND VPWR VPWR sky130_fd_sc_hd__decap_3
X_7260_ _7263_/A _7263_/B VGND VGND VPWR VPWR _7510_/B sky130_fd_sc_hd__nor2_2
Xmax_cap124 _5584_/X VGND VGND VPWR VPWR _8170_/A sky130_fd_sc_hd__buf_2
XFILLER_7_482 VGND VGND VPWR VPWR sky130_fd_sc_hd__decap_3
XTAP_TAPCELL_ROW_96_1578 VGND VPWR sky130_fd_sc_hd__tapvpwrvgnd_1
Xmax_cap135 _5061_/Y VGND VGND VPWR VPWR max_cap135/X sky130_fd_sc_hd__buf_6
XFILLER_116_358 VGND VGND VPWR VPWR sky130_fd_sc_hd__decap_3
X_6211_ _6211_/A _6211_/B VGND VGND VPWR VPWR _6212_/B sky130_fd_sc_hd__nor2_2
Xmax_cap157 wire158/X VGND VGND VPWR VPWR _6311_/A sky130_fd_sc_hd__buf_4
X_7191_ _7243_/A _7191_/B VGND VGND VPWR VPWR _7192_/B sky130_fd_sc_hd__xnor2_2
Xmax_cap168 _5689_/B VGND VGND VPWR VPWR _5483_/A2 sky130_fd_sc_hd__clkbuf_2
Xmax_cap179 _5006_/B VGND VGND VPWR VPWR _6757_/C sky130_fd_sc_hd__clkbuf_2
XFILLER_98_710 VGND VGND VPWR VPWR sky130_fd_sc_hd__decap_3
X_6142_ _6142_/A0 _6141_/Y _6460_/S VGND VGND VPWR VPWR _6142_/X sky130_fd_sc_hd__mux2_2
XFILLER_112_531 VGND VGND VPWR VPWR sky130_fd_sc_hd__fill_1
XFILLER_112_542 VGND VGND VPWR VPWR sky130_fd_sc_hd__decap_3
Xload_slew330 _7227_/B1 VGND VGND VPWR VPWR _6821_/S sky130_fd_sc_hd__clkbuf_4
XFILLER_98_776 VGND VGND VPWR VPWR sky130_fd_sc_hd__fill_1
XFILLER_100_704 VGND VGND VPWR VPWR sky130_fd_sc_hd__fill_2
XFILLER_58_618 VGND VGND VPWR VPWR sky130_fd_sc_hd__decap_3
XFILLER_100_715 VGND VGND VPWR VPWR sky130_fd_sc_hd__fill_2
X_6073_ _6073_/A VGND VGND VPWR VPWR _9207_/D sky130_fd_sc_hd__buf_1
Xload_slew352 rebuffer656/X VGND VGND VPWR VPWR _6807_/A sky130_fd_sc_hd__clkbuf_4
XTAP_TAPCELL_ROW_127_2000 VGND VPWR sky130_fd_sc_hd__tapvpwrvgnd_1
Xhold1105 _9138_/Q VGND VGND VPWR VPWR _4817_/A1 sky130_fd_sc_hd__dlygate4sd3_1
Xload_slew374 fanout373/X VGND VGND VPWR VPWR load_slew374/X sky130_fd_sc_hd__buf_2
Xhold1116 _9168_/Q VGND VGND VPWR VPWR _4847_/A0 sky130_fd_sc_hd__dlygate4sd3_1
X_5024_ _4984_/Y _5017_/Y _5023_/Y VGND VGND VPWR VPWR _5024_/Y sky130_fd_sc_hd__o21ai_2
Xhold1127 _9311_/Q VGND VGND VPWR VPWR _8972_/A1 sky130_fd_sc_hd__dlygate4sd3_1
Xload_slew396 load_slew397/X VGND VGND VPWR VPWR load_slew396/X sky130_fd_sc_hd__buf_6
Xhold1138 _9308_/Q VGND VGND VPWR VPWR _8965_/A1 sky130_fd_sc_hd__dlygate4sd3_1
Xhold1149 _4819_/X VGND VGND VPWR VPWR _4820_/A sky130_fd_sc_hd__dlygate4sd3_1
XFILLER_66_651 VGND VGND VPWR VPWR sky130_fd_sc_hd__decap_3
XFILLER_66_673 VGND VGND VPWR VPWR sky130_fd_sc_hd__decap_3
XFILLER_26_504 VGND VGND VPWR VPWR sky130_fd_sc_hd__decap_3
XFILLER_93_470 VGND VGND VPWR VPWR sky130_fd_sc_hd__decap_3
XFILLER_65_161 VGND VGND VPWR VPWR sky130_fd_sc_hd__decap_3
XFILLER_38_386 VGND VGND VPWR VPWR sky130_fd_sc_hd__fill_1
XFILLER_26_526 VGND VGND VPWR VPWR sky130_fd_sc_hd__decap_3
XFILLER_81_643 VGND VGND VPWR VPWR sky130_fd_sc_hd__decap_3
XFILLER_26_548 VGND VGND VPWR VPWR sky130_fd_sc_hd__decap_3
XFILLER_26_559 VGND VGND VPWR VPWR sky130_fd_sc_hd__decap_3
X_6975_ _6975_/A _6975_/B VGND VGND VPWR VPWR _7038_/A sky130_fd_sc_hd__xnor2_2
XFILLER_81_665 VGND VGND VPWR VPWR sky130_fd_sc_hd__decap_3
X_8714_ _8714_/A _8718_/A VGND VGND VPWR VPWR _8714_/Y sky130_fd_sc_hd__xnor2_2
XFILLER_53_378 VGND VGND VPWR VPWR sky130_fd_sc_hd__decap_3
X_5926_ _6817_/A _5926_/B VGND VGND VPWR VPWR _8020_/A sky130_fd_sc_hd__nor2_2
XFILLER_81_698 VGND VGND VPWR VPWR sky130_fd_sc_hd__decap_3
XFILLER_41_529 VGND VGND VPWR VPWR sky130_fd_sc_hd__decap_3
XTAP_TAPCELL_ROW_105_1696 VGND VPWR sky130_fd_sc_hd__tapvpwrvgnd_1
XFILLER_80_197 VGND VGND VPWR VPWR sky130_fd_sc_hd__decap_3
XFILLER_110_47 VGND VGND VPWR VPWR sky130_fd_sc_hd__decap_3
XFILLER_22_743 VGND VGND VPWR VPWR sky130_fd_sc_hd__decap_3
X_8645_ _8643_/X _8649_/C _8674_/A VGND VGND VPWR VPWR _8645_/X sky130_fd_sc_hd__mux2_2
X_5857_ _6157_/B _6161_/B VGND VGND VPWR VPWR _5858_/A sky130_fd_sc_hd__xnor2_2
XFILLER_21_231 VGND VGND VPWR VPWR sky130_fd_sc_hd__fill_2
XFILLER_21_242 VGND VGND VPWR VPWR sky130_fd_sc_hd__decap_3
X_4808_ _4808_/A VGND VGND VPWR VPWR _9149_/D sky130_fd_sc_hd__buf_1
X_8576_ _8576_/A _8576_/B VGND VGND VPWR VPWR _8633_/C sky130_fd_sc_hd__nand2_2
Xrebuffer502 _7098_/C VGND VGND VPWR VPWR _6952_/S sky130_fd_sc_hd__buf_2
X_5788_ _5950_/A _5785_/X _5786_/Y _5787_/Y VGND VGND VPWR VPWR _5789_/B sky130_fd_sc_hd__o2bb2a_2
Xrebuffer513 _6588_/A VGND VGND VPWR VPWR _5249_/A sky130_fd_sc_hd__buf_2
Xrebuffer524 _7624_/B VGND VGND VPWR VPWR _7438_/B sky130_fd_sc_hd__buf_2
XFILLER_119_12 VGND VGND VPWR VPWR sky130_fd_sc_hd__decap_3
X_7527_ _6077_/A _6416_/X _7525_/B _5535_/B VGND VGND VPWR VPWR _7527_/X sky130_fd_sc_hd__o22a_2
Xrebuffer535 _7564_/B VGND VGND VPWR VPWR _7288_/A2 sky130_fd_sc_hd__buf_2
X_4739_ _4739_/A VGND VGND VPWR VPWR _9116_/D sky130_fd_sc_hd__buf_1
Xrebuffer546 _6516_/Y VGND VGND VPWR VPWR _6517_/B1 sky130_fd_sc_hd__buf_2
Xrebuffer557 _7014_/Y VGND VGND VPWR VPWR _7018_/A2 sky130_fd_sc_hd__buf_2
XFILLER_119_45 VGND VGND VPWR VPWR sky130_fd_sc_hd__decap_3
Xrebuffer568 _7133_/B VGND VGND VPWR VPWR _7134_/A1 sky130_fd_sc_hd__buf_2
Xrebuffer579 _6363_/C VGND VGND VPWR VPWR _6364_/A1 sky130_fd_sc_hd__buf_2
X_7458_ _7458_/A _7458_/B _7458_/C VGND VGND VPWR VPWR _7626_/C sky130_fd_sc_hd__and3_2
XFILLER_79_27 VGND VGND VPWR VPWR sky130_fd_sc_hd__decap_3
XFILLER_119_78 VGND VGND VPWR VPWR sky130_fd_sc_hd__decap_3
XFILLER_102_6 VGND VGND VPWR VPWR sky130_fd_sc_hd__decap_3
XFILLER_107_369 VGND VGND VPWR VPWR sky130_fd_sc_hd__fill_1
X_6409_ _6483_/S _7728_/B VGND VGND VPWR VPWR _6467_/B sky130_fd_sc_hd__xnor2_2
Xhold950 _9171_/Q VGND VGND VPWR VPWR hold950/X sky130_fd_sc_hd__dlygate4sd3_1
XTAP_TAPCELL_ROW_56_1039 VGND VPWR sky130_fd_sc_hd__tapvpwrvgnd_1
XFILLER_1_603 VGND VGND VPWR VPWR sky130_fd_sc_hd__decap_3
X_7389_ _7032_/X _7132_/C1 _7031_/A _7388_/X VGND VGND VPWR VPWR _7389_/X sky130_fd_sc_hd__o2bb2a_2
Xhold961 _8881_/X VGND VGND VPWR VPWR _8882_/A sky130_fd_sc_hd__dlygate4sd3_1
Xhold972 _9032_/Q VGND VGND VPWR VPWR hold972/X sky130_fd_sc_hd__dlygate4sd3_1
XFILLER_122_328 VGND VGND VPWR VPWR sky130_fd_sc_hd__decap_3
XFILLER_89_732 VGND VGND VPWR VPWR sky130_fd_sc_hd__decap_3
XFILLER_0_113 VGND VGND VPWR VPWR sky130_fd_sc_hd__decap_3
XFILLER_103_520 VGND VGND VPWR VPWR sky130_fd_sc_hd__fill_1
Xhold983 _9028_/Q VGND VGND VPWR VPWR hold983/X sky130_fd_sc_hd__dlygate4sd3_1
X_9128_ _9159_/CLK _9128_/D fanout391/X VGND VGND VPWR VPWR _9128_/Q sky130_fd_sc_hd__dfrtp_2
Xhold994 _4865_/X VGND VGND VPWR VPWR _4866_/A sky130_fd_sc_hd__dlygate4sd3_1
XFILLER_89_754 VGND VGND VPWR VPWR sky130_fd_sc_hd__fill_2
XFILLER_1_647 VGND VGND VPWR VPWR sky130_fd_sc_hd__decap_3
XFILLER_88_231 VGND VGND VPWR VPWR sky130_fd_sc_hd__decap_3
XFILLER_103_553 VGND VGND VPWR VPWR sky130_fd_sc_hd__decap_3
XFILLER_88_253 VGND VGND VPWR VPWR sky130_fd_sc_hd__decap_3
XFILLER_103_564 VGND VGND VPWR VPWR sky130_fd_sc_hd__decap_3
XFILLER_76_404 VGND VGND VPWR VPWR sky130_fd_sc_hd__decap_3
X_9059_ _9343_/CLK _9059_/D load_slew397/X VGND VGND VPWR VPWR _9059_/Q sky130_fd_sc_hd__dfrtp_2
XFILLER_76_415 VGND VGND VPWR VPWR sky130_fd_sc_hd__decap_3
XFILLER_48_106 VGND VGND VPWR VPWR sky130_fd_sc_hd__fill_2
XFILLER_130_361 VGND VGND VPWR VPWR sky130_fd_sc_hd__decap_3
XFILLER_28_20 VGND VGND VPWR VPWR sky130_fd_sc_hd__decap_3
XFILLER_76_448 VGND VGND VPWR VPWR sky130_fd_sc_hd__decap_3
XFILLER_29_320 VGND VGND VPWR VPWR sky130_fd_sc_hd__decap_3
XFILLER_28_53 VGND VGND VPWR VPWR sky130_fd_sc_hd__decap_3
XFILLER_57_673 VGND VGND VPWR VPWR sky130_fd_sc_hd__decap_3
XFILLER_91_429 VGND VGND VPWR VPWR sky130_fd_sc_hd__decap_3
XFILLER_57_684 VGND VGND VPWR VPWR sky130_fd_sc_hd__decap_3
XFILLER_56_172 VGND VGND VPWR VPWR sky130_fd_sc_hd__decap_3
XFILLER_29_386 VGND VGND VPWR VPWR sky130_fd_sc_hd__decap_3
XFILLER_28_97 VGND VGND VPWR VPWR sky130_fd_sc_hd__decap_3
XFILLER_44_323 VGND VGND VPWR VPWR sky130_fd_sc_hd__fill_2
XFILLER_71_120 VGND VGND VPWR VPWR sky130_fd_sc_hd__decap_3
XFILLER_44_345 VGND VGND VPWR VPWR sky130_fd_sc_hd__decap_3
XFILLER_32_507 VGND VGND VPWR VPWR sky130_fd_sc_hd__decap_3
XFILLER_71_164 VGND VGND VPWR VPWR sky130_fd_sc_hd__decap_3
XFILLER_44_63 VGND VGND VPWR VPWR sky130_fd_sc_hd__decap_3
XFILLER_13_721 VGND VGND VPWR VPWR sky130_fd_sc_hd__decap_3
XFILLER_44_74 VGND VGND VPWR VPWR sky130_fd_sc_hd__decap_3
XFILLER_13_732 VGND VGND VPWR VPWR sky130_fd_sc_hd__decap_3
XFILLER_44_85 VGND VGND VPWR VPWR sky130_fd_sc_hd__decap_3
XFILLER_9_703 VGND VGND VPWR VPWR sky130_fd_sc_hd__decap_3
XTAP_TAPCELL_ROW_80_1357 VGND VPWR sky130_fd_sc_hd__tapvpwrvgnd_1
XFILLER_40_551 VGND VGND VPWR VPWR sky130_fd_sc_hd__decap_3
XFILLER_13_765 VGND VGND VPWR VPWR sky130_fd_sc_hd__decap_3
XTAP_TAPCELL_ROW_80_1368 VGND VPWR sky130_fd_sc_hd__tapvpwrvgnd_1
XFILLER_12_253 VGND VGND VPWR VPWR sky130_fd_sc_hd__decap_3
XFILLER_9_747 VGND VGND VPWR VPWR sky130_fd_sc_hd__decap_3
XFILLER_100_80 VGND VGND VPWR VPWR sky130_fd_sc_hd__decap_3
XFILLER_100_91 VGND VGND VPWR VPWR sky130_fd_sc_hd__decap_3
XTAP_TAPCELL_ROW_10_410 VGND VPWR sky130_fd_sc_hd__tapvpwrvgnd_1
XFILLER_60_40 VGND VGND VPWR VPWR sky130_fd_sc_hd__fill_2
XTAP_TAPCELL_ROW_10_421 VGND VPWR sky130_fd_sc_hd__tapvpwrvgnd_1
XFILLER_8_268 VGND VGND VPWR VPWR sky130_fd_sc_hd__decap_3
XFILLER_60_73 VGND VGND VPWR VPWR sky130_fd_sc_hd__decap_3
XFILLER_126_612 VGND VGND VPWR VPWR sky130_fd_sc_hd__decap_3
XFILLER_125_111 VGND VGND VPWR VPWR sky130_fd_sc_hd__fill_1
XFILLER_126_645 VGND VGND VPWR VPWR sky130_fd_sc_hd__decap_3
XFILLER_125_122 VGND VGND VPWR VPWR sky130_fd_sc_hd__decap_3
XFILLER_5_24 VGND VGND VPWR VPWR sky130_fd_sc_hd__decap_3
XFILLER_126_678 VGND VGND VPWR VPWR sky130_fd_sc_hd__decap_3
XFILLER_125_155 VGND VGND VPWR VPWR sky130_fd_sc_hd__decap_3
XFILLER_5_57 VGND VGND VPWR VPWR sky130_fd_sc_hd__decap_3
XFILLER_4_463 VGND VGND VPWR VPWR sky130_fd_sc_hd__decap_3
XFILLER_113_317 VGND VGND VPWR VPWR sky130_fd_sc_hd__fill_1
XFILLER_125_199 VGND VGND VPWR VPWR sky130_fd_sc_hd__decap_3
XFILLER_39_106 VGND VGND VPWR VPWR sky130_fd_sc_hd__decap_3
XFILLER_121_361 VGND VGND VPWR VPWR sky130_fd_sc_hd__decap_3
XFILLER_0_691 VGND VGND VPWR VPWR sky130_fd_sc_hd__decap_3
XFILLER_94_256 VGND VGND VPWR VPWR sky130_fd_sc_hd__decap_3
XFILLER_47_150 VGND VGND VPWR VPWR sky130_fd_sc_hd__decap_3
XFILLER_47_172 VGND VGND VPWR VPWR sky130_fd_sc_hd__decap_3
XFILLER_35_323 VGND VGND VPWR VPWR sky130_fd_sc_hd__decap_3
XTAP_TAPCELL_ROW_18_521 VGND VPWR sky130_fd_sc_hd__tapvpwrvgnd_1
XFILLER_35_334 VGND VGND VPWR VPWR sky130_fd_sc_hd__fill_2
XFILLER_63_654 VGND VGND VPWR VPWR sky130_fd_sc_hd__decap_3
XFILLER_90_451 VGND VGND VPWR VPWR sky130_fd_sc_hd__decap_3
XFILLER_63_676 VGND VGND VPWR VPWR sky130_fd_sc_hd__decap_3
XFILLER_62_153 VGND VGND VPWR VPWR sky130_fd_sc_hd__fill_1
XFILLER_23_518 VGND VGND VPWR VPWR sky130_fd_sc_hd__decap_3
XFILLER_35_378 VGND VGND VPWR VPWR sky130_fd_sc_hd__decap_3
X_6760_ _9333_/Q _4992_/X _5115_/X _9097_/Q VGND VGND VPWR VPWR _6762_/C sky130_fd_sc_hd__a22oi_2
XFILLER_63_698 VGND VGND VPWR VPWR sky130_fd_sc_hd__fill_2
XTAP_TAPCELL_ROW_46_896 VGND VPWR sky130_fd_sc_hd__tapvpwrvgnd_1
XFILLER_90_495 VGND VGND VPWR VPWR sky130_fd_sc_hd__decap_3
XFILLER_62_186 VGND VGND VPWR VPWR sky130_fd_sc_hd__decap_3
XFILLER_16_592 VGND VGND VPWR VPWR sky130_fd_sc_hd__decap_3
X_5711_ _5137_/X _5138_/X _7065_/A VGND VGND VPWR VPWR _5711_/Y sky130_fd_sc_hd__a21oi_2
XFILLER_50_348 VGND VGND VPWR VPWR sky130_fd_sc_hd__decap_3
X_6691_ _6691_/A _6691_/B VGND VGND VPWR VPWR _6699_/A sky130_fd_sc_hd__xnor2_2
XFILLER_31_551 VGND VGND VPWR VPWR sky130_fd_sc_hd__decap_3
X_8430_ _9223_/Q _8430_/B VGND VGND VPWR VPWR _8431_/B sky130_fd_sc_hd__and2_2
XTAP_TAPCELL_ROW_98_1607 VGND VPWR sky130_fd_sc_hd__tapvpwrvgnd_1
X_5642_ _5642_/A _5642_/B VGND VGND VPWR VPWR _5643_/B sky130_fd_sc_hd__nor2_2
XFILLER_31_595 VGND VGND VPWR VPWR sky130_fd_sc_hd__decap_3
X_8361_ _9221_/Q _8364_/B VGND VGND VPWR VPWR _8361_/Y sky130_fd_sc_hd__nor2_2
X_5573_ _8271_/B _8155_/A _5482_/A _5481_/A VGND VGND VPWR VPWR _5573_/X sky130_fd_sc_hd__a211o_2
XFILLER_116_100 VGND VGND VPWR VPWR sky130_fd_sc_hd__decap_3
X_7312_ _7088_/A _7088_/B _7311_/Y _7317_/A VGND VGND VPWR VPWR _7312_/X sky130_fd_sc_hd__a31o_2
X_4524_ _8688_/S VGND VGND VPWR VPWR _7561_/A sky130_fd_sc_hd__buf_4
XFILLER_117_645 VGND VGND VPWR VPWR sky130_fd_sc_hd__decap_3
X_8292_ _8292_/A VGND VGND VPWR VPWR _9221_/D sky130_fd_sc_hd__buf_1
XFILLER_7_290 VGND VGND VPWR VPWR sky130_fd_sc_hd__decap_3
XFILLER_117_667 VGND VGND VPWR VPWR sky130_fd_sc_hd__decap_3
XFILLER_116_144 VGND VGND VPWR VPWR sky130_fd_sc_hd__fill_1
X_7243_ _7243_/A _7243_/B VGND VGND VPWR VPWR _7243_/X sky130_fd_sc_hd__and2_2
XFILLER_104_317 VGND VGND VPWR VPWR sky130_fd_sc_hd__decap_3
X_7174_ _7174_/A _7174_/B VGND VGND VPWR VPWR _7229_/B sky130_fd_sc_hd__xnor2_2
X_6125_ _6125_/A _6125_/B VGND VGND VPWR VPWR _6126_/B sky130_fd_sc_hd__xor2_2
XFILLER_58_404 VGND VGND VPWR VPWR sky130_fd_sc_hd__decap_3
XFILLER_85_223 VGND VGND VPWR VPWR sky130_fd_sc_hd__fill_1
XFILLER_100_545 VGND VGND VPWR VPWR sky130_fd_sc_hd__decap_3
X_6056_ _6057_/B wire62/X _6057_/A VGND VGND VPWR VPWR _6056_/X sky130_fd_sc_hd__a21o_2
XFILLER_100_567 VGND VGND VPWR VPWR sky130_fd_sc_hd__decap_3
XFILLER_39_662 VGND VGND VPWR VPWR sky130_fd_sc_hd__fill_1
XFILLER_100_589 VGND VGND VPWR VPWR sky130_fd_sc_hd__fill_2
X_5007_ _9303_/Q _6758_/B _6758_/C VGND VGND VPWR VPWR _5007_/X sky130_fd_sc_hd__and3_2
XFILLER_39_673 VGND VGND VPWR VPWR sky130_fd_sc_hd__decap_3
XTAP_TAPCELL_ROW_107_1725 VGND VPWR sky130_fd_sc_hd__tapvpwrvgnd_1
XFILLER_54_621 VGND VGND VPWR VPWR sky130_fd_sc_hd__decap_3
XFILLER_38_172 VGND VGND VPWR VPWR sky130_fd_sc_hd__decap_3
XFILLER_26_312 VGND VGND VPWR VPWR sky130_fd_sc_hd__decap_3
XFILLER_121_24 VGND VGND VPWR VPWR sky130_fd_sc_hd__decap_3
XFILLER_81_462 VGND VGND VPWR VPWR sky130_fd_sc_hd__decap_3
XFILLER_54_676 VGND VGND VPWR VPWR sky130_fd_sc_hd__decap_3
XFILLER_41_304 VGND VGND VPWR VPWR sky130_fd_sc_hd__decap_3
XFILLER_121_57 VGND VGND VPWR VPWR sky130_fd_sc_hd__decap_3
XTAP_TAPCELL_ROW_120_1903 VGND VPWR sky130_fd_sc_hd__tapvpwrvgnd_1
XFILLER_26_389 VGND VGND VPWR VPWR sky130_fd_sc_hd__decap_3
X_6958_ _7430_/A _5719_/A _7417_/A _7071_/B VGND VGND VPWR VPWR _6960_/A sky130_fd_sc_hd__o211a_2
XFILLER_81_495 VGND VGND VPWR VPWR sky130_fd_sc_hd__fill_1
XFILLER_41_337 VGND VGND VPWR VPWR sky130_fd_sc_hd__decap_3
X_5909_ _5768_/A _5768_/B _5765_/A _5766_/B VGND VGND VPWR VPWR _5911_/B sky130_fd_sc_hd__o211a_2
X_6889_ _6889_/A _7212_/B VGND VGND VPWR VPWR _6890_/B sky130_fd_sc_hd__xor2_2
XFILLER_22_562 VGND VGND VPWR VPWR sky130_fd_sc_hd__fill_2
XFILLER_14_55 VGND VGND VPWR VPWR sky130_fd_sc_hd__decap_3
XFILLER_10_713 VGND VGND VPWR VPWR sky130_fd_sc_hd__decap_3
X_8628_ _8644_/A _8627_/Y _8649_/B VGND VGND VPWR VPWR _8628_/X sky130_fd_sc_hd__mux2_2
XPHY_EDGE_ROW_101_Left_232 VGND VGND VPWR VPWR sky130_fd_sc_hd__decap_3
XFILLER_14_88 VGND VGND VPWR VPWR sky130_fd_sc_hd__decap_3
XFILLER_10_746 VGND VGND VPWR VPWR sky130_fd_sc_hd__decap_3
XFILLER_10_757 VGND VGND VPWR VPWR sky130_fd_sc_hd__decap_3
X_8559_ _8562_/A _8443_/B _8558_/X VGND VGND VPWR VPWR _8559_/Y sky130_fd_sc_hd__o21ai_2
XFILLER_6_728 VGND VGND VPWR VPWR sky130_fd_sc_hd__decap_3
XFILLER_5_205 VGND VGND VPWR VPWR sky130_fd_sc_hd__decap_3
XFILLER_108_645 VGND VGND VPWR VPWR sky130_fd_sc_hd__decap_3
XTAP_TAPCELL_ROW_118_1876 VGND VPWR sky130_fd_sc_hd__tapvpwrvgnd_1
XFILLER_5_249 VGND VGND VPWR VPWR sky130_fd_sc_hd__decap_3
XFILLER_100_3 VGND VGND VPWR VPWR sky130_fd_sc_hd__decap_3
XFILLER_108_689 VGND VGND VPWR VPWR sky130_fd_sc_hd__decap_3
XFILLER_123_615 VGND VGND VPWR VPWR sky130_fd_sc_hd__fill_1
XFILLER_107_166 VGND VGND VPWR VPWR sky130_fd_sc_hd__fill_2
XFILLER_122_103 VGND VGND VPWR VPWR sky130_fd_sc_hd__decap_3
XFILLER_1_411 VGND VGND VPWR VPWR sky130_fd_sc_hd__decap_3
Xhold780 _6446_/A VGND VGND VPWR VPWR hold780/X sky130_fd_sc_hd__dlygate4sd3_1
XFILLER_122_136 VGND VGND VPWR VPWR sky130_fd_sc_hd__decap_3
Xhold791 _9189_/Q VGND VGND VPWR VPWR hold791/X sky130_fd_sc_hd__dlygate4sd3_1
XFILLER_122_147 VGND VGND VPWR VPWR sky130_fd_sc_hd__decap_3
XFILLER_110_309 VGND VGND VPWR VPWR sky130_fd_sc_hd__fill_1
XFILLER_103_361 VGND VGND VPWR VPWR sky130_fd_sc_hd__decap_3
XFILLER_77_724 VGND VGND VPWR VPWR sky130_fd_sc_hd__decap_3
XFILLER_77_735 VGND VGND VPWR VPWR sky130_fd_sc_hd__decap_3
XPHY_EDGE_ROW_110_Left_241 VGND VGND VPWR VPWR sky130_fd_sc_hd__decap_3
XFILLER_39_63 VGND VGND VPWR VPWR sky130_fd_sc_hd__decap_3
XFILLER_77_757 VGND VGND VPWR VPWR sky130_fd_sc_hd__decap_3
XFILLER_76_234 VGND VGND VPWR VPWR sky130_fd_sc_hd__decap_3
XFILLER_39_96 VGND VGND VPWR VPWR sky130_fd_sc_hd__decap_3
XTAP_TAPCELL_ROW_69_1208 VGND VPWR sky130_fd_sc_hd__tapvpwrvgnd_1
XTAP_TAPCELL_ROW_69_1219 VGND VPWR sky130_fd_sc_hd__tapvpwrvgnd_1
XFILLER_76_278 VGND VGND VPWR VPWR sky130_fd_sc_hd__decap_3
XFILLER_57_470 VGND VGND VPWR VPWR sky130_fd_sc_hd__decap_3
XFILLER_29_183 VGND VGND VPWR VPWR sky130_fd_sc_hd__decap_3
XFILLER_45_643 VGND VGND VPWR VPWR sky130_fd_sc_hd__fill_2
XFILLER_55_51 VGND VGND VPWR VPWR sky130_fd_sc_hd__decap_3
XFILLER_45_676 VGND VGND VPWR VPWR sky130_fd_sc_hd__decap_3
XFILLER_72_473 VGND VGND VPWR VPWR sky130_fd_sc_hd__decap_3
XFILLER_72_495 VGND VGND VPWR VPWR sky130_fd_sc_hd__decap_3
XFILLER_60_635 VGND VGND VPWR VPWR sky130_fd_sc_hd__fill_1
XFILLER_44_186 VGND VGND VPWR VPWR sky130_fd_sc_hd__decap_3
XFILLER_44_197 VGND VGND VPWR VPWR sky130_fd_sc_hd__decap_3
XTAP_TAPCELL_ROW_43_866 VGND VPWR sky130_fd_sc_hd__tapvpwrvgnd_1
XFILLER_111_90 VGND VGND VPWR VPWR sky130_fd_sc_hd__decap_3
XFILLER_9_511 VGND VGND VPWR VPWR sky130_fd_sc_hd__decap_3
XFILLER_71_94 VGND VGND VPWR VPWR sky130_fd_sc_hd__fill_2
XFILLER_40_392 VGND VGND VPWR VPWR sky130_fd_sc_hd__fill_1
XTAP_TAPCELL_ROW_23_590 VGND VPWR sky130_fd_sc_hd__tapvpwrvgnd_1
XFILLER_65_6 VGND VGND VPWR VPWR sky130_fd_sc_hd__decap_3
XFILLER_126_431 VGND VGND VPWR VPWR sky130_fd_sc_hd__decap_3
XFILLER_5_750 VGND VGND VPWR VPWR sky130_fd_sc_hd__decap_3
XTAP_TAPCELL_ROW_93_1537 VGND VPWR sky130_fd_sc_hd__tapvpwrvgnd_1
XFILLER_126_486 VGND VGND VPWR VPWR sky130_fd_sc_hd__fill_2
XFILLER_99_337 VGND VGND VPWR VPWR sky130_fd_sc_hd__fill_1
XFILLER_4_271 VGND VGND VPWR VPWR sky130_fd_sc_hd__decap_3
XFILLER_114_648 VGND VGND VPWR VPWR sky130_fd_sc_hd__decap_3
XFILLER_68_713 VGND VGND VPWR VPWR sky130_fd_sc_hd__decap_3
XFILLER_95_521 VGND VGND VPWR VPWR sky130_fd_sc_hd__fill_1
XFILLER_122_681 VGND VGND VPWR VPWR sky130_fd_sc_hd__decap_3
XFILLER_95_532 VGND VGND VPWR VPWR sky130_fd_sc_hd__decap_3
XFILLER_68_757 VGND VGND VPWR VPWR sky130_fd_sc_hd__decap_3
X_7930_ _7791_/A _7791_/B _7929_/X VGND VGND VPWR VPWR _7978_/A sky130_fd_sc_hd__o21a_2
X_7861_ _7741_/A _7740_/B _7860_/X VGND VGND VPWR VPWR _7997_/A sky130_fd_sc_hd__a21o_2
XFILLER_36_654 VGND VGND VPWR VPWR sky130_fd_sc_hd__fill_1
XFILLER_51_602 VGND VGND VPWR VPWR sky130_fd_sc_hd__decap_3
XFILLER_63_462 VGND VGND VPWR VPWR sky130_fd_sc_hd__fill_1
XFILLER_36_687 VGND VGND VPWR VPWR sky130_fd_sc_hd__decap_3
XFILLER_35_153 VGND VGND VPWR VPWR sky130_fd_sc_hd__decap_3
X_6812_ _6434_/Y _6436_/Y _6812_/S VGND VGND VPWR VPWR _6812_/X sky130_fd_sc_hd__mux2_2
XFILLER_50_101 VGND VGND VPWR VPWR sky130_fd_sc_hd__decap_3
XFILLER_23_315 VGND VGND VPWR VPWR sky130_fd_sc_hd__decap_3
X_7792_ _7792_/A _7792_/B VGND VGND VPWR VPWR _7981_/A sky130_fd_sc_hd__xnor2_2
XFILLER_51_635 VGND VGND VPWR VPWR sky130_fd_sc_hd__decap_3
XFILLER_51_657 VGND VGND VPWR VPWR sky130_fd_sc_hd__fill_1
XFILLER_23_348 VGND VGND VPWR VPWR sky130_fd_sc_hd__decap_3
XFILLER_50_134 VGND VGND VPWR VPWR sky130_fd_sc_hd__fill_1
X_6743_ _7480_/C _8161_/B _6624_/B _9210_/Q VGND VGND VPWR VPWR _6743_/X sky130_fd_sc_hd__o211a_2
XTAP_TAPCELL_ROW_102_1655 VGND VPWR sky130_fd_sc_hd__tapvpwrvgnd_1
X_6674_ _6670_/B _6673_/Y _6666_/A VGND VGND VPWR VPWR _6774_/B sky130_fd_sc_hd__o21ai_2
X_8413_ _8137_/A _7573_/B _7951_/A _7952_/A VGND VGND VPWR VPWR _8413_/X sky130_fd_sc_hd__o22a_2
X_5625_ _9154_/Q _5879_/B _5879_/C VGND VGND VPWR VPWR _5626_/D sky130_fd_sc_hd__and3_2
X_8344_ _8344_/A wire67/X VGND VGND VPWR VPWR _8398_/B sky130_fd_sc_hd__nor2_2
X_5556_ _5519_/B _5554_/X _5555_/X VGND VGND VPWR VPWR _5556_/X sky130_fd_sc_hd__a21o_2
XFILLER_3_709 VGND VGND VPWR VPWR sky130_fd_sc_hd__decap_3
XFILLER_117_475 VGND VGND VPWR VPWR sky130_fd_sc_hd__decap_3
X_8275_ _8304_/B _8275_/B VGND VGND VPWR VPWR _8276_/A sky130_fd_sc_hd__xor2_2
X_5487_ _7480_/C _5392_/B _5479_/B _5486_/X _9202_/Q VGND VGND VPWR VPWR _5487_/X
+ sky130_fd_sc_hd__o32a_2
X_7226_ _7869_/A _7525_/B VGND VGND VPWR VPWR _7522_/B sky130_fd_sc_hd__xnor2_2
XFILLER_116_24 VGND VGND VPWR VPWR sky130_fd_sc_hd__decap_3
XFILLER_116_35 VGND VGND VPWR VPWR sky130_fd_sc_hd__decap_3
XFILLER_120_618 VGND VGND VPWR VPWR sky130_fd_sc_hd__decap_3
X_7157_ _7212_/A VGND VGND VPWR VPWR _7157_/Y sky130_fd_sc_hd__inv_2
XFILLER_59_724 VGND VGND VPWR VPWR sky130_fd_sc_hd__decap_3
XFILLER_116_68 VGND VGND VPWR VPWR sky130_fd_sc_hd__decap_3
XFILLER_59_735 VGND VGND VPWR VPWR sky130_fd_sc_hd__decap_3
XFILLER_58_212 VGND VGND VPWR VPWR sky130_fd_sc_hd__decap_3
XFILLER_59_746 VGND VGND VPWR VPWR sky130_fd_sc_hd__fill_2
X_6108_ _7728_/B _6108_/B VGND VGND VPWR VPWR _6109_/B sky130_fd_sc_hd__xnor2_2
X_7088_ _7088_/A _7088_/B VGND VGND VPWR VPWR _7090_/B sky130_fd_sc_hd__and2_4
XFILLER_74_716 VGND VGND VPWR VPWR sky130_fd_sc_hd__decap_3
XFILLER_18_109 VGND VGND VPWR VPWR sky130_fd_sc_hd__decap_3
XFILLER_73_204 VGND VGND VPWR VPWR sky130_fd_sc_hd__fill_2
X_6039_ _6039_/A _8309_/A VGND VGND VPWR VPWR _6041_/B sky130_fd_sc_hd__nand2_4
XFILLER_86_598 VGND VGND VPWR VPWR sky130_fd_sc_hd__decap_3
XFILLER_39_492 VGND VGND VPWR VPWR sky130_fd_sc_hd__decap_3
XFILLER_27_643 VGND VGND VPWR VPWR sky130_fd_sc_hd__decap_3
XFILLER_92_27 VGND VGND VPWR VPWR sky130_fd_sc_hd__fill_1
XFILLER_27_676 VGND VGND VPWR VPWR sky130_fd_sc_hd__decap_3
XFILLER_26_153 VGND VGND VPWR VPWR sky130_fd_sc_hd__fill_1
XFILLER_25_21 VGND VGND VPWR VPWR sky130_fd_sc_hd__decap_3
XTAP_TAPCELL_ROW_1_296 VGND VPWR sky130_fd_sc_hd__tapvpwrvgnd_1
XFILLER_54_484 VGND VGND VPWR VPWR sky130_fd_sc_hd__decap_3
XFILLER_14_315 VGND VGND VPWR VPWR sky130_fd_sc_hd__decap_3
XFILLER_81_270 VGND VGND VPWR VPWR sky130_fd_sc_hd__fill_1
XFILLER_81_281 VGND VGND VPWR VPWR sky130_fd_sc_hd__fill_2
XFILLER_25_43 VGND VGND VPWR VPWR sky130_fd_sc_hd__decap_3
XTAP_TAPCELL_ROW_64_1149 VGND VPWR sky130_fd_sc_hd__tapvpwrvgnd_1
XFILLER_41_134 VGND VGND VPWR VPWR sky130_fd_sc_hd__decap_3
XFILLER_14_359 VGND VGND VPWR VPWR sky130_fd_sc_hd__decap_3
XTAP_TAPCELL_ROW_40_825 VGND VPWR sky130_fd_sc_hd__tapvpwrvgnd_1
XFILLER_22_381 VGND VGND VPWR VPWR sky130_fd_sc_hd__decap_3
XFILLER_128_707 VGND VGND VPWR VPWR sky130_fd_sc_hd__decap_3
XFILLER_127_217 VGND VGND VPWR VPWR sky130_fd_sc_hd__decap_3
XFILLER_127_228 VGND VGND VPWR VPWR sky130_fd_sc_hd__decap_3
XFILLER_6_536 VGND VGND VPWR VPWR sky130_fd_sc_hd__decap_3
XFILLER_10_587 VGND VGND VPWR VPWR sky130_fd_sc_hd__fill_1
XFILLER_108_442 VGND VGND VPWR VPWR sky130_fd_sc_hd__fill_2
XFILLER_6_558 VGND VGND VPWR VPWR sky130_fd_sc_hd__decap_3
XFILLER_108_453 VGND VGND VPWR VPWR sky130_fd_sc_hd__decap_3
XFILLER_108_475 VGND VGND VPWR VPWR sky130_fd_sc_hd__fill_1
XFILLER_123_434 VGND VGND VPWR VPWR sky130_fd_sc_hd__decap_3
XFILLER_2_731 VGND VGND VPWR VPWR sky130_fd_sc_hd__decap_3
XTAP_TAPCELL_ROW_75_1289 VGND VPWR sky130_fd_sc_hd__tapvpwrvgnd_1
XFILLER_123_467 VGND VGND VPWR VPWR sky130_fd_sc_hd__decap_3
XFILLER_96_318 VGND VGND VPWR VPWR sky130_fd_sc_hd__fill_1
XFILLER_2_775 VGND VGND VPWR VPWR sky130_fd_sc_hd__fill_2
XFILLER_1_263 VGND VGND VPWR VPWR sky130_fd_sc_hd__fill_2
XFILLER_49_234 VGND VGND VPWR VPWR sky130_fd_sc_hd__decap_3
XFILLER_1_296 VGND VGND VPWR VPWR sky130_fd_sc_hd__fill_1
XFILLER_2_47 VGND VGND VPWR VPWR sky130_fd_sc_hd__decap_3
XFILLER_49_267 VGND VGND VPWR VPWR sky130_fd_sc_hd__decap_3
XTAP_TAPCELL_ROW_48_925 VGND VPWR sky130_fd_sc_hd__tapvpwrvgnd_1
XFILLER_92_524 VGND VGND VPWR VPWR sky130_fd_sc_hd__decap_3
XTAP_TAPCELL_ROW_48_936 VGND VPWR sky130_fd_sc_hd__tapvpwrvgnd_1
XFILLER_92_546 VGND VGND VPWR VPWR sky130_fd_sc_hd__decap_3
XFILLER_18_632 VGND VGND VPWR VPWR sky130_fd_sc_hd__decap_3
XFILLER_66_94 VGND VGND VPWR VPWR sky130_fd_sc_hd__decap_3
XFILLER_17_120 VGND VGND VPWR VPWR sky130_fd_sc_hd__decap_3
XFILLER_80_719 VGND VGND VPWR VPWR sky130_fd_sc_hd__fill_2
XFILLER_33_602 VGND VGND VPWR VPWR sky130_fd_sc_hd__decap_3
XFILLER_18_676 VGND VGND VPWR VPWR sky130_fd_sc_hd__decap_3
XTAP_TAPCELL_ROW_28_660 VGND VPWR sky130_fd_sc_hd__tapvpwrvgnd_1
XFILLER_33_613 VGND VGND VPWR VPWR sky130_fd_sc_hd__decap_3
XFILLER_17_164 VGND VGND VPWR VPWR sky130_fd_sc_hd__decap_3
XFILLER_18_698 VGND VGND VPWR VPWR sky130_fd_sc_hd__fill_2
XFILLER_60_421 VGND VGND VPWR VPWR sky130_fd_sc_hd__decap_3
XFILLER_33_635 VGND VGND VPWR VPWR sky130_fd_sc_hd__decap_3
XFILLER_72_292 VGND VGND VPWR VPWR sky130_fd_sc_hd__fill_1
XFILLER_60_443 VGND VGND VPWR VPWR sky130_fd_sc_hd__decap_3
XFILLER_60_487 VGND VGND VPWR VPWR sky130_fd_sc_hd__decap_3
XFILLER_13_381 VGND VGND VPWR VPWR sky130_fd_sc_hd__decap_3
XFILLER_119_729 VGND VGND VPWR VPWR sky130_fd_sc_hd__decap_3
X_5410_ _5410_/A _5410_/B VGND VGND VPWR VPWR _5412_/A sky130_fd_sc_hd__or2_2
XFILLER_63_3 VGND VGND VPWR VPWR sky130_fd_sc_hd__decap_3
X_6390_ _6390_/A _6390_/B VGND VGND VPWR VPWR _6390_/Y sky130_fd_sc_hd__xnor2_2
XFILLER_127_762 VGND VGND VPWR VPWR sky130_fd_sc_hd__decap_3
X_5341_ _5452_/C _5452_/B VGND VGND VPWR VPWR _5367_/A sky130_fd_sc_hd__nor2_2
XFILLER_114_401 VGND VGND VPWR VPWR sky130_fd_sc_hd__decap_3
XTAP_TAPCELL_ROW_130_2040 VGND VPWR sky130_fd_sc_hd__tapvpwrvgnd_1
XFILLER_126_283 VGND VGND VPWR VPWR sky130_fd_sc_hd__decap_3
XTAP_TAPCELL_ROW_130_2051 VGND VPWR sky130_fd_sc_hd__tapvpwrvgnd_1
X_8060_ _8233_/B2 _8154_/A _8059_/Y VGND VGND VPWR VPWR _8061_/B sky130_fd_sc_hd__a21oi_2
X_5272_ _5272_/A VGND VGND VPWR VPWR _5272_/X sky130_fd_sc_hd__buf_8
XFILLER_114_456 VGND VGND VPWR VPWR sky130_fd_sc_hd__decap_3
XFILLER_102_607 VGND VGND VPWR VPWR sky130_fd_sc_hd__fill_1
X_7011_ _7099_/B _7012_/B VGND VGND VPWR VPWR _7013_/C sky130_fd_sc_hd__nor2_2
XFILLER_99_178 VGND VGND VPWR VPWR sky130_fd_sc_hd__decap_3
XFILLER_114_489 VGND VGND VPWR VPWR sky130_fd_sc_hd__decap_3
XFILLER_68_510 VGND VGND VPWR VPWR sky130_fd_sc_hd__decap_3
XFILLER_68_565 VGND VGND VPWR VPWR sky130_fd_sc_hd__decap_3
XFILLER_110_651 VGND VGND VPWR VPWR sky130_fd_sc_hd__decap_3
XFILLER_83_502 VGND VGND VPWR VPWR sky130_fd_sc_hd__fill_2
XFILLER_56_738 VGND VGND VPWR VPWR sky130_fd_sc_hd__decap_3
X_8962_ _8962_/A VGND VGND VPWR VPWR _9322_/D sky130_fd_sc_hd__buf_1
XFILLER_83_524 VGND VGND VPWR VPWR sky130_fd_sc_hd__decap_3
XFILLER_83_557 VGND VGND VPWR VPWR sky130_fd_sc_hd__decap_3
X_7913_ _7913_/A VGND VGND VPWR VPWR wire66/A sky130_fd_sc_hd__clkbuf_1
XFILLER_36_440 VGND VGND VPWR VPWR sky130_fd_sc_hd__fill_2
XFILLER_102_15 VGND VGND VPWR VPWR sky130_fd_sc_hd__fill_2
X_8893_ _8893_/A VGND VGND VPWR VPWR _9289_/D sky130_fd_sc_hd__buf_1
XFILLER_64_760 VGND VGND VPWR VPWR sky130_fd_sc_hd__decap_3
XFILLER_24_602 VGND VGND VPWR VPWR sky130_fd_sc_hd__decap_3
X_7844_ wire67/A _7832_/X _7837_/X _9214_/Q _7843_/X VGND VGND VPWR VPWR _7845_/B
+ sky130_fd_sc_hd__o221a_2
XFILLER_70_229 VGND VGND VPWR VPWR sky130_fd_sc_hd__fill_1
XFILLER_51_443 VGND VGND VPWR VPWR sky130_fd_sc_hd__decap_3
X_7775_ _7775_/A _7775_/B VGND VGND VPWR VPWR _7776_/B sky130_fd_sc_hd__xnor2_2
X_4987_ _9019_/Q _9147_/Q _5059_/S VGND VGND VPWR VPWR _4987_/X sky130_fd_sc_hd__mux2_2
XFILLER_11_318 VGND VGND VPWR VPWR sky130_fd_sc_hd__decap_3
X_6726_ _7016_/B _7016_/C _6732_/A _6725_/Y VGND VGND VPWR VPWR _6733_/D sky130_fd_sc_hd__a211o_2
XFILLER_109_217 VGND VGND VPWR VPWR sky130_fd_sc_hd__fill_2
X_6657_ _6657_/A _6657_/B VGND VGND VPWR VPWR _6778_/A sky130_fd_sc_hd__and2_2
X_5608_ _5434_/A _5433_/B _5433_/A VGND VGND VPWR VPWR _5608_/X sky130_fd_sc_hd__a21o_2
XFILLER_11_12 VGND VGND VPWR VPWR sky130_fd_sc_hd__decap_3
XFILLER_118_740 VGND VGND VPWR VPWR sky130_fd_sc_hd__decap_3
X_6588_ _6588_/A _7329_/C VGND VGND VPWR VPWR _6708_/A sky130_fd_sc_hd__nand2_2
XFILLER_127_12 VGND VGND VPWR VPWR sky130_fd_sc_hd__decap_3
XFILLER_124_209 VGND VGND VPWR VPWR sky130_fd_sc_hd__decap_3
XFILLER_11_45 VGND VGND VPWR VPWR sky130_fd_sc_hd__decap_3
XFILLER_117_250 VGND VGND VPWR VPWR sky130_fd_sc_hd__decap_3
X_8327_ _8325_/X _8416_/C _8327_/S VGND VGND VPWR VPWR _8328_/B sky130_fd_sc_hd__mux2_2
XTAP_TAPCELL_ROW_115_1835 VGND VPWR sky130_fd_sc_hd__tapvpwrvgnd_1
X_5539_ _6490_/A _5930_/C _5538_/X VGND VGND VPWR VPWR _5539_/Y sky130_fd_sc_hd__o21ai_2
XFILLER_117_261 VGND VGND VPWR VPWR sky130_fd_sc_hd__decap_3
XFILLER_105_412 VGND VGND VPWR VPWR sky130_fd_sc_hd__decap_3
XFILLER_127_45 VGND VGND VPWR VPWR sky130_fd_sc_hd__decap_3
XFILLER_11_78 VGND VGND VPWR VPWR sky130_fd_sc_hd__fill_2
XFILLER_105_456 VGND VGND VPWR VPWR sky130_fd_sc_hd__decap_3
X_8258_ _8268_/S _8345_/A _8257_/Y VGND VGND VPWR VPWR _8258_/Y sky130_fd_sc_hd__a21oi_2
XFILLER_127_78 VGND VGND VPWR VPWR sky130_fd_sc_hd__decap_3
XFILLER_78_307 VGND VGND VPWR VPWR sky130_fd_sc_hd__fill_1
X_7209_ _7209_/A _7209_/B VGND VGND VPWR VPWR _7210_/B sky130_fd_sc_hd__nor2_2
Xfanout320 _6425_/S VGND VGND VPWR VPWR _6131_/A sky130_fd_sc_hd__clkdlybuf4s25_1
X_8189_ _8189_/A _8286_/S VGND VGND VPWR VPWR _8190_/B sky130_fd_sc_hd__nor2_2
Xfanout331 _5803_/C VGND VGND VPWR VPWR _7871_/A sky130_fd_sc_hd__buf_4
XFILLER_59_543 VGND VGND VPWR VPWR sky130_fd_sc_hd__decap_3
XTAP_TAPCELL_ROW_6_366 VGND VPWR sky130_fd_sc_hd__tapvpwrvgnd_1
XFILLER_59_554 VGND VGND VPWR VPWR sky130_fd_sc_hd__decap_3
Xfanout375 fanout391/A VGND VGND VPWR VPWR fanout375/X sky130_fd_sc_hd__clkdlybuf4s25_1
XFILLER_47_705 VGND VGND VPWR VPWR sky130_fd_sc_hd__decap_3
XFILLER_59_576 VGND VGND VPWR VPWR sky130_fd_sc_hd__decap_3
XFILLER_101_673 VGND VGND VPWR VPWR sky130_fd_sc_hd__decap_3
XFILLER_86_362 VGND VGND VPWR VPWR sky130_fd_sc_hd__fill_2
XFILLER_47_727 VGND VGND VPWR VPWR sky130_fd_sc_hd__fill_1
XFILLER_74_557 VGND VGND VPWR VPWR sky130_fd_sc_hd__decap_3
XFILLER_46_259 VGND VGND VPWR VPWR sky130_fd_sc_hd__fill_1
XFILLER_74_579 VGND VGND VPWR VPWR sky130_fd_sc_hd__decap_3
XFILLER_36_53 VGND VGND VPWR VPWR sky130_fd_sc_hd__decap_3
XFILLER_55_771 VGND VGND VPWR VPWR sky130_fd_sc_hd__decap_3
XFILLER_15_602 VGND VGND VPWR VPWR sky130_fd_sc_hd__decap_3
XFILLER_15_613 VGND VGND VPWR VPWR sky130_fd_sc_hd__decap_3
XTAP_TAPCELL_ROW_126_1986 VGND VPWR sky130_fd_sc_hd__tapvpwrvgnd_1
XFILLER_42_410 VGND VGND VPWR VPWR sky130_fd_sc_hd__decap_3
XFILLER_15_635 VGND VGND VPWR VPWR sky130_fd_sc_hd__decap_3
XFILLER_36_97 VGND VGND VPWR VPWR sky130_fd_sc_hd__decap_3
XFILLER_14_112 VGND VGND VPWR VPWR sky130_fd_sc_hd__decap_3
XFILLER_70_752 VGND VGND VPWR VPWR sky130_fd_sc_hd__decap_3
XFILLER_42_443 VGND VGND VPWR VPWR sky130_fd_sc_hd__decap_3
XFILLER_70_763 VGND VGND VPWR VPWR sky130_fd_sc_hd__fill_1
XFILLER_70_774 VGND VGND VPWR VPWR sky130_fd_sc_hd__decap_3
XFILLER_30_616 VGND VGND VPWR VPWR sky130_fd_sc_hd__decap_3
XFILLER_14_167 VGND VGND VPWR VPWR sky130_fd_sc_hd__decap_3
XTAP_TAPCELL_ROW_53_994 VGND VPWR sky130_fd_sc_hd__tapvpwrvgnd_1
XFILLER_52_85 VGND VGND VPWR VPWR sky130_fd_sc_hd__decap_3
XFILLER_128_515 VGND VGND VPWR VPWR sky130_fd_sc_hd__decap_3
XFILLER_10_340 VGND VGND VPWR VPWR sky130_fd_sc_hd__decap_3
Xinput17 sample_in[9] VGND VGND VPWR VPWR _6425_/S sky130_fd_sc_hd__clkbuf_2
XTAP_TAPCELL_ROW_77_1318 VGND VPWR sky130_fd_sc_hd__tapvpwrvgnd_1
XFILLER_124_710 VGND VGND VPWR VPWR sky130_fd_sc_hd__decap_3
XFILLER_124_743 VGND VGND VPWR VPWR sky130_fd_sc_hd__decap_3
XFILLER_123_220 VGND VGND VPWR VPWR sky130_fd_sc_hd__decap_3
XFILLER_97_638 VGND VGND VPWR VPWR sky130_fd_sc_hd__fill_2
XFILLER_77_60 VGND VGND VPWR VPWR sky130_fd_sc_hd__fill_2
XFILLER_28_6 VGND VGND VPWR VPWR sky130_fd_sc_hd__decap_3
XFILLER_77_384 VGND VGND VPWR VPWR sky130_fd_sc_hd__decap_3
XFILLER_37_215 VGND VGND VPWR VPWR sky130_fd_sc_hd__decap_3
XFILLER_38_749 VGND VGND VPWR VPWR sky130_fd_sc_hd__decap_3
XFILLER_65_535 VGND VGND VPWR VPWR sky130_fd_sc_hd__fill_1
XFILLER_65_546 VGND VGND VPWR VPWR sky130_fd_sc_hd__decap_3
XTAP_TAPCELL_ROW_88_1469 VGND VPWR sky130_fd_sc_hd__tapvpwrvgnd_1
XFILLER_18_440 VGND VGND VPWR VPWR sky130_fd_sc_hd__decap_3
X_4910_ _4910_/A VGND VGND VPWR VPWR _9195_/D sky130_fd_sc_hd__buf_1
XFILLER_33_410 VGND VGND VPWR VPWR sky130_fd_sc_hd__decap_3
X_5890_ _5890_/A _5890_/B _5890_/C _5890_/D VGND VGND VPWR VPWR _5890_/Y sky130_fd_sc_hd__nor4_4
XFILLER_73_590 VGND VGND VPWR VPWR sky130_fd_sc_hd__fill_2
XFILLER_45_281 VGND VGND VPWR VPWR sky130_fd_sc_hd__decap_3
XFILLER_33_443 VGND VGND VPWR VPWR sky130_fd_sc_hd__decap_3
X_4841_ _4841_/A VGND VGND VPWR VPWR _9165_/D sky130_fd_sc_hd__buf_1
XFILLER_33_454 VGND VGND VPWR VPWR sky130_fd_sc_hd__decap_3
XFILLER_60_262 VGND VGND VPWR VPWR sky130_fd_sc_hd__decap_3
X_7560_ _7560_/A0 _7559_/Y _7560_/S VGND VGND VPWR VPWR _7561_/B sky130_fd_sc_hd__mux2_2
X_4772_ _4772_/A VGND VGND VPWR VPWR _9132_/D sky130_fd_sc_hd__buf_1
XFILLER_20_137 VGND VGND VPWR VPWR sky130_fd_sc_hd__decap_3
X_6511_ _6394_/A _6509_/A _6456_/A _6510_/X VGND VGND VPWR VPWR _6512_/B sky130_fd_sc_hd__a31o_2
XFILLER_119_515 VGND VGND VPWR VPWR sky130_fd_sc_hd__decap_3
XFILLER_20_159 VGND VGND VPWR VPWR sky130_fd_sc_hd__decap_3
X_7491_ _7492_/A _7466_/Y _7487_/Y _7490_/X VGND VGND VPWR VPWR _7491_/X sky130_fd_sc_hd__a31o_2
XFILLER_9_160 VGND VGND VPWR VPWR sky130_fd_sc_hd__decap_3
XFILLER_119_548 VGND VGND VPWR VPWR sky130_fd_sc_hd__decap_3
X_9230_ _9232_/CLK _9230_/D fanout405/A VGND VGND VPWR VPWR _9230_/Q sky130_fd_sc_hd__dfrtp_2
XTAP_TAPCELL_ROW_31_699 VGND VPWR sky130_fd_sc_hd__tapvpwrvgnd_1
X_6442_ _6497_/B _6442_/B VGND VGND VPWR VPWR _6443_/B sky130_fd_sc_hd__xor2_2
X_9161_ _9317_/CLK _9161_/D wire406/X VGND VGND VPWR VPWR _9161_/Q sky130_fd_sc_hd__dfrtp_2
XFILLER_115_710 VGND VGND VPWR VPWR sky130_fd_sc_hd__decap_3
X_6373_ _6529_/A _6367_/Y _6370_/X _6372_/X VGND VGND VPWR VPWR _6374_/C sky130_fd_sc_hd__a211oi_2
XFILLER_127_592 VGND VGND VPWR VPWR sky130_fd_sc_hd__decap_3
X_8112_ _8112_/A _8112_/B _8112_/C VGND VGND VPWR VPWR _8121_/A sky130_fd_sc_hd__nor3_2
X_5324_ _6083_/B _5315_/X _5323_/Y VGND VGND VPWR VPWR _5338_/A sky130_fd_sc_hd__a21bo_2
X_9092_ _9313_/CLK _9092_/D load_slew388/X VGND VGND VPWR VPWR _9092_/Q sky130_fd_sc_hd__dfrtp_2
XFILLER_130_713 VGND VGND VPWR VPWR sky130_fd_sc_hd__decap_3
X_8043_ _8043_/A _8043_/B VGND VGND VPWR VPWR _8044_/A sky130_fd_sc_hd__xnor2_2
X_5255_ _5255_/A _5255_/B VGND VGND VPWR VPWR _5255_/X sky130_fd_sc_hd__or2_2
XFILLER_130_735 VGND VGND VPWR VPWR sky130_fd_sc_hd__decap_3
XFILLER_130_757 VGND VGND VPWR VPWR sky130_fd_sc_hd__decap_3
XTAP_TAPCELL_ROW_110_1765 VGND VPWR sky130_fd_sc_hd__tapvpwrvgnd_1
X_5186_ _5187_/C _5266_/S _9038_/Q VGND VGND VPWR VPWR _5186_/X sky130_fd_sc_hd__and3b_2
XTAP_TAPCELL_ROW_3_325 VGND VPWR sky130_fd_sc_hd__tapvpwrvgnd_1
XFILLER_3_90 VGND VGND VPWR VPWR sky130_fd_sc_hd__decap_3
XFILLER_29_727 VGND VGND VPWR VPWR sky130_fd_sc_hd__fill_1
XFILLER_28_204 VGND VGND VPWR VPWR sky130_fd_sc_hd__decap_3
XFILLER_29_738 VGND VGND VPWR VPWR sky130_fd_sc_hd__decap_3
XFILLER_96_693 VGND VGND VPWR VPWR sky130_fd_sc_hd__decap_3
XFILLER_28_215 VGND VGND VPWR VPWR sky130_fd_sc_hd__decap_3
XFILLER_110_470 VGND VGND VPWR VPWR sky130_fd_sc_hd__decap_3
XFILLER_28_248 VGND VGND VPWR VPWR sky130_fd_sc_hd__decap_3
XFILLER_113_36 VGND VGND VPWR VPWR sky130_fd_sc_hd__decap_3
XFILLER_28_259 VGND VGND VPWR VPWR sky130_fd_sc_hd__decap_3
X_8945_ _8945_/A VGND VGND VPWR VPWR _9314_/D sky130_fd_sc_hd__buf_1
Xwire41 wire41/A VGND VGND VPWR VPWR wire41/X sky130_fd_sc_hd__buf_2
XFILLER_83_398 VGND VGND VPWR VPWR sky130_fd_sc_hd__decap_3
XFILLER_36_270 VGND VGND VPWR VPWR sky130_fd_sc_hd__decap_3
X_8876_ _8876_/A VGND VGND VPWR VPWR _9281_/D sky130_fd_sc_hd__buf_1
XFILLER_24_421 VGND VGND VPWR VPWR sky130_fd_sc_hd__decap_3
XFILLER_52_741 VGND VGND VPWR VPWR sky130_fd_sc_hd__decap_3
X_7827_ _7634_/B _7633_/A _7633_/B VGND VGND VPWR VPWR _7827_/X sky130_fd_sc_hd__a21bo_2
XFILLER_24_454 VGND VGND VPWR VPWR sky130_fd_sc_hd__decap_3
XTAP_TAPCELL_ROW_61_1108 VGND VPWR sky130_fd_sc_hd__tapvpwrvgnd_1
XFILLER_51_251 VGND VGND VPWR VPWR sky130_fd_sc_hd__decap_3
XFILLER_12_638 VGND VGND VPWR VPWR sky130_fd_sc_hd__decap_3
X_7758_ _7763_/A _7945_/A VGND VGND VPWR VPWR _7931_/A sky130_fd_sc_hd__nor2_2
XTAP_TAPCELL_ROW_50_953 VGND VPWR sky130_fd_sc_hd__tapvpwrvgnd_1
X_6709_ _6708_/A _6708_/B _6591_/A VGND VGND VPWR VPWR _6730_/C sky130_fd_sc_hd__a21bo_2
XFILLER_7_119 VGND VGND VPWR VPWR sky130_fd_sc_hd__decap_3
X_7689_ _7689_/A _7545_/B VGND VGND VPWR VPWR _7689_/X sky130_fd_sc_hd__or2b_2
XFILLER_20_660 VGND VGND VPWR VPWR sky130_fd_sc_hd__decap_3
XFILLER_22_88 VGND VGND VPWR VPWR sky130_fd_sc_hd__fill_2
XFILLER_98_15 VGND VGND VPWR VPWR sky130_fd_sc_hd__fill_2
XFILLER_98_26 VGND VGND VPWR VPWR sky130_fd_sc_hd__fill_2
XFILLER_106_721 VGND VGND VPWR VPWR sky130_fd_sc_hd__decap_3
XFILLER_3_314 VGND VGND VPWR VPWR sky130_fd_sc_hd__decap_3
XFILLER_118_581 VGND VGND VPWR VPWR sky130_fd_sc_hd__decap_3
XFILLER_118_592 VGND VGND VPWR VPWR sky130_fd_sc_hd__decap_3
XFILLER_105_231 VGND VGND VPWR VPWR sky130_fd_sc_hd__decap_3
XFILLER_105_253 VGND VGND VPWR VPWR sky130_fd_sc_hd__decap_3
XFILLER_105_275 VGND VGND VPWR VPWR sky130_fd_sc_hd__decap_3
XFILLER_79_638 VGND VGND VPWR VPWR sky130_fd_sc_hd__decap_3
XTAP_TAPCELL_ROW_72_1248 VGND VPWR sky130_fd_sc_hd__tapvpwrvgnd_1
XFILLER_121_735 VGND VGND VPWR VPWR sky130_fd_sc_hd__decap_3
XTAP_TAPCELL_ROW_72_1259 VGND VPWR sky130_fd_sc_hd__tapvpwrvgnd_1
XFILLER_121_768 VGND VGND VPWR VPWR sky130_fd_sc_hd__decap_3
XFILLER_78_159 VGND VGND VPWR VPWR sky130_fd_sc_hd__decap_3
XFILLER_59_340 VGND VGND VPWR VPWR sky130_fd_sc_hd__decap_3
XFILLER_87_660 VGND VGND VPWR VPWR sky130_fd_sc_hd__decap_3
XFILLER_120_289 VGND VGND VPWR VPWR sky130_fd_sc_hd__decap_3
XFILLER_59_384 VGND VGND VPWR VPWR sky130_fd_sc_hd__decap_3
XFILLER_47_524 VGND VGND VPWR VPWR sky130_fd_sc_hd__decap_3
XFILLER_101_481 VGND VGND VPWR VPWR sky130_fd_sc_hd__decap_3
XFILLER_74_321 VGND VGND VPWR VPWR sky130_fd_sc_hd__decap_3
XFILLER_47_63 VGND VGND VPWR VPWR sky130_fd_sc_hd__fill_1
XFILLER_47_557 VGND VGND VPWR VPWR sky130_fd_sc_hd__decap_3
XFILLER_74_354 VGND VGND VPWR VPWR sky130_fd_sc_hd__fill_2
XFILLER_74_365 VGND VGND VPWR VPWR sky130_fd_sc_hd__decap_3
XFILLER_62_505 VGND VGND VPWR VPWR sky130_fd_sc_hd__decap_3
XFILLER_47_579 VGND VGND VPWR VPWR sky130_fd_sc_hd__decap_3
XFILLER_28_760 VGND VGND VPWR VPWR sky130_fd_sc_hd__decap_3
XFILLER_62_527 VGND VGND VPWR VPWR sky130_fd_sc_hd__decap_3
XFILLER_27_281 VGND VGND VPWR VPWR sky130_fd_sc_hd__fill_1
XFILLER_63_40 VGND VGND VPWR VPWR sky130_fd_sc_hd__decap_3
XFILLER_43_752 VGND VGND VPWR VPWR sky130_fd_sc_hd__decap_3
XFILLER_70_560 VGND VGND VPWR VPWR sky130_fd_sc_hd__decap_3
XFILLER_15_476 VGND VGND VPWR VPWR sky130_fd_sc_hd__decap_3
XTAP_TAPCELL_ROW_83_1399 VGND VPWR sky130_fd_sc_hd__tapvpwrvgnd_1
XFILLER_15_498 VGND VGND VPWR VPWR sky130_fd_sc_hd__decap_3
XFILLER_8_24 VGND VGND VPWR VPWR sky130_fd_sc_hd__decap_3
XFILLER_30_446 VGND VGND VPWR VPWR sky130_fd_sc_hd__decap_3
XFILLER_8_35 VGND VGND VPWR VPWR sky130_fd_sc_hd__decap_3
XFILLER_7_620 VGND VGND VPWR VPWR sky130_fd_sc_hd__decap_3
XFILLER_8_79 VGND VGND VPWR VPWR sky130_fd_sc_hd__decap_3
XFILLER_11_693 VGND VGND VPWR VPWR sky130_fd_sc_hd__decap_3
XFILLER_7_653 VGND VGND VPWR VPWR sky130_fd_sc_hd__decap_3
XFILLER_6_141 VGND VGND VPWR VPWR sky130_fd_sc_hd__decap_3
XFILLER_116_529 VGND VGND VPWR VPWR sky130_fd_sc_hd__decap_3
XFILLER_7_686 VGND VGND VPWR VPWR sky130_fd_sc_hd__decap_3
XFILLER_124_573 VGND VGND VPWR VPWR sky130_fd_sc_hd__decap_3
XFILLER_111_212 VGND VGND VPWR VPWR sky130_fd_sc_hd__decap_3
XFILLER_111_234 VGND VGND VPWR VPWR sky130_fd_sc_hd__decap_3
X_5040_ _5040_/A VGND VGND VPWR VPWR _5041_/B sky130_fd_sc_hd__clkbuf_2
XFILLER_26_3 VGND VGND VPWR VPWR sky130_fd_sc_hd__fill_1
XFILLER_78_671 VGND VGND VPWR VPWR sky130_fd_sc_hd__decap_3
XFILLER_38_502 VGND VGND VPWR VPWR sky130_fd_sc_hd__decap_3
XFILLER_111_278 VGND VGND VPWR VPWR sky130_fd_sc_hd__fill_2
XFILLER_93_652 VGND VGND VPWR VPWR sky130_fd_sc_hd__decap_3
XFILLER_65_343 VGND VGND VPWR VPWR sky130_fd_sc_hd__decap_3
XFILLER_53_505 VGND VGND VPWR VPWR sky130_fd_sc_hd__decap_3
XFILLER_26_719 VGND VGND VPWR VPWR sky130_fd_sc_hd__decap_3
X_6991_ _7573_/B _5893_/B _6683_/B VGND VGND VPWR VPWR _6991_/Y sky130_fd_sc_hd__a21oi_2
XFILLER_93_685 VGND VGND VPWR VPWR sky130_fd_sc_hd__decap_3
XFILLER_65_376 VGND VGND VPWR VPWR sky130_fd_sc_hd__decap_3
XFILLER_19_771 VGND VGND VPWR VPWR sky130_fd_sc_hd__decap_3
X_8730_ _9230_/Q _8758_/A VGND VGND VPWR VPWR _8732_/B sky130_fd_sc_hd__nor2_2
X_5942_ _6098_/A _5942_/B VGND VGND VPWR VPWR _5943_/B sky130_fd_sc_hd__xnor2_2
XTAP_TAPCELL_ROW_36_769 VGND VPWR sky130_fd_sc_hd__tapvpwrvgnd_1
X_8661_ _8695_/B VGND VGND VPWR VPWR _8753_/A sky130_fd_sc_hd__clkbuf_2
XFILLER_34_763 VGND VGND VPWR VPWR sky130_fd_sc_hd__decap_3
X_5873_ _9248_/Q _5873_/B VGND VGND VPWR VPWR _5975_/A sky130_fd_sc_hd__nand2_4
XFILLER_80_379 VGND VGND VPWR VPWR sky130_fd_sc_hd__fill_2
XFILLER_33_262 VGND VGND VPWR VPWR sky130_fd_sc_hd__decap_3
X_7612_ _7612_/A1 _7612_/A2 _5743_/Y _8405_/B VGND VGND VPWR VPWR _7787_/C sky130_fd_sc_hd__a211o_2
X_4824_ _9157_/Q hold902/X _4840_/S VGND VGND VPWR VPWR _4824_/X sky130_fd_sc_hd__mux2_2
X_8592_ _8560_/A _8476_/X _8655_/B VGND VGND VPWR VPWR _8592_/X sky130_fd_sc_hd__a21o_2
XFILLER_21_435 VGND VGND VPWR VPWR sky130_fd_sc_hd__decap_3
XTAP_TAPCELL_ROW_16_493 VGND VPWR sky130_fd_sc_hd__tapvpwrvgnd_1
XFILLER_21_446 VGND VGND VPWR VPWR sky130_fd_sc_hd__fill_2
XFILLER_21_468 VGND VGND VPWR VPWR sky130_fd_sc_hd__decap_3
X_7543_ _7877_/A _7543_/B VGND VGND VPWR VPWR _7544_/B sky130_fd_sc_hd__nor2_2
X_4755_ _4755_/A VGND VGND VPWR VPWR _9124_/D sky130_fd_sc_hd__buf_1
XFILLER_119_312 VGND VGND VPWR VPWR sky130_fd_sc_hd__decap_3
XFILLER_119_323 VGND VGND VPWR VPWR sky130_fd_sc_hd__decap_3
X_7474_ _8175_/A _7474_/B VGND VGND VPWR VPWR _7819_/B sky130_fd_sc_hd__nor2_2
X_4686_ _4686_/A VGND VGND VPWR VPWR _9091_/D sky130_fd_sc_hd__buf_1
X_9213_ _9215_/CLK _9213_/D load_slew420/X VGND VGND VPWR VPWR _9213_/Q sky130_fd_sc_hd__dfrtp_2
X_6425_ _6117_/X _7195_/A _6425_/S VGND VGND VPWR VPWR _6425_/X sky130_fd_sc_hd__mux2_2
XFILLER_108_47 VGND VGND VPWR VPWR sky130_fd_sc_hd__decap_3
X_9144_ _9348_/CLK _9144_/D load_slew408/X VGND VGND VPWR VPWR _9144_/Q sky130_fd_sc_hd__dfrtp_2
XFILLER_115_540 VGND VGND VPWR VPWR sky130_fd_sc_hd__decap_3
X_6356_ _6224_/A _6224_/B _6939_/B _9208_/Q VGND VGND VPWR VPWR _6356_/X sky130_fd_sc_hd__a22o_2
XTAP_TAPCELL_ROW_58_1070 VGND VPWR sky130_fd_sc_hd__tapvpwrvgnd_1
XFILLER_68_29 VGND VGND VPWR VPWR sky130_fd_sc_hd__decap_3
X_5307_ _5307_/A _5307_/B VGND VGND VPWR VPWR _5308_/B sky130_fd_sc_hd__xnor2_2
XFILLER_0_328 VGND VGND VPWR VPWR sky130_fd_sc_hd__decap_3
X_9075_ _9135_/CLK _9075_/D load_slew396/X VGND VGND VPWR VPWR _9075_/Q sky130_fd_sc_hd__dfrtp_2
XFILLER_115_595 VGND VGND VPWR VPWR sky130_fd_sc_hd__decap_3
X_6287_ _6287_/A _6287_/B VGND VGND VPWR VPWR _6288_/A sky130_fd_sc_hd__xnor2_4
XFILLER_88_457 VGND VGND VPWR VPWR sky130_fd_sc_hd__fill_1
X_8026_ _7889_/A _8010_/A _8025_/X VGND VGND VPWR VPWR _8026_/Y sky130_fd_sc_hd__o21bai_2
XFILLER_130_554 VGND VGND VPWR VPWR sky130_fd_sc_hd__decap_3
X_5238_ _9199_/Q _5344_/A VGND VGND VPWR VPWR _5238_/Y sky130_fd_sc_hd__nand2_2
XFILLER_124_24 VGND VGND VPWR VPWR sky130_fd_sc_hd__decap_3
XFILLER_130_576 VGND VGND VPWR VPWR sky130_fd_sc_hd__decap_3
XFILLER_124_35 VGND VGND VPWR VPWR sky130_fd_sc_hd__decap_3
XFILLER_130_598 VGND VGND VPWR VPWR sky130_fd_sc_hd__decap_3
XFILLER_124_68 VGND VGND VPWR VPWR sky130_fd_sc_hd__decap_3
X_5169_ _5134_/B _5167_/Y _9199_/Q _5135_/A VGND VGND VPWR VPWR _5169_/X sky130_fd_sc_hd__o211a_2
XFILLER_84_641 VGND VGND VPWR VPWR sky130_fd_sc_hd__decap_3
XFILLER_83_140 VGND VGND VPWR VPWR sky130_fd_sc_hd__decap_3
XFILLER_17_719 VGND VGND VPWR VPWR sky130_fd_sc_hd__decap_3
XFILLER_83_151 VGND VGND VPWR VPWR sky130_fd_sc_hd__decap_3
XFILLER_56_365 VGND VGND VPWR VPWR sky130_fd_sc_hd__decap_3
XFILLER_17_33 VGND VGND VPWR VPWR sky130_fd_sc_hd__fill_2
XFILLER_44_527 VGND VGND VPWR VPWR sky130_fd_sc_hd__decap_3
XFILLER_16_229 VGND VGND VPWR VPWR sky130_fd_sc_hd__decap_3
X_8928_ _8961_/A1 _8928_/A1 _8946_/S VGND VGND VPWR VPWR _8929_/A sky130_fd_sc_hd__mux2_2
XTAP_TAPCELL_ROW_123_1945 VGND VPWR sky130_fd_sc_hd__tapvpwrvgnd_1
XFILLER_17_99 VGND VGND VPWR VPWR sky130_fd_sc_hd__decap_3
XFILLER_25_774 VGND VGND VPWR VPWR sky130_fd_sc_hd__decap_3
X_8859_ _8859_/A VGND VGND VPWR VPWR _9273_/D sky130_fd_sc_hd__buf_1
XFILLER_24_262 VGND VGND VPWR VPWR sky130_fd_sc_hd__decap_3
XFILLER_40_722 VGND VGND VPWR VPWR sky130_fd_sc_hd__decap_3
XFILLER_33_76 VGND VGND VPWR VPWR sky130_fd_sc_hd__decap_3
XFILLER_130_3 VGND VGND VPWR VPWR sky130_fd_sc_hd__decap_3
XFILLER_20_490 VGND VGND VPWR VPWR sky130_fd_sc_hd__decap_3
XFILLER_125_337 VGND VGND VPWR VPWR sky130_fd_sc_hd__decap_3
XFILLER_3_111 VGND VGND VPWR VPWR sky130_fd_sc_hd__fill_1
XFILLER_3_122 VGND VGND VPWR VPWR sky130_fd_sc_hd__decap_3
XFILLER_4_667 VGND VGND VPWR VPWR sky130_fd_sc_hd__decap_3
XFILLER_106_551 VGND VGND VPWR VPWR sky130_fd_sc_hd__decap_3
XFILLER_106_584 VGND VGND VPWR VPWR sky130_fd_sc_hd__decap_3
XFILLER_106_595 VGND VGND VPWR VPWR sky130_fd_sc_hd__decap_3
XFILLER_79_446 VGND VGND VPWR VPWR sky130_fd_sc_hd__fill_2
XFILLER_121_554 VGND VGND VPWR VPWR sky130_fd_sc_hd__decap_3
XFILLER_58_73 VGND VGND VPWR VPWR sky130_fd_sc_hd__fill_2
XFILLER_59_181 VGND VGND VPWR VPWR sky130_fd_sc_hd__decap_3
XFILLER_12_9 VGND VGND VPWR VPWR sky130_fd_sc_hd__decap_3
XFILLER_47_354 VGND VGND VPWR VPWR sky130_fd_sc_hd__decap_3
XFILLER_74_162 VGND VGND VPWR VPWR sky130_fd_sc_hd__decap_3
XTAP_TAPCELL_ROW_85_1428 VGND VPWR sky130_fd_sc_hd__tapvpwrvgnd_1
XFILLER_47_387 VGND VGND VPWR VPWR sky130_fd_sc_hd__decap_3
XFILLER_90_633 VGND VGND VPWR VPWR sky130_fd_sc_hd__decap_3
XFILLER_62_324 VGND VGND VPWR VPWR sky130_fd_sc_hd__decap_3
XFILLER_62_346 VGND VGND VPWR VPWR sky130_fd_sc_hd__decap_3
XFILLER_16_752 VGND VGND VPWR VPWR sky130_fd_sc_hd__decap_3
XFILLER_90_677 VGND VGND VPWR VPWR sky130_fd_sc_hd__fill_2
XFILLER_62_368 VGND VGND VPWR VPWR sky130_fd_sc_hd__decap_3
XFILLER_16_763 VGND VGND VPWR VPWR sky130_fd_sc_hd__decap_3
XFILLER_50_519 VGND VGND VPWR VPWR sky130_fd_sc_hd__fill_1
XTAP_TAPCELL_ROW_33_728 VGND VPWR sky130_fd_sc_hd__tapvpwrvgnd_1
XFILLER_95_6 VGND VGND VPWR VPWR sky130_fd_sc_hd__fill_1
XFILLER_31_744 VGND VGND VPWR VPWR sky130_fd_sc_hd__fill_1
XFILLER_70_390 VGND VGND VPWR VPWR sky130_fd_sc_hd__decap_3
XFILLER_31_766 VGND VGND VPWR VPWR sky130_fd_sc_hd__decap_3
XTAP_TAPCELL_ROW_13_452 VGND VPWR sky130_fd_sc_hd__tapvpwrvgnd_1
XFILLER_30_265 VGND VGND VPWR VPWR sky130_fd_sc_hd__decap_3
XTAP_TAPCELL_ROW_13_463 VGND VPWR sky130_fd_sc_hd__tapvpwrvgnd_1
XFILLER_129_632 VGND VGND VPWR VPWR sky130_fd_sc_hd__decap_3
XFILLER_30_298 VGND VGND VPWR VPWR sky130_fd_sc_hd__decap_3
X_4540_ _9023_/Q hold932/X _4544_/S VGND VGND VPWR VPWR _4540_/X sky130_fd_sc_hd__mux2_2
XFILLER_129_665 VGND VGND VPWR VPWR sky130_fd_sc_hd__decap_3
Xclkbuf_leaf_10_clk clkbuf_leaf_9_clk/A VGND VGND VPWR VPWR _9339_/CLK sky130_fd_sc_hd__clkbuf_8
XFILLER_129_676 VGND VGND VPWR VPWR sky130_fd_sc_hd__decap_3
XFILLER_128_153 VGND VGND VPWR VPWR sky130_fd_sc_hd__decap_3
Xmax_cap103 _5016_/A VGND VGND VPWR VPWR _6160_/A1 sky130_fd_sc_hd__buf_2
XFILLER_116_315 VGND VGND VPWR VPWR sky130_fd_sc_hd__decap_3
Xmax_cap114 _7908_/X VGND VGND VPWR VPWR _8697_/C sky130_fd_sc_hd__buf_2
XFILLER_128_186 VGND VGND VPWR VPWR sky130_fd_sc_hd__decap_3
Xmax_cap125 _5476_/X VGND VGND VPWR VPWR _7430_/A sky130_fd_sc_hd__buf_6
XFILLER_128_197 VGND VGND VPWR VPWR sky130_fd_sc_hd__decap_3
XTAP_TAPCELL_ROW_96_1579 VGND VPWR sky130_fd_sc_hd__tapvpwrvgnd_1
Xmax_cap136 _5016_/B VGND VGND VPWR VPWR _5343_/A sky130_fd_sc_hd__clkbuf_2
XFILLER_116_348 VGND VGND VPWR VPWR sky130_fd_sc_hd__fill_1
X_6210_ _6210_/A _8405_/A VGND VGND VPWR VPWR _6212_/A sky130_fd_sc_hd__nand2_2
X_7190_ _7244_/B _8013_/A _7189_/X VGND VGND VPWR VPWR _7191_/B sky130_fd_sc_hd__a21oi_2
Xmax_cap169 _5689_/A VGND VGND VPWR VPWR _5483_/A1 sky130_fd_sc_hd__clkbuf_2
X_6141_ _6141_/A _6141_/B VGND VGND VPWR VPWR _6141_/Y sky130_fd_sc_hd__xnor2_2
XFILLER_98_733 VGND VGND VPWR VPWR sky130_fd_sc_hd__decap_3
Xload_slew342 _6414_/A VGND VGND VPWR VPWR _5803_/A sky130_fd_sc_hd__buf_4
XFILLER_97_254 VGND VGND VPWR VPWR sky130_fd_sc_hd__fill_2
XFILLER_112_554 VGND VGND VPWR VPWR sky130_fd_sc_hd__decap_3
X_6072_ _5968_/X _6071_/X _6270_/S VGND VGND VPWR VPWR _6073_/A sky130_fd_sc_hd__mux2_2
XFILLER_85_405 VGND VGND VPWR VPWR sky130_fd_sc_hd__fill_2
XTAP_TAPCELL_ROW_127_2001 VGND VPWR sky130_fd_sc_hd__tapvpwrvgnd_1
Xload_slew364 _5667_/S VGND VGND VPWR VPWR _6083_/B sky130_fd_sc_hd__clkbuf_4
Xhold1106 _4817_/X VGND VGND VPWR VPWR _4818_/A sky130_fd_sc_hd__dlygate4sd3_1
Xhold1117 _9029_/Q VGND VGND VPWR VPWR _4554_/A0 sky130_fd_sc_hd__dlygate4sd3_1
XFILLER_97_287 VGND VGND VPWR VPWR sky130_fd_sc_hd__fill_1
X_5023_ _6304_/A _5018_/Y _7317_/A VGND VGND VPWR VPWR _5023_/Y sky130_fd_sc_hd__o21ai_2
Xload_slew386 fanout385/X VGND VGND VPWR VPWR load_slew386/X sky130_fd_sc_hd__clkbuf_4
Xhold1128 _9347_/Q VGND VGND VPWR VPWR _4558_/A1 sky130_fd_sc_hd__dlygate4sd3_1
XFILLER_85_438 VGND VGND VPWR VPWR sky130_fd_sc_hd__decap_3
XFILLER_112_598 VGND VGND VPWR VPWR sky130_fd_sc_hd__decap_3
Xload_slew397 fanout395/X VGND VGND VPWR VPWR load_slew397/X sky130_fd_sc_hd__clkbuf_4
XFILLER_85_449 VGND VGND VPWR VPWR sky130_fd_sc_hd__decap_3
Xhold1139 _9075_/Q VGND VGND VPWR VPWR _4685_/A1 sky130_fd_sc_hd__dlygate4sd3_1
XFILLER_66_630 VGND VGND VPWR VPWR sky130_fd_sc_hd__fill_1
XFILLER_38_343 VGND VGND VPWR VPWR sky130_fd_sc_hd__decap_3
XFILLER_38_365 VGND VGND VPWR VPWR sky130_fd_sc_hd__decap_3
XFILLER_53_302 VGND VGND VPWR VPWR sky130_fd_sc_hd__fill_2
XFILLER_93_482 VGND VGND VPWR VPWR sky130_fd_sc_hd__decap_3
X_6974_ _7073_/A _7073_/B VGND VGND VPWR VPWR _6975_/B sky130_fd_sc_hd__xnor2_2
XFILLER_53_346 VGND VGND VPWR VPWR sky130_fd_sc_hd__decap_3
XFILLER_41_508 VGND VGND VPWR VPWR sky130_fd_sc_hd__decap_3
X_5925_ _5925_/A _5926_/B VGND VGND VPWR VPWR _6868_/A sky130_fd_sc_hd__and2_2
X_8713_ _8710_/X wire110/X _8712_/X VGND VGND VPWR VPWR _9230_/D sky130_fd_sc_hd__a21oi_4
XFILLER_110_15 VGND VGND VPWR VPWR sky130_fd_sc_hd__decap_3
XFILLER_22_722 VGND VGND VPWR VPWR sky130_fd_sc_hd__decap_3
X_8644_ _8644_/A _8644_/B VGND VGND VPWR VPWR _8649_/C sky130_fd_sc_hd__nor2_2
XTAP_TAPCELL_ROW_105_1697 VGND VPWR sky130_fd_sc_hd__tapvpwrvgnd_1
X_5856_ _5856_/A VGND VGND VPWR VPWR _6161_/B sky130_fd_sc_hd__buf_1
XFILLER_21_221 VGND VGND VPWR VPWR sky130_fd_sc_hd__decap_3
XFILLER_22_755 VGND VGND VPWR VPWR sky130_fd_sc_hd__fill_1
XFILLER_22_766 VGND VGND VPWR VPWR sky130_fd_sc_hd__decap_3
XPHY_EDGE_ROW_3_Right_3 VGND VGND VPWR VPWR sky130_fd_sc_hd__decap_3
X_4807_ _9149_/Q _4807_/A1 _4819_/S VGND VGND VPWR VPWR _4807_/X sky130_fd_sc_hd__mux2_2
X_8575_ _8636_/A _8575_/B VGND VGND VPWR VPWR _8576_/B sky130_fd_sc_hd__nand2_2
X_5787_ _6436_/A _5790_/A VGND VGND VPWR VPWR _5787_/Y sky130_fd_sc_hd__nor2_2
Xrebuffer503 _8706_/A VGND VGND VPWR VPWR _8765_/C sky130_fd_sc_hd__buf_6
Xrebuffer514 _6293_/B VGND VGND VPWR VPWR _6185_/B1 sky130_fd_sc_hd__buf_2
X_7526_ _6416_/B _7525_/B _7525_/X _6077_/A _5538_/X VGND VGND VPWR VPWR _7526_/X
+ sky130_fd_sc_hd__o221a_2
Xrebuffer525 _5820_/C VGND VGND VPWR VPWR _5973_/B sky130_fd_sc_hd__buf_2
XFILLER_21_298 VGND VGND VPWR VPWR sky130_fd_sc_hd__decap_3
XFILLER_119_131 VGND VGND VPWR VPWR sky130_fd_sc_hd__decap_3
X_4738_ _9116_/Q hold882/X _4756_/S VGND VGND VPWR VPWR _4738_/X sky130_fd_sc_hd__mux2_2
Xrebuffer536 _5604_/B VGND VGND VPWR VPWR _5705_/A sky130_fd_sc_hd__buf_2
Xrebuffer547 _5105_/B VGND VGND VPWR VPWR _5356_/A sky130_fd_sc_hd__buf_2
XFILLER_119_24 VGND VGND VPWR VPWR sky130_fd_sc_hd__decap_3
XFILLER_119_153 VGND VGND VPWR VPWR sky130_fd_sc_hd__decap_3
Xrebuffer558 fanout249/X VGND VGND VPWR VPWR _4924_/B sky130_fd_sc_hd__buf_2
Xrebuffer569 _8058_/Y VGND VGND VPWR VPWR _8157_/A2 sky130_fd_sc_hd__buf_2
XFILLER_119_57 VGND VGND VPWR VPWR sky130_fd_sc_hd__decap_3
XFILLER_119_175 VGND VGND VPWR VPWR sky130_fd_sc_hd__decap_3
X_7457_ _7454_/X _7455_/Y _7443_/Y _7444_/X VGND VGND VPWR VPWR _7458_/C sky130_fd_sc_hd__o211ai_2
XFILLER_107_337 VGND VGND VPWR VPWR sky130_fd_sc_hd__decap_3
X_4669_ _4669_/A VGND VGND VPWR VPWR _9083_/D sky130_fd_sc_hd__buf_1
X_6408_ _6404_/X _6405_/X _6407_/X _6084_/A VGND VGND VPWR VPWR _6412_/A sky130_fd_sc_hd__o2bb2ai_4
Xhold940 _9151_/Q VGND VGND VPWR VPWR hold940/X sky130_fd_sc_hd__dlygate4sd3_1
X_7388_ _7388_/A _7388_/B VGND VGND VPWR VPWR _7388_/X sky130_fd_sc_hd__or2_2
XFILLER_89_700 VGND VGND VPWR VPWR sky130_fd_sc_hd__decap_3
XFILLER_122_307 VGND VGND VPWR VPWR sky130_fd_sc_hd__fill_1
Xhold951 _4853_/X VGND VGND VPWR VPWR _4854_/A sky130_fd_sc_hd__dlygate4sd3_1
Xhold962 _9284_/Q VGND VGND VPWR VPWR hold962/X sky130_fd_sc_hd__dlygate4sd3_1
XFILLER_1_615 VGND VGND VPWR VPWR sky130_fd_sc_hd__fill_1
Xhold973 _4594_/X VGND VGND VPWR VPWR _4595_/A sky130_fd_sc_hd__dlygate4sd3_1
X_9127_ _9159_/CLK _9127_/D fanout391/X VGND VGND VPWR VPWR _9127_/Q sky130_fd_sc_hd__dfrtp_2
XFILLER_1_626 VGND VGND VPWR VPWR sky130_fd_sc_hd__decap_3
X_6339_ _9063_/Q _6753_/B _6607_/B VGND VGND VPWR VPWR _6339_/X sky130_fd_sc_hd__and3_2
Xhold984 _4585_/X VGND VGND VPWR VPWR _4586_/A sky130_fd_sc_hd__dlygate4sd3_1
Xhold995 _9331_/Q VGND VGND VPWR VPWR hold995/X sky130_fd_sc_hd__dlygate4sd3_1
XFILLER_88_221 VGND VGND VPWR VPWR sky130_fd_sc_hd__decap_3
XFILLER_0_125 VGND VGND VPWR VPWR sky130_fd_sc_hd__decap_3
XFILLER_1_659 VGND VGND VPWR VPWR sky130_fd_sc_hd__decap_3
XFILLER_0_147 VGND VGND VPWR VPWR sky130_fd_sc_hd__decap_3
XFILLER_95_16 VGND VGND VPWR VPWR sky130_fd_sc_hd__fill_2
XFILLER_130_340 VGND VGND VPWR VPWR sky130_fd_sc_hd__decap_3
X_9058_ _9341_/CLK _9058_/D fanout379/X VGND VGND VPWR VPWR _9058_/Q sky130_fd_sc_hd__dfrtp_2
XFILLER_103_576 VGND VGND VPWR VPWR sky130_fd_sc_hd__decap_3
XFILLER_0_169 VGND VGND VPWR VPWR sky130_fd_sc_hd__decap_3
XFILLER_88_287 VGND VGND VPWR VPWR sky130_fd_sc_hd__decap_3
XFILLER_48_118 VGND VGND VPWR VPWR sky130_fd_sc_hd__fill_1
X_8009_ _8009_/A _8009_/B VGND VGND VPWR VPWR _8010_/A sky130_fd_sc_hd__xnor2_2
XFILLER_57_630 VGND VGND VPWR VPWR sky130_fd_sc_hd__fill_1
XFILLER_28_32 VGND VGND VPWR VPWR sky130_fd_sc_hd__fill_2
XFILLER_29_332 VGND VGND VPWR VPWR sky130_fd_sc_hd__decap_3
XFILLER_29_343 VGND VGND VPWR VPWR sky130_fd_sc_hd__decap_3
XFILLER_91_408 VGND VGND VPWR VPWR sky130_fd_sc_hd__fill_1
XFILLER_28_65 VGND VGND VPWR VPWR sky130_fd_sc_hd__decap_3
XFILLER_29_365 VGND VGND VPWR VPWR sky130_fd_sc_hd__decap_3
XFILLER_17_505 VGND VGND VPWR VPWR sky130_fd_sc_hd__decap_3
XFILLER_44_302 VGND VGND VPWR VPWR sky130_fd_sc_hd__fill_2
XFILLER_56_162 VGND VGND VPWR VPWR sky130_fd_sc_hd__fill_1
XFILLER_72_622 VGND VGND VPWR VPWR sky130_fd_sc_hd__fill_2
XFILLER_29_398 VGND VGND VPWR VPWR sky130_fd_sc_hd__decap_3
XFILLER_44_357 VGND VGND VPWR VPWR sky130_fd_sc_hd__decap_3
XFILLER_44_368 VGND VGND VPWR VPWR sky130_fd_sc_hd__fill_2
XFILLER_72_688 VGND VGND VPWR VPWR sky130_fd_sc_hd__decap_3
XFILLER_32_519 VGND VGND VPWR VPWR sky130_fd_sc_hd__decap_3
XFILLER_13_700 VGND VGND VPWR VPWR sky130_fd_sc_hd__decap_3
XFILLER_25_571 VGND VGND VPWR VPWR sky130_fd_sc_hd__fill_2
XFILLER_13_744 VGND VGND VPWR VPWR sky130_fd_sc_hd__decap_3
XFILLER_12_232 VGND VGND VPWR VPWR sky130_fd_sc_hd__decap_3
XTAP_TAPCELL_ROW_80_1358 VGND VPWR sky130_fd_sc_hd__tapvpwrvgnd_1
XFILLER_9_715 VGND VGND VPWR VPWR sky130_fd_sc_hd__decap_3
XFILLER_8_203 VGND VGND VPWR VPWR sky130_fd_sc_hd__fill_2
XFILLER_40_563 VGND VGND VPWR VPWR sky130_fd_sc_hd__decap_3
XFILLER_12_265 VGND VGND VPWR VPWR sky130_fd_sc_hd__decap_3
XFILLER_9_759 VGND VGND VPWR VPWR sky130_fd_sc_hd__decap_3
XFILLER_40_585 VGND VGND VPWR VPWR sky130_fd_sc_hd__decap_3
XTAP_TAPCELL_ROW_10_411 VGND VPWR sky130_fd_sc_hd__tapvpwrvgnd_1
XFILLER_12_298 VGND VGND VPWR VPWR sky130_fd_sc_hd__decap_3
XTAP_TAPCELL_ROW_10_422 VGND VPWR sky130_fd_sc_hd__tapvpwrvgnd_1
XFILLER_60_85 VGND VGND VPWR VPWR sky130_fd_sc_hd__decap_3
XFILLER_126_624 VGND VGND VPWR VPWR sky130_fd_sc_hd__decap_3
XFILLER_126_657 VGND VGND VPWR VPWR sky130_fd_sc_hd__decap_3
XFILLER_125_134 VGND VGND VPWR VPWR sky130_fd_sc_hd__decap_3
XFILLER_99_508 VGND VGND VPWR VPWR sky130_fd_sc_hd__fill_2
XFILLER_5_36 VGND VGND VPWR VPWR sky130_fd_sc_hd__decap_3
XFILLER_125_167 VGND VGND VPWR VPWR sky130_fd_sc_hd__fill_1
XFILLER_125_178 VGND VGND VPWR VPWR sky130_fd_sc_hd__decap_3
XFILLER_121_340 VGND VGND VPWR VPWR sky130_fd_sc_hd__decap_3
XFILLER_95_725 VGND VGND VPWR VPWR sky130_fd_sc_hd__decap_3
XFILLER_79_287 VGND VGND VPWR VPWR sky130_fd_sc_hd__decap_3
XFILLER_94_224 VGND VGND VPWR VPWR sky130_fd_sc_hd__decap_3
XFILLER_67_449 VGND VGND VPWR VPWR sky130_fd_sc_hd__decap_3
XFILLER_10_6 VGND VGND VPWR VPWR sky130_fd_sc_hd__decap_3
XFILLER_85_60 VGND VGND VPWR VPWR sky130_fd_sc_hd__decap_3
XFILLER_63_600 VGND VGND VPWR VPWR sky130_fd_sc_hd__fill_2
XFILLER_85_93 VGND VGND VPWR VPWR sky130_fd_sc_hd__fill_1
XFILLER_35_302 VGND VGND VPWR VPWR sky130_fd_sc_hd__decap_3
XTAP_TAPCELL_ROW_18_522 VGND VPWR sky130_fd_sc_hd__tapvpwrvgnd_1
XFILLER_35_346 VGND VGND VPWR VPWR sky130_fd_sc_hd__decap_3
XFILLER_23_508 VGND VGND VPWR VPWR sky130_fd_sc_hd__fill_2
XTAP_TAPCELL_ROW_46_897 VGND VPWR sky130_fd_sc_hd__tapvpwrvgnd_1
XFILLER_16_582 VGND VGND VPWR VPWR sky130_fd_sc_hd__decap_3
X_5710_ _5710_/A VGND VGND VPWR VPWR _7071_/D sky130_fd_sc_hd__buf_4
X_6690_ _6690_/A _6690_/B VGND VGND VPWR VPWR _6691_/B sky130_fd_sc_hd__xnor2_2
XFILLER_93_3 VGND VGND VPWR VPWR sky130_fd_sc_hd__decap_3
XFILLER_43_390 VGND VGND VPWR VPWR sky130_fd_sc_hd__fill_2
X_5641_ _5642_/A _5642_/B VGND VGND VPWR VPWR _5773_/C sky130_fd_sc_hd__and2_2
XTAP_TAPCELL_ROW_98_1608 VGND VPWR sky130_fd_sc_hd__tapvpwrvgnd_1
XFILLER_31_574 VGND VGND VPWR VPWR sky130_fd_sc_hd__decap_3
X_8360_ _9220_/Q _8358_/X _8359_/Y _8367_/B VGND VGND VPWR VPWR _8360_/X sky130_fd_sc_hd__o22a_2
X_5572_ _5631_/B VGND VGND VPWR VPWR _8155_/A sky130_fd_sc_hd__clkbuf_2
XFILLER_117_613 VGND VGND VPWR VPWR sky130_fd_sc_hd__decap_3
X_7311_ _7311_/A _7764_/A VGND VGND VPWR VPWR _7311_/Y sky130_fd_sc_hd__nand2_2
X_4523_ _5029_/S VGND VGND VPWR VPWR _8688_/S sky130_fd_sc_hd__inv_2
X_8291_ _8288_/Y _8290_/Y _8291_/S VGND VGND VPWR VPWR _8292_/A sky130_fd_sc_hd__mux2_2
XFILLER_129_495 VGND VGND VPWR VPWR sky130_fd_sc_hd__decap_3
XFILLER_116_112 VGND VGND VPWR VPWR sky130_fd_sc_hd__decap_3
X_7242_ _7193_/A _7193_/B _7241_/X VGND VGND VPWR VPWR _7253_/A sky130_fd_sc_hd__o21a_2
X_7173_ _7244_/B _7173_/B VGND VGND VPWR VPWR _7682_/A sky130_fd_sc_hd__nand2_2
XFILLER_98_530 VGND VGND VPWR VPWR sky130_fd_sc_hd__fill_2
X_6124_ _6124_/A _6124_/B VGND VGND VPWR VPWR _6125_/B sky130_fd_sc_hd__xnor2_2
XFILLER_98_574 VGND VGND VPWR VPWR sky130_fd_sc_hd__decap_3
XFILLER_105_15 VGND VGND VPWR VPWR sky130_fd_sc_hd__fill_1
XFILLER_86_736 VGND VGND VPWR VPWR sky130_fd_sc_hd__decap_3
XFILLER_58_427 VGND VGND VPWR VPWR sky130_fd_sc_hd__decap_3
X_6055_ _6057_/B wire62/X VGND VGND VPWR VPWR _6055_/X sky130_fd_sc_hd__or2_2
X_5006_ _9115_/Q _5006_/B _6756_/C VGND VGND VPWR VPWR _5006_/X sky130_fd_sc_hd__and3_2
XFILLER_73_408 VGND VGND VPWR VPWR sky130_fd_sc_hd__decap_3
XFILLER_100_579 VGND VGND VPWR VPWR sky130_fd_sc_hd__decap_3
XFILLER_85_279 VGND VGND VPWR VPWR sky130_fd_sc_hd__fill_1
XFILLER_73_419 VGND VGND VPWR VPWR sky130_fd_sc_hd__decap_3
XFILLER_66_460 VGND VGND VPWR VPWR sky130_fd_sc_hd__decap_3
XTAP_TAPCELL_ROW_107_1726 VGND VPWR sky130_fd_sc_hd__tapvpwrvgnd_1
XFILLER_54_633 VGND VGND VPWR VPWR sky130_fd_sc_hd__decap_3
XFILLER_26_324 VGND VGND VPWR VPWR sky130_fd_sc_hd__decap_3
XFILLER_53_110 VGND VGND VPWR VPWR sky130_fd_sc_hd__fill_2
XFILLER_38_184 VGND VGND VPWR VPWR sky130_fd_sc_hd__decap_3
XFILLER_26_335 VGND VGND VPWR VPWR sky130_fd_sc_hd__decap_3
XFILLER_81_441 VGND VGND VPWR VPWR sky130_fd_sc_hd__fill_1
XFILLER_81_452 VGND VGND VPWR VPWR sky130_fd_sc_hd__decap_3
XFILLER_121_36 VGND VGND VPWR VPWR sky130_fd_sc_hd__decap_3
XFILLER_14_519 VGND VGND VPWR VPWR sky130_fd_sc_hd__decap_3
X_6957_ _8309_/A _6957_/B VGND VGND VPWR VPWR _6961_/A sky130_fd_sc_hd__nand2_2
XFILLER_81_474 VGND VGND VPWR VPWR sky130_fd_sc_hd__decap_3
XFILLER_53_165 VGND VGND VPWR VPWR sky130_fd_sc_hd__decap_3
XFILLER_121_69 VGND VGND VPWR VPWR sky130_fd_sc_hd__decap_3
XTAP_TAPCELL_ROW_120_1904 VGND VPWR sky130_fd_sc_hd__tapvpwrvgnd_1
XFILLER_54_699 VGND VGND VPWR VPWR sky130_fd_sc_hd__fill_1
XFILLER_41_316 VGND VGND VPWR VPWR sky130_fd_sc_hd__decap_3
XFILLER_41_349 VGND VGND VPWR VPWR sky130_fd_sc_hd__decap_3
X_5908_ _5908_/A _5908_/B VGND VGND VPWR VPWR _5913_/A sky130_fd_sc_hd__nand2_2
XFILLER_14_12 VGND VGND VPWR VPWR sky130_fd_sc_hd__decap_3
X_6888_ _6884_/Y _6823_/B _6887_/Y _6821_/S VGND VGND VPWR VPWR _7212_/B sky130_fd_sc_hd__a2bb2o_2
X_5839_ _6311_/A _7805_/A VGND VGND VPWR VPWR _5840_/B sky130_fd_sc_hd__nor2_2
X_8627_ _8627_/A _8644_/A VGND VGND VPWR VPWR _8627_/Y sky130_fd_sc_hd__nor2_2
XFILLER_22_574 VGND VGND VPWR VPWR sky130_fd_sc_hd__decap_3
XFILLER_10_725 VGND VGND VPWR VPWR sky130_fd_sc_hd__decap_3
XFILLER_6_707 VGND VGND VPWR VPWR sky130_fd_sc_hd__decap_3
XFILLER_108_602 VGND VGND VPWR VPWR sky130_fd_sc_hd__fill_1
X_8558_ _9225_/Q _8697_/C _8557_/Y _9224_/Q VGND VGND VPWR VPWR _8558_/X sky130_fd_sc_hd__a211o_2
XFILLER_10_769 VGND VGND VPWR VPWR sky130_fd_sc_hd__decap_3
X_7509_ _7508_/A _7510_/B _7508_/X _7510_/A VGND VGND VPWR VPWR _7509_/X sky130_fd_sc_hd__o22a_2
XFILLER_5_228 VGND VGND VPWR VPWR sky130_fd_sc_hd__decap_3
X_8489_ _9224_/Q VGND VGND VPWR VPWR _8562_/A sky130_fd_sc_hd__inv_2
XTAP_TAPCELL_ROW_118_1877 VGND VPWR sky130_fd_sc_hd__tapvpwrvgnd_1
XFILLER_122_115 VGND VGND VPWR VPWR sky130_fd_sc_hd__decap_3
XFILLER_1_423 VGND VGND VPWR VPWR sky130_fd_sc_hd__decap_3
Xhold770 input6/X VGND VGND VPWR VPWR hold770/X sky130_fd_sc_hd__dlygate4sd3_1
Xhold781 _8804_/X VGND VGND VPWR VPWR _8805_/A sky130_fd_sc_hd__dlygate4sd3_1
Xhold792 _4898_/X VGND VGND VPWR VPWR _9189_/D sky130_fd_sc_hd__dlygate4sd3_1
XFILLER_77_703 VGND VGND VPWR VPWR sky130_fd_sc_hd__decap_3
XFILLER_122_159 VGND VGND VPWR VPWR sky130_fd_sc_hd__decap_3
XFILLER_39_53 VGND VGND VPWR VPWR sky130_fd_sc_hd__decap_3
XFILLER_76_213 VGND VGND VPWR VPWR sky130_fd_sc_hd__decap_3
XFILLER_49_427 VGND VGND VPWR VPWR sky130_fd_sc_hd__decap_3
XFILLER_49_449 VGND VGND VPWR VPWR sky130_fd_sc_hd__fill_2
XFILLER_39_75 VGND VGND VPWR VPWR sky130_fd_sc_hd__decap_3
XFILLER_130_181 VGND VGND VPWR VPWR sky130_fd_sc_hd__decap_3
XTAP_TAPCELL_ROW_69_1209 VGND VPWR sky130_fd_sc_hd__tapvpwrvgnd_1
XFILLER_64_408 VGND VGND VPWR VPWR sky130_fd_sc_hd__decap_3
XFILLER_29_151 VGND VGND VPWR VPWR sky130_fd_sc_hd__decap_3
XFILLER_17_313 VGND VGND VPWR VPWR sky130_fd_sc_hd__decap_3
XFILLER_57_482 VGND VGND VPWR VPWR sky130_fd_sc_hd__decap_3
XFILLER_44_121 VGND VGND VPWR VPWR sky130_fd_sc_hd__decap_3
XFILLER_17_335 VGND VGND VPWR VPWR sky130_fd_sc_hd__fill_1
XFILLER_72_452 VGND VGND VPWR VPWR sky130_fd_sc_hd__decap_3
XFILLER_44_165 VGND VGND VPWR VPWR sky130_fd_sc_hd__decap_3
XFILLER_32_316 VGND VGND VPWR VPWR sky130_fd_sc_hd__decap_3
XTAP_TAPCELL_ROW_43_856 VGND VPWR sky130_fd_sc_hd__tapvpwrvgnd_1
XTAP_TAPCELL_ROW_43_867 VGND VPWR sky130_fd_sc_hd__tapvpwrvgnd_1
XFILLER_13_541 VGND VGND VPWR VPWR sky130_fd_sc_hd__decap_3
XFILLER_9_523 VGND VGND VPWR VPWR sky130_fd_sc_hd__decap_3
XFILLER_40_371 VGND VGND VPWR VPWR sky130_fd_sc_hd__decap_3
XTAP_TAPCELL_ROW_23_591 VGND VPWR sky130_fd_sc_hd__tapvpwrvgnd_1
XFILLER_126_443 VGND VGND VPWR VPWR sky130_fd_sc_hd__decap_3
XFILLER_58_6 VGND VGND VPWR VPWR sky130_fd_sc_hd__decap_3
XFILLER_126_465 VGND VGND VPWR VPWR sky130_fd_sc_hd__decap_3
XFILLER_114_605 VGND VGND VPWR VPWR sky130_fd_sc_hd__decap_3
XTAP_TAPCELL_ROW_93_1538 VGND VPWR sky130_fd_sc_hd__tapvpwrvgnd_1
XFILLER_5_762 VGND VGND VPWR VPWR sky130_fd_sc_hd__decap_3
XFILLER_99_349 VGND VGND VPWR VPWR sky130_fd_sc_hd__decap_3
XFILLER_113_159 VGND VGND VPWR VPWR sky130_fd_sc_hd__decap_3
XFILLER_68_725 VGND VGND VPWR VPWR sky130_fd_sc_hd__decap_3
XFILLER_122_693 VGND VGND VPWR VPWR sky130_fd_sc_hd__decap_3
XFILLER_95_544 VGND VGND VPWR VPWR sky130_fd_sc_hd__decap_3
XFILLER_121_181 VGND VGND VPWR VPWR sky130_fd_sc_hd__decap_3
XFILLER_55_408 VGND VGND VPWR VPWR sky130_fd_sc_hd__decap_3
XFILLER_95_599 VGND VGND VPWR VPWR sky130_fd_sc_hd__decap_3
XFILLER_48_471 VGND VGND VPWR VPWR sky130_fd_sc_hd__decap_3
X_7860_ _7741_/A _7740_/B _7740_/A VGND VGND VPWR VPWR _7860_/X sky130_fd_sc_hd__o21a_2
XFILLER_63_430 VGND VGND VPWR VPWR sky130_fd_sc_hd__decap_3
XFILLER_35_143 VGND VGND VPWR VPWR sky130_fd_sc_hd__fill_1
X_6811_ _5949_/A _5228_/Y _5229_/X VGND VGND VPWR VPWR _6811_/Y sky130_fd_sc_hd__o21bai_2
XFILLER_51_614 VGND VGND VPWR VPWR sky130_fd_sc_hd__fill_2
X_7791_ _7791_/A _7791_/B VGND VGND VPWR VPWR _7792_/B sky130_fd_sc_hd__xnor2_2
XFILLER_63_485 VGND VGND VPWR VPWR sky130_fd_sc_hd__fill_1
X_6742_ _6739_/A _8411_/A _6620_/B VGND VGND VPWR VPWR _6742_/X sky130_fd_sc_hd__a21o_2
XFILLER_16_390 VGND VGND VPWR VPWR sky130_fd_sc_hd__decap_3
XTAP_TAPCELL_ROW_102_1656 VGND VPWR sky130_fd_sc_hd__tapvpwrvgnd_1
X_6673_ _6673_/A _6907_/A VGND VGND VPWR VPWR _6673_/Y sky130_fd_sc_hd__nor2_2
XFILLER_31_360 VGND VGND VPWR VPWR sky130_fd_sc_hd__decap_3
X_5624_ _9058_/Q _5624_/B _5624_/C VGND VGND VPWR VPWR _5626_/C sky130_fd_sc_hd__and3_2
X_8412_ _8405_/B _8406_/B _8327_/S VGND VGND VPWR VPWR _8496_/S sky130_fd_sc_hd__a21oi_2
XFILLER_31_393 VGND VGND VPWR VPWR sky130_fd_sc_hd__decap_3
X_8343_ _8445_/A wire67/X _8344_/A VGND VGND VPWR VPWR _8343_/X sky130_fd_sc_hd__a21o_2
X_5555_ _5521_/A _5519_/B _6416_/B _6817_/A VGND VGND VPWR VPWR _5555_/X sky130_fd_sc_hd__o211a_2
XFILLER_129_281 VGND VGND VPWR VPWR sky130_fd_sc_hd__fill_1
XFILLER_117_454 VGND VGND VPWR VPWR sky130_fd_sc_hd__decap_3
X_8274_ _8216_/B _8269_/Y _8270_/X _8273_/Y VGND VGND VPWR VPWR _8304_/B sky130_fd_sc_hd__o211a_2
X_5486_ _7763_/A _5392_/B _6765_/A VGND VGND VPWR VPWR _5486_/X sky130_fd_sc_hd__o21a_2
XFILLER_117_487 VGND VGND VPWR VPWR sky130_fd_sc_hd__decap_3
X_7225_ _7668_/A _7225_/B VGND VGND VPWR VPWR _7525_/B sky130_fd_sc_hd__xnor2_2
XFILLER_120_608 VGND VGND VPWR VPWR sky130_fd_sc_hd__fill_1
XFILLER_116_47 VGND VGND VPWR VPWR sky130_fd_sc_hd__decap_3
X_7156_ _6891_/A _7154_/Y _7155_/X VGND VGND VPWR VPWR _7156_/X sky130_fd_sc_hd__o21a_2
XFILLER_86_511 VGND VGND VPWR VPWR sky130_fd_sc_hd__decap_3
XFILLER_76_29 VGND VGND VPWR VPWR sky130_fd_sc_hd__decap_3
XFILLER_113_682 VGND VGND VPWR VPWR sky130_fd_sc_hd__decap_3
X_6107_ _6446_/A _6107_/B VGND VGND VPWR VPWR _6108_/B sky130_fd_sc_hd__nand2_2
XFILLER_86_533 VGND VGND VPWR VPWR sky130_fd_sc_hd__decap_3
X_7087_ _7404_/B _7083_/A _7086_/C _7086_/D VGND VGND VPWR VPWR _7088_/B sky130_fd_sc_hd__a22o_2
XFILLER_59_769 VGND VGND VPWR VPWR sky130_fd_sc_hd__decap_3
XFILLER_86_555 VGND VGND VPWR VPWR sky130_fd_sc_hd__fill_1
XFILLER_112_192 VGND VGND VPWR VPWR sky130_fd_sc_hd__fill_1
XFILLER_100_365 VGND VGND VPWR VPWR sky130_fd_sc_hd__decap_3
X_6038_ _6038_/A _6038_/B VGND VGND VPWR VPWR _6368_/A sky130_fd_sc_hd__nand2_2
XFILLER_58_279 VGND VGND VPWR VPWR sky130_fd_sc_hd__decap_3
XFILLER_39_460 VGND VGND VPWR VPWR sky130_fd_sc_hd__decap_3
XFILLER_27_600 VGND VGND VPWR VPWR sky130_fd_sc_hd__decap_3
XFILLER_27_633 VGND VGND VPWR VPWR sky130_fd_sc_hd__fill_2
XFILLER_26_121 VGND VGND VPWR VPWR sky130_fd_sc_hd__decap_3
XFILLER_27_655 VGND VGND VPWR VPWR sky130_fd_sc_hd__decap_3
XFILLER_14_305 VGND VGND VPWR VPWR sky130_fd_sc_hd__decap_3
XTAP_TAPCELL_ROW_1_297 VGND VPWR sky130_fd_sc_hd__tapvpwrvgnd_1
X_7989_ _7989_/A _7989_/B VGND VGND VPWR VPWR _7989_/Y sky130_fd_sc_hd__nand2_2
XFILLER_42_636 VGND VGND VPWR VPWR sky130_fd_sc_hd__decap_3
XFILLER_41_113 VGND VGND VPWR VPWR sky130_fd_sc_hd__decap_3
XTAP_TAPCELL_ROW_64_1139 VGND VPWR sky130_fd_sc_hd__tapvpwrvgnd_1
XFILLER_14_338 VGND VGND VPWR VPWR sky130_fd_sc_hd__decap_3
XFILLER_25_55 VGND VGND VPWR VPWR sky130_fd_sc_hd__fill_1
XFILLER_25_88 VGND VGND VPWR VPWR sky130_fd_sc_hd__decap_3
XTAP_TAPCELL_ROW_40_815 VGND VPWR sky130_fd_sc_hd__tapvpwrvgnd_1
XTAP_TAPCELL_ROW_40_826 VGND VPWR sky130_fd_sc_hd__tapvpwrvgnd_1
XFILLER_22_360 VGND VGND VPWR VPWR sky130_fd_sc_hd__decap_3
XFILLER_22_371 VGND VGND VPWR VPWR sky130_fd_sc_hd__decap_3
XFILLER_41_21 VGND VGND VPWR VPWR sky130_fd_sc_hd__decap_3
XFILLER_22_393 VGND VGND VPWR VPWR sky130_fd_sc_hd__decap_3
XFILLER_128_719 VGND VGND VPWR VPWR sky130_fd_sc_hd__decap_3
XFILLER_10_533 VGND VGND VPWR VPWR sky130_fd_sc_hd__decap_3
XFILLER_41_54 VGND VGND VPWR VPWR sky130_fd_sc_hd__fill_2
XTAP_TAPCELL_ROW_20_550 VGND VPWR sky130_fd_sc_hd__tapvpwrvgnd_1
XFILLER_41_65 VGND VGND VPWR VPWR sky130_fd_sc_hd__decap_3
XFILLER_108_421 VGND VGND VPWR VPWR sky130_fd_sc_hd__fill_2
XFILLER_108_487 VGND VGND VPWR VPWR sky130_fd_sc_hd__decap_3
XFILLER_2_710 VGND VGND VPWR VPWR sky130_fd_sc_hd__decap_3
XFILLER_123_413 VGND VGND VPWR VPWR sky130_fd_sc_hd__decap_3
XFILLER_2_743 VGND VGND VPWR VPWR sky130_fd_sc_hd__decap_3
XFILLER_1_220 VGND VGND VPWR VPWR sky130_fd_sc_hd__decap_3
XTAP_TAPCELL_ROW_9_397 VGND VPWR sky130_fd_sc_hd__tapvpwrvgnd_1
XFILLER_110_118 VGND VGND VPWR VPWR sky130_fd_sc_hd__decap_3
XFILLER_2_15 VGND VGND VPWR VPWR sky130_fd_sc_hd__decap_3
XFILLER_104_693 VGND VGND VPWR VPWR sky130_fd_sc_hd__decap_3
XFILLER_77_533 VGND VGND VPWR VPWR sky130_fd_sc_hd__decap_3
XFILLER_2_59 VGND VGND VPWR VPWR sky130_fd_sc_hd__decap_3
XTAP_TAPCELL_ROW_48_926 VGND VPWR sky130_fd_sc_hd__tapvpwrvgnd_1
XFILLER_49_279 VGND VGND VPWR VPWR sky130_fd_sc_hd__fill_1
XFILLER_66_62 VGND VGND VPWR VPWR sky130_fd_sc_hd__decap_3
XFILLER_66_73 VGND VGND VPWR VPWR sky130_fd_sc_hd__fill_2
XFILLER_64_238 VGND VGND VPWR VPWR sky130_fd_sc_hd__decap_3
XFILLER_73_750 VGND VGND VPWR VPWR sky130_fd_sc_hd__fill_1
XFILLER_45_441 VGND VGND VPWR VPWR sky130_fd_sc_hd__fill_1
XFILLER_17_132 VGND VGND VPWR VPWR sky130_fd_sc_hd__decap_3
XFILLER_17_143 VGND VGND VPWR VPWR sky130_fd_sc_hd__decap_3
XTAP_TAPCELL_ROW_28_661 VGND VPWR sky130_fd_sc_hd__tapvpwrvgnd_1
XFILLER_72_271 VGND VGND VPWR VPWR sky130_fd_sc_hd__decap_3
XFILLER_60_433 VGND VGND VPWR VPWR sky130_fd_sc_hd__fill_2
XFILLER_33_658 VGND VGND VPWR VPWR sky130_fd_sc_hd__decap_3
XFILLER_32_135 VGND VGND VPWR VPWR sky130_fd_sc_hd__fill_2
XFILLER_60_455 VGND VGND VPWR VPWR sky130_fd_sc_hd__decap_3
XFILLER_82_83 VGND VGND VPWR VPWR sky130_fd_sc_hd__fill_1
XFILLER_32_168 VGND VGND VPWR VPWR sky130_fd_sc_hd__decap_3
XFILLER_60_499 VGND VGND VPWR VPWR sky130_fd_sc_hd__decap_3
XFILLER_9_320 VGND VGND VPWR VPWR sky130_fd_sc_hd__decap_3
XFILLER_119_708 VGND VGND VPWR VPWR sky130_fd_sc_hd__decap_3
XFILLER_13_393 VGND VGND VPWR VPWR sky130_fd_sc_hd__fill_1
XFILLER_40_190 VGND VGND VPWR VPWR sky130_fd_sc_hd__decap_3
XFILLER_127_741 VGND VGND VPWR VPWR sky130_fd_sc_hd__decap_3
X_5340_ _5312_/A _5311_/A _5310_/Y VGND VGND VPWR VPWR _5418_/A sky130_fd_sc_hd__o21a_2
XFILLER_127_774 VGND VGND VPWR VPWR sky130_fd_sc_hd__decap_3
XFILLER_56_3 VGND VGND VPWR VPWR sky130_fd_sc_hd__decap_3
XTAP_TAPCELL_ROW_130_2030 VGND VPWR sky130_fd_sc_hd__tapvpwrvgnd_1
XFILLER_99_113 VGND VGND VPWR VPWR sky130_fd_sc_hd__fill_2
XFILLER_114_413 VGND VGND VPWR VPWR sky130_fd_sc_hd__decap_3
XFILLER_114_424 VGND VGND VPWR VPWR sky130_fd_sc_hd__decap_3
XTAP_TAPCELL_ROW_130_2041 VGND VPWR sky130_fd_sc_hd__tapvpwrvgnd_1
XFILLER_99_124 VGND VGND VPWR VPWR sky130_fd_sc_hd__decap_3
X_5271_ _5271_/A _5271_/B _5271_/C _5271_/D VGND VGND VPWR VPWR _5271_/Y sky130_fd_sc_hd__nor4_4
XTAP_TAPCELL_ROW_130_2052 VGND VPWR sky130_fd_sc_hd__tapvpwrvgnd_1
XFILLER_126_295 VGND VGND VPWR VPWR sky130_fd_sc_hd__decap_3
X_7010_ _7010_/A _7010_/B VGND VGND VPWR VPWR _7010_/Y sky130_fd_sc_hd__nand2_2
XFILLER_68_533 VGND VGND VPWR VPWR sky130_fd_sc_hd__decap_3
XFILLER_56_717 VGND VGND VPWR VPWR sky130_fd_sc_hd__fill_2
XFILLER_28_408 VGND VGND VPWR VPWR sky130_fd_sc_hd__decap_3
XFILLER_110_663 VGND VGND VPWR VPWR sky130_fd_sc_hd__decap_3
XFILLER_68_577 VGND VGND VPWR VPWR sky130_fd_sc_hd__decap_3
XFILLER_55_205 VGND VGND VPWR VPWR sky130_fd_sc_hd__fill_1
X_8961_ _8995_/A1 _8961_/A1 _8967_/S VGND VGND VPWR VPWR _8962_/A sky130_fd_sc_hd__mux2_2
XFILLER_83_536 VGND VGND VPWR VPWR sky130_fd_sc_hd__decap_3
X_7912_ _7924_/A _7909_/X _7911_/Y _7824_/A VGND VGND VPWR VPWR _7912_/X sky130_fd_sc_hd__o22a_2
X_8892_ hold914/X _8892_/A1 _8904_/S VGND VGND VPWR VPWR _8893_/A sky130_fd_sc_hd__mux2_2
XFILLER_36_463 VGND VGND VPWR VPWR sky130_fd_sc_hd__decap_3
XFILLER_102_38 VGND VGND VPWR VPWR sky130_fd_sc_hd__decap_3
XFILLER_24_614 VGND VGND VPWR VPWR sky130_fd_sc_hd__decap_3
X_7843_ _7836_/A _7839_/X _7842_/X VGND VGND VPWR VPWR _7843_/X sky130_fd_sc_hd__o21a_2
XFILLER_51_411 VGND VGND VPWR VPWR sky130_fd_sc_hd__decap_3
XFILLER_36_496 VGND VGND VPWR VPWR sky130_fd_sc_hd__decap_3
X_4986_ _9271_/Q _4916_/A _4985_/X _5059_/S VGND VGND VPWR VPWR _4986_/X sky130_fd_sc_hd__a22o_2
X_7774_ wire84/X _7764_/B _7762_/Y VGND VGND VPWR VPWR _7775_/B sky130_fd_sc_hd__a21oi_2
XFILLER_51_455 VGND VGND VPWR VPWR sky130_fd_sc_hd__decap_3
XFILLER_23_157 VGND VGND VPWR VPWR sky130_fd_sc_hd__fill_2
XFILLER_51_477 VGND VGND VPWR VPWR sky130_fd_sc_hd__decap_3
X_6725_ _6727_/A _6727_/B VGND VGND VPWR VPWR _6725_/Y sky130_fd_sc_hd__nor2_2
XFILLER_51_499 VGND VGND VPWR VPWR sky130_fd_sc_hd__decap_3
X_6656_ _6656_/A _6656_/B VGND VGND VPWR VPWR _6657_/B sky130_fd_sc_hd__nand2_2
XFILLER_127_9 VGND VGND VPWR VPWR sky130_fd_sc_hd__decap_3
X_5607_ _5607_/A _5607_/B VGND VGND VPWR VPWR _5766_/A sky130_fd_sc_hd__xnor2_2
X_6587_ _6976_/B _5071_/Y _6305_/B VGND VGND VPWR VPWR _6591_/A sky130_fd_sc_hd__a21oi_2
XFILLER_11_24 VGND VGND VPWR VPWR sky130_fd_sc_hd__decap_3
XFILLER_118_752 VGND VGND VPWR VPWR sky130_fd_sc_hd__decap_3
XFILLER_118_763 VGND VGND VPWR VPWR sky130_fd_sc_hd__decap_3
X_5538_ _5538_/A _6416_/B VGND VGND VPWR VPWR _5538_/X sky130_fd_sc_hd__or2b_2
X_8326_ _8245_/A _8321_/A _8324_/X VGND VGND VPWR VPWR _8416_/C sky130_fd_sc_hd__o21ai_2
XTAP_TAPCELL_ROW_115_1836 VGND VPWR sky130_fd_sc_hd__tapvpwrvgnd_1
XFILLER_127_24 VGND VGND VPWR VPWR sky130_fd_sc_hd__decap_3
XFILLER_11_57 VGND VGND VPWR VPWR sky130_fd_sc_hd__decap_3
XFILLER_105_424 VGND VGND VPWR VPWR sky130_fd_sc_hd__decap_3
XFILLER_127_57 VGND VGND VPWR VPWR sky130_fd_sc_hd__decap_3
X_8257_ _9220_/Q _8257_/B VGND VGND VPWR VPWR _8257_/Y sky130_fd_sc_hd__nor2_2
XFILLER_117_295 VGND VGND VPWR VPWR sky130_fd_sc_hd__fill_1
X_5469_ _9041_/Q _5469_/B _5875_/B VGND VGND VPWR VPWR _5473_/C sky130_fd_sc_hd__and3_2
XFILLER_105_468 VGND VGND VPWR VPWR sky130_fd_sc_hd__fill_1
XFILLER_105_479 VGND VGND VPWR VPWR sky130_fd_sc_hd__decap_3
X_7208_ _7208_/A _7208_/B VGND VGND VPWR VPWR _7209_/B sky130_fd_sc_hd__nor2_2
X_8188_ _8189_/A _8286_/S VGND VGND VPWR VPWR _8190_/A sky130_fd_sc_hd__and2_2
X_7139_ _7272_/B _7142_/C _7285_/B VGND VGND VPWR VPWR _7139_/Y sky130_fd_sc_hd__o21ai_2
XTAP_TAPCELL_ROW_6_356 VGND VPWR sky130_fd_sc_hd__tapvpwrvgnd_1
XFILLER_113_490 VGND VGND VPWR VPWR sky130_fd_sc_hd__decap_3
XTAP_TAPCELL_ROW_6_367 VGND VPWR sky130_fd_sc_hd__tapvpwrvgnd_1
XFILLER_86_341 VGND VGND VPWR VPWR sky130_fd_sc_hd__decap_3
Xfanout387 fanout391/X VGND VGND VPWR VPWR fanout387/X sky130_fd_sc_hd__clkdlybuf4s25_1
Xfanout398 fanout402/X VGND VGND VPWR VPWR fanout398/X sky130_fd_sc_hd__clkdlybuf4s25_1
XFILLER_59_588 VGND VGND VPWR VPWR sky130_fd_sc_hd__decap_3
XFILLER_86_374 VGND VGND VPWR VPWR sky130_fd_sc_hd__decap_3
XFILLER_59_599 VGND VGND VPWR VPWR sky130_fd_sc_hd__decap_3
XFILLER_101_696 VGND VGND VPWR VPWR sky130_fd_sc_hd__decap_3
XFILLER_74_536 VGND VGND VPWR VPWR sky130_fd_sc_hd__decap_3
XFILLER_36_21 VGND VGND VPWR VPWR sky130_fd_sc_hd__decap_3
XFILLER_36_32 VGND VGND VPWR VPWR sky130_fd_sc_hd__decap_3
XFILLER_27_452 VGND VGND VPWR VPWR sky130_fd_sc_hd__decap_3
XTAP_TAPCELL_ROW_126_1976 VGND VPWR sky130_fd_sc_hd__tapvpwrvgnd_1
XTAP_TAPCELL_ROW_126_1987 VGND VPWR sky130_fd_sc_hd__tapvpwrvgnd_1
XFILLER_70_720 VGND VGND VPWR VPWR sky130_fd_sc_hd__fill_2
XTAP_TAPCELL_ROW_25_620 VGND VPWR sky130_fd_sc_hd__tapvpwrvgnd_1
XFILLER_15_647 VGND VGND VPWR VPWR sky130_fd_sc_hd__decap_3
XFILLER_14_124 VGND VGND VPWR VPWR sky130_fd_sc_hd__decap_3
XFILLER_42_455 VGND VGND VPWR VPWR sky130_fd_sc_hd__decap_3
XFILLER_42_477 VGND VGND VPWR VPWR sky130_fd_sc_hd__decap_3
XTAP_TAPCELL_ROW_53_995 VGND VPWR sky130_fd_sc_hd__tapvpwrvgnd_1
Xinput18 input18/A VGND VGND VPWR VPWR input18/X sky130_fd_sc_hd__clkdlybuf4s25_1
XFILLER_10_352 VGND VGND VPWR VPWR sky130_fd_sc_hd__decap_3
XFILLER_6_312 VGND VGND VPWR VPWR sky130_fd_sc_hd__decap_3
XTAP_TAPCELL_ROW_77_1319 VGND VPWR sky130_fd_sc_hd__tapvpwrvgnd_1
XFILLER_6_345 VGND VGND VPWR VPWR sky130_fd_sc_hd__decap_3
XFILLER_124_722 VGND VGND VPWR VPWR sky130_fd_sc_hd__decap_3
XFILLER_124_755 VGND VGND VPWR VPWR sky130_fd_sc_hd__fill_1
XFILLER_124_766 VGND VGND VPWR VPWR sky130_fd_sc_hd__decap_3
XFILLER_97_606 VGND VGND VPWR VPWR sky130_fd_sc_hd__decap_3
XFILLER_69_308 VGND VGND VPWR VPWR sky130_fd_sc_hd__fill_2
XFILLER_96_127 VGND VGND VPWR VPWR sky130_fd_sc_hd__fill_2
XFILLER_2_584 VGND VGND VPWR VPWR sky130_fd_sc_hd__decap_3
XFILLER_117_90 VGND VGND VPWR VPWR sky130_fd_sc_hd__decap_3
XFILLER_96_138 VGND VGND VPWR VPWR sky130_fd_sc_hd__fill_2
XFILLER_77_50 VGND VGND VPWR VPWR sky130_fd_sc_hd__decap_3
XFILLER_2_595 VGND VGND VPWR VPWR sky130_fd_sc_hd__decap_3
XFILLER_123_298 VGND VGND VPWR VPWR sky130_fd_sc_hd__decap_3
XFILLER_111_449 VGND VGND VPWR VPWR sky130_fd_sc_hd__fill_1
XFILLER_65_514 VGND VGND VPWR VPWR sky130_fd_sc_hd__decap_3
XFILLER_38_739 VGND VGND VPWR VPWR sky130_fd_sc_hd__fill_1
XFILLER_77_396 VGND VGND VPWR VPWR sky130_fd_sc_hd__decap_3
XFILLER_92_333 VGND VGND VPWR VPWR sky130_fd_sc_hd__decap_3
XFILLER_65_558 VGND VGND VPWR VPWR sky130_fd_sc_hd__fill_2
XFILLER_80_506 VGND VGND VPWR VPWR sky130_fd_sc_hd__fill_2
XFILLER_80_517 VGND VGND VPWR VPWR sky130_fd_sc_hd__decap_3
XFILLER_18_452 VGND VGND VPWR VPWR sky130_fd_sc_hd__decap_3
XFILLER_46_772 VGND VGND VPWR VPWR sky130_fd_sc_hd__decap_3
XFILLER_45_260 VGND VGND VPWR VPWR sky130_fd_sc_hd__decap_3
XFILLER_18_474 VGND VGND VPWR VPWR sky130_fd_sc_hd__fill_2
XFILLER_80_539 VGND VGND VPWR VPWR sky130_fd_sc_hd__decap_3
X_4840_ hold958/X _9149_/Q _4840_/S VGND VGND VPWR VPWR _4840_/X sky130_fd_sc_hd__mux2_2
XFILLER_61_753 VGND VGND VPWR VPWR sky130_fd_sc_hd__decap_3
XFILLER_33_466 VGND VGND VPWR VPWR sky130_fd_sc_hd__decap_3
XFILLER_21_617 VGND VGND VPWR VPWR sky130_fd_sc_hd__decap_3
XFILLER_33_488 VGND VGND VPWR VPWR sky130_fd_sc_hd__decap_3
X_4771_ hold947/X _4771_/A1 _4777_/S VGND VGND VPWR VPWR _4772_/A sky130_fd_sc_hd__mux2_2
X_6510_ _6508_/X _6509_/Y _6510_/S VGND VGND VPWR VPWR _6510_/X sky130_fd_sc_hd__mux2_2
XFILLER_119_505 VGND VGND VPWR VPWR sky130_fd_sc_hd__fill_2
X_7490_ _7492_/A _7490_/B _7492_/B VGND VGND VPWR VPWR _7490_/X sky130_fd_sc_hd__and3_2
XFILLER_9_150 VGND VGND VPWR VPWR sky130_fd_sc_hd__decap_3
X_6441_ _6441_/A1 _6439_/X _6440_/X VGND VGND VPWR VPWR _6442_/B sky130_fd_sc_hd__o21ai_4
XFILLER_9_183 VGND VGND VPWR VPWR sky130_fd_sc_hd__decap_3
X_9160_ _9348_/CLK _9160_/D load_slew404/X VGND VGND VPWR VPWR _9160_/Q sky130_fd_sc_hd__dfrtp_2
XFILLER_115_700 VGND VGND VPWR VPWR sky130_fd_sc_hd__decap_3
X_6372_ _6370_/B _6528_/B _6367_/Y _6371_/Y VGND VGND VPWR VPWR _6372_/X sky130_fd_sc_hd__o2bb2a_2
XFILLER_115_722 VGND VGND VPWR VPWR sky130_fd_sc_hd__decap_3
X_8111_ _8111_/A _8111_/B VGND VGND VPWR VPWR _8112_/C sky130_fd_sc_hd__and2_2
X_5323_ _7528_/B2 _5535_/B _5319_/Y _5322_/X _6077_/A VGND VGND VPWR VPWR _5323_/Y
+ sky130_fd_sc_hd__o221ai_2
X_9091_ _9135_/CLK _9091_/D load_slew396/X VGND VGND VPWR VPWR _9091_/Q sky130_fd_sc_hd__dfrtp_2
XFILLER_115_755 VGND VGND VPWR VPWR sky130_fd_sc_hd__decap_3
XFILLER_88_606 VGND VGND VPWR VPWR sky130_fd_sc_hd__decap_3
XFILLER_102_405 VGND VGND VPWR VPWR sky130_fd_sc_hd__decap_3
X_8042_ _7895_/A _7894_/A _8041_/X VGND VGND VPWR VPWR _8043_/B sky130_fd_sc_hd__o21a_2
XFILLER_88_628 VGND VGND VPWR VPWR sky130_fd_sc_hd__decap_3
XFILLER_114_265 VGND VGND VPWR VPWR sky130_fd_sc_hd__decap_3
X_5254_ _9200_/Q _5410_/A _5247_/X _5253_/Y VGND VGND VPWR VPWR _5308_/A sky130_fd_sc_hd__o31a_2
XFILLER_130_725 VGND VGND VPWR VPWR sky130_fd_sc_hd__decap_3
XFILLER_87_116 VGND VGND VPWR VPWR sky130_fd_sc_hd__decap_3
XFILLER_102_427 VGND VGND VPWR VPWR sky130_fd_sc_hd__decap_3
XFILLER_130_747 VGND VGND VPWR VPWR sky130_fd_sc_hd__decap_3
XFILLER_114_298 VGND VGND VPWR VPWR sky130_fd_sc_hd__fill_1
XFILLER_102_449 VGND VGND VPWR VPWR sky130_fd_sc_hd__decap_3
XFILLER_68_330 VGND VGND VPWR VPWR sky130_fd_sc_hd__decap_3
XFILLER_130_769 VGND VGND VPWR VPWR sky130_fd_sc_hd__decap_3
X_5185_ _5187_/C _5457_/A _5185_/C VGND VGND VPWR VPWR _5185_/X sky130_fd_sc_hd__and3_2
XTAP_TAPCELL_ROW_110_1766 VGND VPWR sky130_fd_sc_hd__tapvpwrvgnd_1
XFILLER_56_503 VGND VGND VPWR VPWR sky130_fd_sc_hd__decap_3
XTAP_TAPCELL_ROW_3_326 VGND VPWR sky130_fd_sc_hd__tapvpwrvgnd_1
XFILLER_56_525 VGND VGND VPWR VPWR sky130_fd_sc_hd__decap_3
XFILLER_28_227 VGND VGND VPWR VPWR sky130_fd_sc_hd__decap_3
XFILLER_113_15 VGND VGND VPWR VPWR sky130_fd_sc_hd__decap_3
XFILLER_56_547 VGND VGND VPWR VPWR sky130_fd_sc_hd__decap_3
XFILLER_110_493 VGND VGND VPWR VPWR sky130_fd_sc_hd__decap_3
XFILLER_56_558 VGND VGND VPWR VPWR sky130_fd_sc_hd__decap_3
XFILLER_113_48 VGND VGND VPWR VPWR sky130_fd_sc_hd__decap_3
X_8944_ _8944_/A0 _8944_/A1 _8946_/S VGND VGND VPWR VPWR _8945_/A sky130_fd_sc_hd__mux2_2
XFILLER_37_750 VGND VGND VPWR VPWR sky130_fd_sc_hd__decap_3
XFILLER_37_772 VGND VGND VPWR VPWR sky130_fd_sc_hd__decap_3
XFILLER_71_539 VGND VGND VPWR VPWR sky130_fd_sc_hd__decap_3
XFILLER_24_400 VGND VGND VPWR VPWR sky130_fd_sc_hd__decap_3
X_8875_ _9281_/Q _8875_/A1 _8883_/S VGND VGND VPWR VPWR _8875_/X sky130_fd_sc_hd__mux2_2
XFILLER_52_753 VGND VGND VPWR VPWR sky130_fd_sc_hd__decap_3
XFILLER_24_444 VGND VGND VPWR VPWR sky130_fd_sc_hd__decap_3
X_7826_ _7826_/A _7826_/B VGND VGND VPWR VPWR _7846_/A sky130_fd_sc_hd__xnor2_2
XTAP_TAPCELL_ROW_61_1109 VGND VPWR sky130_fd_sc_hd__tapvpwrvgnd_1
XFILLER_24_466 VGND VGND VPWR VPWR sky130_fd_sc_hd__decap_3
XFILLER_12_606 VGND VGND VPWR VPWR sky130_fd_sc_hd__decap_3
XFILLER_24_477 VGND VGND VPWR VPWR sky130_fd_sc_hd__decap_3
XFILLER_24_488 VGND VGND VPWR VPWR sky130_fd_sc_hd__decap_3
X_4969_ _5934_/A VGND VGND VPWR VPWR _5514_/A sky130_fd_sc_hd__inv_2
X_7757_ _7408_/A _8155_/A _7619_/A _7763_/A VGND VGND VPWR VPWR _7757_/X sky130_fd_sc_hd__o211a_2
XFILLER_11_116 VGND VGND VPWR VPWR sky130_fd_sc_hd__fill_1
XTAP_TAPCELL_ROW_50_954 VGND VPWR sky130_fd_sc_hd__tapvpwrvgnd_1
X_6708_ _6708_/A _6708_/B VGND VGND VPWR VPWR _6730_/A sky130_fd_sc_hd__or2_2
XFILLER_22_12 VGND VGND VPWR VPWR sky130_fd_sc_hd__decap_3
XFILLER_7_109 VGND VGND VPWR VPWR sky130_fd_sc_hd__decap_3
X_7688_ _7688_/A _7688_/B VGND VGND VPWR VPWR _7705_/B sky130_fd_sc_hd__xnor2_2
XFILLER_20_672 VGND VGND VPWR VPWR sky130_fd_sc_hd__decap_3
XFILLER_125_6 VGND VGND VPWR VPWR sky130_fd_sc_hd__decap_3
X_6639_ _6643_/B _6644_/S VGND VGND VPWR VPWR _6640_/C sky130_fd_sc_hd__nor2_2
XFILLER_22_67 VGND VGND VPWR VPWR sky130_fd_sc_hd__decap_3
XFILLER_106_733 VGND VGND VPWR VPWR sky130_fd_sc_hd__decap_3
X_8309_ _8309_/A _8309_/B VGND VGND VPWR VPWR _8309_/Y sky130_fd_sc_hd__nor2_2
XFILLER_3_337 VGND VGND VPWR VPWR sky130_fd_sc_hd__decap_3
XFILLER_105_243 VGND VGND VPWR VPWR sky130_fd_sc_hd__decap_3
X_9289_ clkload4/A _9289_/D wire372/X VGND VGND VPWR VPWR _9289_/Q sky130_fd_sc_hd__dfrtp_2
XFILLER_79_606 VGND VGND VPWR VPWR sky130_fd_sc_hd__decap_3
XFILLER_79_617 VGND VGND VPWR VPWR sky130_fd_sc_hd__fill_2
XFILLER_105_265 VGND VGND VPWR VPWR sky130_fd_sc_hd__fill_2
XTAP_TAPCELL_ROW_72_1249 VGND VPWR sky130_fd_sc_hd__tapvpwrvgnd_1
XFILLER_78_116 VGND VGND VPWR VPWR sky130_fd_sc_hd__decap_3
XFILLER_120_213 VGND VGND VPWR VPWR sky130_fd_sc_hd__decap_3
XPHY_EDGE_ROW_110_Right_110 VGND VGND VPWR VPWR sky130_fd_sc_hd__decap_3
XFILLER_121_747 VGND VGND VPWR VPWR sky130_fd_sc_hd__decap_3
XFILLER_59_363 VGND VGND VPWR VPWR sky130_fd_sc_hd__decap_3
XFILLER_47_503 VGND VGND VPWR VPWR sky130_fd_sc_hd__fill_1
XFILLER_47_514 VGND VGND VPWR VPWR sky130_fd_sc_hd__fill_2
XFILLER_120_279 VGND VGND VPWR VPWR sky130_fd_sc_hd__decap_3
XFILLER_59_396 VGND VGND VPWR VPWR sky130_fd_sc_hd__fill_2
XFILLER_47_53 VGND VGND VPWR VPWR sky130_fd_sc_hd__decap_3
XFILLER_62_517 VGND VGND VPWR VPWR sky130_fd_sc_hd__fill_1
XFILLER_28_772 VGND VGND VPWR VPWR sky130_fd_sc_hd__decap_3
XFILLER_15_411 VGND VGND VPWR VPWR sky130_fd_sc_hd__decap_3
XFILLER_15_433 VGND VGND VPWR VPWR sky130_fd_sc_hd__fill_2
XFILLER_43_764 VGND VGND VPWR VPWR sky130_fd_sc_hd__decap_3
XFILLER_15_455 VGND VGND VPWR VPWR sky130_fd_sc_hd__decap_3
XFILLER_30_458 VGND VGND VPWR VPWR sky130_fd_sc_hd__decap_3
XFILLER_8_47 VGND VGND VPWR VPWR sky130_fd_sc_hd__decap_3
XFILLER_11_661 VGND VGND VPWR VPWR sky130_fd_sc_hd__decap_3
XFILLER_7_643 VGND VGND VPWR VPWR sky130_fd_sc_hd__decap_3
XFILLER_6_120 VGND VGND VPWR VPWR sky130_fd_sc_hd__decap_3
XFILLER_128_368 VGND VGND VPWR VPWR sky130_fd_sc_hd__decap_3
XFILLER_7_665 VGND VGND VPWR VPWR sky130_fd_sc_hd__decap_3
XFILLER_7_698 VGND VGND VPWR VPWR sky130_fd_sc_hd__decap_3
XFILLER_109_593 VGND VGND VPWR VPWR sky130_fd_sc_hd__decap_3
XFILLER_6_197 VGND VGND VPWR VPWR sky130_fd_sc_hd__decap_3
XFILLER_69_116 VGND VGND VPWR VPWR sky130_fd_sc_hd__decap_3
XPHY_EDGE_ROW_69_Left_200 VGND VGND VPWR VPWR sky130_fd_sc_hd__decap_3
XFILLER_78_683 VGND VGND VPWR VPWR sky130_fd_sc_hd__decap_3
XFILLER_38_514 VGND VGND VPWR VPWR sky130_fd_sc_hd__decap_3
XFILLER_93_620 VGND VGND VPWR VPWR sky130_fd_sc_hd__fill_1
XFILLER_65_322 VGND VGND VPWR VPWR sky130_fd_sc_hd__decap_3
XFILLER_38_536 VGND VGND VPWR VPWR sky130_fd_sc_hd__decap_3
XFILLER_19_3 VGND VGND VPWR VPWR sky130_fd_sc_hd__decap_3
XFILLER_38_558 VGND VGND VPWR VPWR sky130_fd_sc_hd__decap_3
XFILLER_93_664 VGND VGND VPWR VPWR sky130_fd_sc_hd__decap_3
XFILLER_92_141 VGND VGND VPWR VPWR sky130_fd_sc_hd__decap_3
XFILLER_65_355 VGND VGND VPWR VPWR sky130_fd_sc_hd__decap_3
XFILLER_19_750 VGND VGND VPWR VPWR sky130_fd_sc_hd__decap_3
X_6990_ _6990_/A _6990_/B VGND VGND VPWR VPWR _6990_/Y sky130_fd_sc_hd__xnor2_2
XFILLER_53_517 VGND VGND VPWR VPWR sky130_fd_sc_hd__decap_3
XFILLER_92_163 VGND VGND VPWR VPWR sky130_fd_sc_hd__decap_3
XFILLER_93_697 VGND VGND VPWR VPWR sky130_fd_sc_hd__decap_3
XFILLER_18_260 VGND VGND VPWR VPWR sky130_fd_sc_hd__decap_3
X_5941_ _6483_/S _6446_/B VGND VGND VPWR VPWR _5942_/B sky130_fd_sc_hd__nand2_2
XFILLER_65_399 VGND VGND VPWR VPWR sky130_fd_sc_hd__decap_3
XFILLER_34_731 VGND VGND VPWR VPWR sky130_fd_sc_hd__decap_3
XFILLER_18_282 VGND VGND VPWR VPWR sky130_fd_sc_hd__decap_3
X_5872_ _5872_/A _5872_/B _5872_/C VGND VGND VPWR VPWR _6061_/C sky130_fd_sc_hd__and3_2
X_8660_ _8581_/Y _8476_/X _8654_/S VGND VGND VPWR VPWR _8660_/Y sky130_fd_sc_hd__a21oi_2
XFILLER_34_775 VGND VGND VPWR VPWR sky130_fd_sc_hd__fill_2
XFILLER_33_241 VGND VGND VPWR VPWR sky130_fd_sc_hd__fill_2
XFILLER_21_403 VGND VGND VPWR VPWR sky130_fd_sc_hd__fill_2
X_4823_ _4823_/A VGND VGND VPWR VPWR _9156_/D sky130_fd_sc_hd__buf_1
X_7611_ _5975_/A _7611_/A2 _5855_/B VGND VGND VPWR VPWR _7613_/A sky130_fd_sc_hd__a21oi_2
XFILLER_21_414 VGND VGND VPWR VPWR sky130_fd_sc_hd__decap_3
X_8591_ _8581_/Y _8588_/X _8590_/X VGND VGND VPWR VPWR _8591_/Y sky130_fd_sc_hd__o21ai_2
XTAP_TAPCELL_ROW_16_494 VGND VPWR sky130_fd_sc_hd__tapvpwrvgnd_1
X_4754_ _9124_/Q hold924/X _4756_/S VGND VGND VPWR VPWR _4754_/X sky130_fd_sc_hd__mux2_2
X_7542_ _7877_/A _7543_/B VGND VGND VPWR VPWR _7702_/B sky130_fd_sc_hd__and2_2
XFILLER_119_335 VGND VGND VPWR VPWR sky130_fd_sc_hd__fill_1
X_7473_ _8780_/C _5349_/X _7472_/Y _5348_/S VGND VGND VPWR VPWR _7474_/B sky130_fd_sc_hd__o211a_2
X_4685_ hold831/X _4685_/A1 _4693_/S VGND VGND VPWR VPWR _4686_/A sky130_fd_sc_hd__mux2_2
XFILLER_107_508 VGND VGND VPWR VPWR sky130_fd_sc_hd__decap_3
XFILLER_119_368 VGND VGND VPWR VPWR sky130_fd_sc_hd__decap_3
X_9212_ _9215_/CLK _9212_/D load_slew420/X VGND VGND VPWR VPWR _9212_/Q sky130_fd_sc_hd__dfrtp_2
X_6424_ input3/X _6117_/X _6425_/S VGND VGND VPWR VPWR _6424_/X sky130_fd_sc_hd__mux2_2
XFILLER_108_15 VGND VGND VPWR VPWR sky130_fd_sc_hd__decap_3
X_9143_ _9159_/CLK _9143_/D fanout391/X VGND VGND VPWR VPWR _9143_/Q sky130_fd_sc_hd__dfrtp_2
XTAP_TAPCELL_ROW_58_1060 VGND VPWR sky130_fd_sc_hd__tapvpwrvgnd_1
XFILLER_115_552 VGND VGND VPWR VPWR sky130_fd_sc_hd__decap_3
XTAP_TAPCELL_ROW_58_1071 VGND VPWR sky130_fd_sc_hd__tapvpwrvgnd_1
X_5306_ _5493_/A _5493_/B VGND VGND VPWR VPWR _5306_/X sky130_fd_sc_hd__xor2_2
XFILLER_115_574 VGND VGND VPWR VPWR sky130_fd_sc_hd__decap_3
XFILLER_103_725 VGND VGND VPWR VPWR sky130_fd_sc_hd__decap_3
X_9074_ _9341_/CLK _9074_/D fanout379/A VGND VGND VPWR VPWR _9074_/Q sky130_fd_sc_hd__dfrtp_2
X_6286_ _6286_/A _6286_/B VGND VGND VPWR VPWR _6287_/A sky130_fd_sc_hd__xnor2_4
XFILLER_130_511 VGND VGND VPWR VPWR sky130_fd_sc_hd__decap_3
XFILLER_88_436 VGND VGND VPWR VPWR sky130_fd_sc_hd__decap_3
XFILLER_130_533 VGND VGND VPWR VPWR sky130_fd_sc_hd__decap_3
X_5237_ _9199_/Q _5344_/A VGND VGND VPWR VPWR _5237_/X sky130_fd_sc_hd__or2_2
X_8025_ _8022_/X _8017_/A _8025_/S VGND VGND VPWR VPWR _8025_/X sky130_fd_sc_hd__mux2_2
XFILLER_69_661 VGND VGND VPWR VPWR sky130_fd_sc_hd__decap_3
XFILLER_124_47 VGND VGND VPWR VPWR sky130_fd_sc_hd__decap_3
XFILLER_29_514 VGND VGND VPWR VPWR sky130_fd_sc_hd__fill_1
X_5168_ _9199_/Q _5135_/A _7311_/A _5167_/Y _5048_/B VGND VGND VPWR VPWR _5168_/Y
+ sky130_fd_sc_hd__a221oi_2
XFILLER_69_694 VGND VGND VPWR VPWR sky130_fd_sc_hd__decap_3
XFILLER_96_491 VGND VGND VPWR VPWR sky130_fd_sc_hd__fill_2
XFILLER_84_653 VGND VGND VPWR VPWR sky130_fd_sc_hd__fill_2
XFILLER_56_344 VGND VGND VPWR VPWR sky130_fd_sc_hd__decap_3
XFILLER_17_12 VGND VGND VPWR VPWR sky130_fd_sc_hd__decap_3
X_5099_ _6094_/B _6083_/B VGND VGND VPWR VPWR _5100_/C sky130_fd_sc_hd__nor2_2
XFILLER_44_506 VGND VGND VPWR VPWR sky130_fd_sc_hd__decap_3
XFILLER_83_163 VGND VGND VPWR VPWR sky130_fd_sc_hd__fill_2
XFILLER_56_377 VGND VGND VPWR VPWR sky130_fd_sc_hd__fill_1
XFILLER_17_45 VGND VGND VPWR VPWR sky130_fd_sc_hd__decap_3
X_8927_ _8969_/A VGND VGND VPWR VPWR _8946_/S sky130_fd_sc_hd__clkbuf_2
XFILLER_44_539 VGND VGND VPWR VPWR sky130_fd_sc_hd__decap_3
XFILLER_83_196 VGND VGND VPWR VPWR sky130_fd_sc_hd__decap_3
XFILLER_71_347 VGND VGND VPWR VPWR sky130_fd_sc_hd__decap_3
XTAP_TAPCELL_ROW_123_1946 VGND VPWR sky130_fd_sc_hd__tapvpwrvgnd_1
XFILLER_25_753 VGND VGND VPWR VPWR sky130_fd_sc_hd__decap_3
X_8858_ _8892_/A1 _8858_/A1 _8862_/S VGND VGND VPWR VPWR _8859_/A sky130_fd_sc_hd__mux2_2
XFILLER_52_561 VGND VGND VPWR VPWR sky130_fd_sc_hd__decap_3
XFILLER_40_701 VGND VGND VPWR VPWR sky130_fd_sc_hd__fill_2
XFILLER_52_572 VGND VGND VPWR VPWR sky130_fd_sc_hd__decap_3
XFILLER_12_403 VGND VGND VPWR VPWR sky130_fd_sc_hd__decap_3
X_7809_ _7809_/A _7809_/B VGND VGND VPWR VPWR _7810_/B sky130_fd_sc_hd__xor2_2
XFILLER_33_22 VGND VGND VPWR VPWR sky130_fd_sc_hd__decap_3
XFILLER_24_274 VGND VGND VPWR VPWR sky130_fd_sc_hd__decap_3
X_8789_ _9240_/Q hold749/X _8799_/S VGND VGND VPWR VPWR _8789_/X sky130_fd_sc_hd__mux2_2
XFILLER_33_44 VGND VGND VPWR VPWR sky130_fd_sc_hd__decap_3
XFILLER_8_407 VGND VGND VPWR VPWR sky130_fd_sc_hd__decap_3
XFILLER_33_66 VGND VGND VPWR VPWR sky130_fd_sc_hd__decap_3
XFILLER_8_429 VGND VGND VPWR VPWR sky130_fd_sc_hd__decap_3
XFILLER_123_3 VGND VGND VPWR VPWR sky130_fd_sc_hd__decap_3
XFILLER_125_316 VGND VGND VPWR VPWR sky130_fd_sc_hd__fill_2
XFILLER_4_679 VGND VGND VPWR VPWR sky130_fd_sc_hd__decap_3
XFILLER_79_414 VGND VGND VPWR VPWR sky130_fd_sc_hd__decap_3
XFILLER_79_469 VGND VGND VPWR VPWR sky130_fd_sc_hd__decap_3
XFILLER_67_609 VGND VGND VPWR VPWR sky130_fd_sc_hd__fill_2
XFILLER_58_52 VGND VGND VPWR VPWR sky130_fd_sc_hd__decap_3
XFILLER_94_439 VGND VGND VPWR VPWR sky130_fd_sc_hd__decap_3
XFILLER_75_642 VGND VGND VPWR VPWR sky130_fd_sc_hd__decap_3
XFILLER_75_664 VGND VGND VPWR VPWR sky130_fd_sc_hd__decap_3
XFILLER_74_141 VGND VGND VPWR VPWR sky130_fd_sc_hd__decap_3
XFILLER_47_366 VGND VGND VPWR VPWR sky130_fd_sc_hd__decap_3
XFILLER_114_80 VGND VGND VPWR VPWR sky130_fd_sc_hd__decap_3
XTAP_TAPCELL_ROW_85_1429 VGND VPWR sky130_fd_sc_hd__tapvpwrvgnd_1
XFILLER_47_399 VGND VGND VPWR VPWR sky130_fd_sc_hd__decap_3
XFILLER_90_645 VGND VGND VPWR VPWR sky130_fd_sc_hd__fill_2
XFILLER_16_731 VGND VGND VPWR VPWR sky130_fd_sc_hd__decap_3
XFILLER_62_358 VGND VGND VPWR VPWR sky130_fd_sc_hd__decap_3
XFILLER_15_241 VGND VGND VPWR VPWR sky130_fd_sc_hd__decap_3
XFILLER_90_689 VGND VGND VPWR VPWR sky130_fd_sc_hd__decap_3
XFILLER_43_561 VGND VGND VPWR VPWR sky130_fd_sc_hd__decap_3
XFILLER_16_775 VGND VGND VPWR VPWR sky130_fd_sc_hd__fill_2
XTAP_TAPCELL_ROW_33_729 VGND VPWR sky130_fd_sc_hd__tapvpwrvgnd_1
XFILLER_43_572 VGND VGND VPWR VPWR sky130_fd_sc_hd__decap_3
XFILLER_43_594 VGND VGND VPWR VPWR sky130_fd_sc_hd__decap_3
XFILLER_30_222 VGND VGND VPWR VPWR sky130_fd_sc_hd__decap_3
XFILLER_129_600 VGND VGND VPWR VPWR sky130_fd_sc_hd__decap_3
XTAP_TAPCELL_ROW_13_453 VGND VPWR sky130_fd_sc_hd__tapvpwrvgnd_1
XFILLER_90_83 VGND VGND VPWR VPWR sky130_fd_sc_hd__fill_1
XFILLER_90_94 VGND VGND VPWR VPWR sky130_fd_sc_hd__decap_3
XFILLER_30_277 VGND VGND VPWR VPWR sky130_fd_sc_hd__decap_3
XFILLER_129_644 VGND VGND VPWR VPWR sky130_fd_sc_hd__decap_3
XFILLER_128_121 VGND VGND VPWR VPWR sky130_fd_sc_hd__decap_3
XFILLER_11_480 VGND VGND VPWR VPWR sky130_fd_sc_hd__fill_1
XFILLER_129_688 VGND VGND VPWR VPWR sky130_fd_sc_hd__decap_3
XFILLER_128_165 VGND VGND VPWR VPWR sky130_fd_sc_hd__decap_3
Xmax_cap104 _8837_/S VGND VGND VPWR VPWR _8841_/S sky130_fd_sc_hd__buf_2
Xmax_cap115 _7857_/B VGND VGND VPWR VPWR _7694_/A sky130_fd_sc_hd__clkbuf_2
XFILLER_109_390 VGND VGND VPWR VPWR sky130_fd_sc_hd__fill_2
Xmax_cap137 _5014_/X VGND VGND VPWR VPWR _5016_/B sky130_fd_sc_hd__clkbuf_2
XFILLER_98_701 VGND VGND VPWR VPWR sky130_fd_sc_hd__decap_3
X_6140_ _6140_/A _6140_/B VGND VGND VPWR VPWR _6140_/Y sky130_fd_sc_hd__xnor2_2
Xload_slew310 _6460_/S VGND VGND VPWR VPWR _5968_/S sky130_fd_sc_hd__buf_2
XFILLER_98_745 VGND VGND VPWR VPWR sky130_fd_sc_hd__decap_3
XFILLER_112_522 VGND VGND VPWR VPWR sky130_fd_sc_hd__decap_3
XFILLER_112_533 VGND VGND VPWR VPWR sky130_fd_sc_hd__decap_3
Xload_slew321 _6131_/A VGND VGND VPWR VPWR _6446_/A sky130_fd_sc_hd__clkbuf_4
X_6071_ _6068_/Y _6071_/B VGND VGND VPWR VPWR _6071_/X sky130_fd_sc_hd__and2b_2
Xload_slew332 _6873_/A VGND VGND VPWR VPWR _5546_/B sky130_fd_sc_hd__buf_2
XFILLER_58_609 VGND VGND VPWR VPWR sky130_fd_sc_hd__decap_3
Xload_slew343 _7869_/A VGND VGND VPWR VPWR _6414_/A sky130_fd_sc_hd__buf_6
XTAP_TAPCELL_ROW_127_2002 VGND VPWR sky130_fd_sc_hd__tapvpwrvgnd_1
XFILLER_112_577 VGND VGND VPWR VPWR sky130_fd_sc_hd__decap_3
X_5022_ _7095_/A VGND VGND VPWR VPWR _7317_/A sky130_fd_sc_hd__buf_6
Xhold1107 _9271_/Q VGND VGND VPWR VPWR _8888_/A1 sky130_fd_sc_hd__dlygate4sd3_1
XFILLER_85_428 VGND VGND VPWR VPWR sky130_fd_sc_hd__fill_2
Xload_slew376 fanout375/X VGND VGND VPWR VPWR load_slew376/X sky130_fd_sc_hd__buf_4
Xhold1118 _4554_/X VGND VGND VPWR VPWR _4555_/A sky130_fd_sc_hd__dlygate4sd3_1
Xhold1129 _4558_/X VGND VGND VPWR VPWR _4559_/A sky130_fd_sc_hd__dlygate4sd3_1
XFILLER_97_299 VGND VGND VPWR VPWR sky130_fd_sc_hd__decap_3
XFILLER_78_491 VGND VGND VPWR VPWR sky130_fd_sc_hd__decap_3
XFILLER_66_642 VGND VGND VPWR VPWR sky130_fd_sc_hd__fill_2
XFILLER_38_355 VGND VGND VPWR VPWR sky130_fd_sc_hd__decap_3
XFILLER_93_461 VGND VGND VPWR VPWR sky130_fd_sc_hd__decap_3
XFILLER_38_377 VGND VGND VPWR VPWR sky130_fd_sc_hd__decap_3
XFILLER_26_517 VGND VGND VPWR VPWR sky130_fd_sc_hd__decap_3
XFILLER_81_612 VGND VGND VPWR VPWR sky130_fd_sc_hd__decap_3
XFILLER_66_697 VGND VGND VPWR VPWR sky130_fd_sc_hd__decap_3
XFILLER_93_494 VGND VGND VPWR VPWR sky130_fd_sc_hd__decap_3
XFILLER_53_325 VGND VGND VPWR VPWR sky130_fd_sc_hd__fill_2
XFILLER_38_399 VGND VGND VPWR VPWR sky130_fd_sc_hd__decap_3
X_6973_ _5743_/B _5272_/X _5273_/Y _6211_/B VGND VGND VPWR VPWR _7073_/B sky130_fd_sc_hd__a211o_2
X_8712_ _8210_/B _8728_/S _7561_/A _8774_/C1 VGND VGND VPWR VPWR _8712_/X sky130_fd_sc_hd__o211a_2
XFILLER_0_92 VGND VGND VPWR VPWR sky130_fd_sc_hd__decap_3
X_5924_ _5920_/Y _5921_/Y _5923_/X VGND VGND VPWR VPWR _5963_/A sky130_fd_sc_hd__o21ai_2
XFILLER_53_369 VGND VGND VPWR VPWR sky130_fd_sc_hd__decap_3
XFILLER_22_701 VGND VGND VPWR VPWR sky130_fd_sc_hd__decap_3
XFILLER_80_177 VGND VGND VPWR VPWR sky130_fd_sc_hd__decap_3
XFILLER_110_27 VGND VGND VPWR VPWR sky130_fd_sc_hd__fill_1
XFILLER_110_38 VGND VGND VPWR VPWR sky130_fd_sc_hd__decap_3
X_8643_ _8644_/A _8644_/B VGND VGND VPWR VPWR _8643_/X sky130_fd_sc_hd__and2_2
XFILLER_22_734 VGND VGND VPWR VPWR sky130_fd_sc_hd__decap_3
X_5855_ _5855_/A _5855_/B VGND VGND VPWR VPWR _5856_/A sky130_fd_sc_hd__or2_2
XTAP_TAPCELL_ROW_105_1698 VGND VPWR sky130_fd_sc_hd__tapvpwrvgnd_1
XFILLER_61_391 VGND VGND VPWR VPWR sky130_fd_sc_hd__fill_1
X_4806_ _4806_/A VGND VGND VPWR VPWR _9148_/D sky130_fd_sc_hd__buf_1
X_8574_ _8636_/A _8575_/B VGND VGND VPWR VPWR _8576_/A sky130_fd_sc_hd__or2_2
X_5786_ _6873_/A _5926_/B VGND VGND VPWR VPWR _5786_/Y sky130_fd_sc_hd__nand2_2
Xrebuffer504 _6387_/A VGND VGND VPWR VPWR _6069_/A sky130_fd_sc_hd__buf_2
XFILLER_21_277 VGND VGND VPWR VPWR sky130_fd_sc_hd__decap_3
Xrebuffer515 wire243/A VGND VGND VPWR VPWR _5266_/S sky130_fd_sc_hd__buf_2
X_7525_ _6406_/X _7525_/B VGND VGND VPWR VPWR _7525_/X sky130_fd_sc_hd__and2b_2
X_4737_ _4842_/A VGND VGND VPWR VPWR _4756_/S sky130_fd_sc_hd__clkbuf_2
Xrebuffer526 _7467_/X VGND VGND VPWR VPWR _7486_/A sky130_fd_sc_hd__buf_2
Xrebuffer537 _6203_/A VGND VGND VPWR VPWR _6289_/A2 sky130_fd_sc_hd__buf_2
Xrebuffer548 _5724_/B VGND VGND VPWR VPWR _5723_/B1 sky130_fd_sc_hd__buf_2
XFILLER_119_36 VGND VGND VPWR VPWR sky130_fd_sc_hd__decap_3
Xrebuffer559 _6022_/A VGND VGND VPWR VPWR _6189_/B sky130_fd_sc_hd__buf_6
XFILLER_119_165 VGND VGND VPWR VPWR sky130_fd_sc_hd__decap_3
XFILLER_107_316 VGND VGND VPWR VPWR sky130_fd_sc_hd__decap_3
X_4668_ _4702_/A1 _4668_/A1 _4672_/S VGND VGND VPWR VPWR _4669_/A sky130_fd_sc_hd__mux2_2
X_7456_ _7443_/Y _7444_/X _7454_/X _7455_/Y VGND VGND VPWR VPWR _7458_/B sky130_fd_sc_hd__a211o_2
XFILLER_119_69 VGND VGND VPWR VPWR sky130_fd_sc_hd__decap_3
XFILLER_119_187 VGND VGND VPWR VPWR sky130_fd_sc_hd__decap_3
X_6407_ _5950_/A _6406_/X _5538_/X _5949_/Y VGND VGND VPWR VPWR _6407_/X sky130_fd_sc_hd__o2bb2a_2
Xhold930 _9262_/Q VGND VGND VPWR VPWR hold930/X sky130_fd_sc_hd__dlygate4sd3_1
X_4599_ _4599_/A VGND VGND VPWR VPWR _9050_/D sky130_fd_sc_hd__buf_1
X_7387_ _7387_/A _7387_/B VGND VGND VPWR VPWR _7392_/A sky130_fd_sc_hd__xnor2_2
Xhold941 _4845_/X VGND VGND VPWR VPWR _4846_/A sky130_fd_sc_hd__dlygate4sd3_1
Xhold952 _9195_/Q VGND VGND VPWR VPWR hold952/X sky130_fd_sc_hd__dlygate4sd3_1
Xhold963 _8915_/X VGND VGND VPWR VPWR _8916_/A sky130_fd_sc_hd__dlygate4sd3_1
XFILLER_89_712 VGND VGND VPWR VPWR sky130_fd_sc_hd__decap_3
XFILLER_122_319 VGND VGND VPWR VPWR sky130_fd_sc_hd__decap_3
X_9126_ _9142_/CLK _9126_/D load_slew404/X VGND VGND VPWR VPWR _9126_/Q sky130_fd_sc_hd__dfrtp_2
XFILLER_115_360 VGND VGND VPWR VPWR sky130_fd_sc_hd__decap_3
XFILLER_0_104 VGND VGND VPWR VPWR sky130_fd_sc_hd__decap_3
X_6338_ _9079_/Q _5456_/B _6335_/X _6336_/X _6337_/X VGND VGND VPWR VPWR _6345_/D
+ sky130_fd_sc_hd__a2111o_2
Xhold974 _9163_/Q VGND VGND VPWR VPWR hold974/X sky130_fd_sc_hd__dlygate4sd3_1
Xhold985 _9166_/Q VGND VGND VPWR VPWR hold985/X sky130_fd_sc_hd__dlygate4sd3_1
XFILLER_1_638 VGND VGND VPWR VPWR sky130_fd_sc_hd__decap_3
Xhold996 _9013_/X VGND VGND VPWR VPWR _9014_/A sky130_fd_sc_hd__dlygate4sd3_1
XFILLER_115_393 VGND VGND VPWR VPWR sky130_fd_sc_hd__decap_3
XFILLER_103_544 VGND VGND VPWR VPWR sky130_fd_sc_hd__decap_3
XFILLER_130_330 VGND VGND VPWR VPWR sky130_fd_sc_hd__decap_3
X_6269_ _6269_/A _6269_/B VGND VGND VPWR VPWR _6269_/Y sky130_fd_sc_hd__xnor2_2
X_9057_ _9293_/CLK _9057_/D fanout377/X VGND VGND VPWR VPWR _9057_/Q sky130_fd_sc_hd__dfrtp_2
XFILLER_0_159 VGND VGND VPWR VPWR sky130_fd_sc_hd__decap_3
XFILLER_130_352 VGND VGND VPWR VPWR sky130_fd_sc_hd__decap_3
XFILLER_103_599 VGND VGND VPWR VPWR sky130_fd_sc_hd__decap_3
X_8008_ _8003_/X _8004_/X _8007_/X _8034_/A VGND VGND VPWR VPWR _8040_/A sky130_fd_sc_hd__a2bb2o_2
XFILLER_29_311 VGND VGND VPWR VPWR sky130_fd_sc_hd__decap_3
XFILLER_69_480 VGND VGND VPWR VPWR sky130_fd_sc_hd__decap_3
XFILLER_69_491 VGND VGND VPWR VPWR sky130_fd_sc_hd__decap_3
XFILLER_57_653 VGND VGND VPWR VPWR sky130_fd_sc_hd__decap_3
XFILLER_56_141 VGND VGND VPWR VPWR sky130_fd_sc_hd__decap_3
XFILLER_28_77 VGND VGND VPWR VPWR sky130_fd_sc_hd__decap_3
XFILLER_84_472 VGND VGND VPWR VPWR sky130_fd_sc_hd__decap_3
XFILLER_29_377 VGND VGND VPWR VPWR sky130_fd_sc_hd__decap_3
XFILLER_28_88 VGND VGND VPWR VPWR sky130_fd_sc_hd__fill_1
XFILLER_17_517 VGND VGND VPWR VPWR sky130_fd_sc_hd__fill_1
XFILLER_71_111 VGND VGND VPWR VPWR sky130_fd_sc_hd__fill_1
XFILLER_72_667 VGND VGND VPWR VPWR sky130_fd_sc_hd__decap_3
XFILLER_44_32 VGND VGND VPWR VPWR sky130_fd_sc_hd__decap_3
XFILLER_44_54 VGND VGND VPWR VPWR sky130_fd_sc_hd__decap_3
XFILLER_13_712 VGND VGND VPWR VPWR sky130_fd_sc_hd__decap_3
XFILLER_12_200 VGND VGND VPWR VPWR sky130_fd_sc_hd__fill_2
XFILLER_40_520 VGND VGND VPWR VPWR sky130_fd_sc_hd__fill_2
XFILLER_12_211 VGND VGND VPWR VPWR sky130_fd_sc_hd__decap_3
XFILLER_13_756 VGND VGND VPWR VPWR sky130_fd_sc_hd__decap_3
XTAP_TAPCELL_ROW_80_1359 VGND VPWR sky130_fd_sc_hd__tapvpwrvgnd_1
XFILLER_9_727 VGND VGND VPWR VPWR sky130_fd_sc_hd__fill_1
XFILLER_9_738 VGND VGND VPWR VPWR sky130_fd_sc_hd__decap_3
XTAP_TAPCELL_ROW_10_412 VGND VPWR sky130_fd_sc_hd__tapvpwrvgnd_1
XFILLER_8_248 VGND VGND VPWR VPWR sky130_fd_sc_hd__decap_3
XTAP_TAPCELL_ROW_10_423 VGND VPWR sky130_fd_sc_hd__tapvpwrvgnd_1
XFILLER_8_259 VGND VGND VPWR VPWR sky130_fd_sc_hd__decap_3
XFILLER_126_603 VGND VGND VPWR VPWR sky130_fd_sc_hd__decap_3
XFILLER_125_102 VGND VGND VPWR VPWR sky130_fd_sc_hd__decap_3
XFILLER_60_97 VGND VGND VPWR VPWR sky130_fd_sc_hd__fill_2
XFILLER_126_636 VGND VGND VPWR VPWR sky130_fd_sc_hd__decap_3
XFILLER_125_113 VGND VGND VPWR VPWR sky130_fd_sc_hd__decap_3
XFILLER_5_15 VGND VGND VPWR VPWR sky130_fd_sc_hd__decap_3
XFILLER_126_669 VGND VGND VPWR VPWR sky130_fd_sc_hd__decap_3
XFILLER_125_146 VGND VGND VPWR VPWR sky130_fd_sc_hd__decap_3
XFILLER_5_48 VGND VGND VPWR VPWR sky130_fd_sc_hd__decap_3
XFILLER_4_454 VGND VGND VPWR VPWR sky130_fd_sc_hd__decap_3
XFILLER_113_308 VGND VGND VPWR VPWR sky130_fd_sc_hd__decap_3
XFILLER_106_393 VGND VGND VPWR VPWR sky130_fd_sc_hd__decap_3
XFILLER_79_244 VGND VGND VPWR VPWR sky130_fd_sc_hd__decap_3
XFILLER_121_352 VGND VGND VPWR VPWR sky130_fd_sc_hd__decap_3
XFILLER_0_660 VGND VGND VPWR VPWR sky130_fd_sc_hd__decap_3
XFILLER_94_203 VGND VGND VPWR VPWR sky130_fd_sc_hd__fill_1
XFILLER_0_682 VGND VGND VPWR VPWR sky130_fd_sc_hd__decap_3
XFILLER_125_90 VGND VGND VPWR VPWR sky130_fd_sc_hd__decap_3
XFILLER_48_642 VGND VGND VPWR VPWR sky130_fd_sc_hd__fill_2
XPHY_EDGE_ROW_13_Right_13 VGND VGND VPWR VPWR sky130_fd_sc_hd__decap_3
XFILLER_47_141 VGND VGND VPWR VPWR sky130_fd_sc_hd__decap_3
XFILLER_63_612 VGND VGND VPWR VPWR sky130_fd_sc_hd__decap_3
XFILLER_63_623 VGND VGND VPWR VPWR sky130_fd_sc_hd__decap_3
XFILLER_48_697 VGND VGND VPWR VPWR sky130_fd_sc_hd__decap_3
XFILLER_75_494 VGND VGND VPWR VPWR sky130_fd_sc_hd__decap_3
XTAP_TAPCELL_ROW_18_523 VGND VPWR sky130_fd_sc_hd__tapvpwrvgnd_1
XFILLER_90_442 VGND VGND VPWR VPWR sky130_fd_sc_hd__decap_3
XFILLER_35_358 VGND VGND VPWR VPWR sky130_fd_sc_hd__decap_3
XFILLER_62_144 VGND VGND VPWR VPWR sky130_fd_sc_hd__decap_3
XFILLER_90_464 VGND VGND VPWR VPWR sky130_fd_sc_hd__decap_3
XFILLER_50_306 VGND VGND VPWR VPWR sky130_fd_sc_hd__fill_2
XFILLER_90_486 VGND VGND VPWR VPWR sky130_fd_sc_hd__decap_3
XTAP_TAPCELL_ROW_46_898 VGND VPWR sky130_fd_sc_hd__tapvpwrvgnd_1
XFILLER_31_542 VGND VGND VPWR VPWR sky130_fd_sc_hd__decap_3
X_5640_ _5489_/A _5489_/B _5639_/X VGND VGND VPWR VPWR _5642_/B sky130_fd_sc_hd__o21ai_2
XFILLER_86_3 VGND VGND VPWR VPWR sky130_fd_sc_hd__decap_3
XTAP_TAPCELL_ROW_98_1609 VGND VPWR sky130_fd_sc_hd__tapvpwrvgnd_1
XFILLER_31_586 VGND VGND VPWR VPWR sky130_fd_sc_hd__decap_3
X_5571_ _5479_/B _5569_/X _5570_/X VGND VGND VPWR VPWR _5571_/X sky130_fd_sc_hd__o21a_2
XPHY_EDGE_ROW_22_Right_22 VGND VGND VPWR VPWR sky130_fd_sc_hd__decap_3
XFILLER_8_760 VGND VGND VPWR VPWR sky130_fd_sc_hd__decap_3
X_4522_ _6758_/B _6757_/B VGND VGND VPWR VPWR _5029_/S sky130_fd_sc_hd__nand2_2
X_7310_ _7317_/A _7408_/A _7090_/B _7311_/A VGND VGND VPWR VPWR _7310_/X sky130_fd_sc_hd__a211o_2
X_8290_ _8461_/A1 _8441_/B _8211_/X VGND VGND VPWR VPWR _8290_/Y sky130_fd_sc_hd__o21ai_2
XFILLER_117_636 VGND VGND VPWR VPWR sky130_fd_sc_hd__decap_3
XFILLER_7_281 VGND VGND VPWR VPWR sky130_fd_sc_hd__decap_3
X_7241_ _7193_/A _7193_/B _7194_/A VGND VGND VPWR VPWR _7241_/X sky130_fd_sc_hd__a21o_2
X_7172_ _6821_/S _7532_/B1 _5803_/C VGND VGND VPWR VPWR _7173_/B sky130_fd_sc_hd__o21ai_2
XTAP_TAPCELL_ROW_55_1030 VGND VPWR sky130_fd_sc_hd__tapvpwrvgnd_1
X_6123_ _6440_/B _6123_/B VGND VGND VPWR VPWR _6124_/B sky130_fd_sc_hd__xnor2_2
XFILLER_98_586 VGND VGND VPWR VPWR sky130_fd_sc_hd__fill_2
XFILLER_100_525 VGND VGND VPWR VPWR sky130_fd_sc_hd__decap_3
X_6054_ _6057_/A _6057_/B VGND VGND VPWR VPWR _6054_/X sky130_fd_sc_hd__or2_2
XFILLER_58_439 VGND VGND VPWR VPWR sky130_fd_sc_hd__decap_3
XFILLER_100_536 VGND VGND VPWR VPWR sky130_fd_sc_hd__fill_1
XPHY_EDGE_ROW_31_Right_31 VGND VGND VPWR VPWR sky130_fd_sc_hd__decap_3
XFILLER_85_225 VGND VGND VPWR VPWR sky130_fd_sc_hd__fill_2
XFILLER_39_620 VGND VGND VPWR VPWR sky130_fd_sc_hd__decap_3
XFILLER_112_396 VGND VGND VPWR VPWR sky130_fd_sc_hd__fill_1
X_5005_ _6604_/C VGND VGND VPWR VPWR _6756_/C sky130_fd_sc_hd__buf_2
XFILLER_39_653 VGND VGND VPWR VPWR sky130_fd_sc_hd__decap_3
XFILLER_38_141 VGND VGND VPWR VPWR sky130_fd_sc_hd__fill_1
XFILLER_39_686 VGND VGND VPWR VPWR sky130_fd_sc_hd__decap_3
XFILLER_66_472 VGND VGND VPWR VPWR sky130_fd_sc_hd__decap_3
XFILLER_54_612 VGND VGND VPWR VPWR sky130_fd_sc_hd__decap_3
XTAP_TAPCELL_ROW_107_1727 VGND VPWR sky130_fd_sc_hd__tapvpwrvgnd_1
XFILLER_66_483 VGND VGND VPWR VPWR sky130_fd_sc_hd__decap_3
XFILLER_54_645 VGND VGND VPWR VPWR sky130_fd_sc_hd__decap_3
XFILLER_121_15 VGND VGND VPWR VPWR sky130_fd_sc_hd__decap_3
XFILLER_53_122 VGND VGND VPWR VPWR sky130_fd_sc_hd__decap_3
XFILLER_26_347 VGND VGND VPWR VPWR sky130_fd_sc_hd__decap_3
XFILLER_53_133 VGND VGND VPWR VPWR sky130_fd_sc_hd__decap_3
XFILLER_54_667 VGND VGND VPWR VPWR sky130_fd_sc_hd__decap_3
XFILLER_121_48 VGND VGND VPWR VPWR sky130_fd_sc_hd__decap_3
X_6956_ _6304_/A _6952_/X _6955_/X _7014_/B VGND VGND VPWR VPWR _6956_/X sky130_fd_sc_hd__o22a_2
XTAP_TAPCELL_ROW_120_1905 VGND VPWR sky130_fd_sc_hd__tapvpwrvgnd_1
XFILLER_81_486 VGND VGND VPWR VPWR sky130_fd_sc_hd__decap_3
XTAP_TAPCELL_ROW_66_1170 VGND VPWR sky130_fd_sc_hd__tapvpwrvgnd_1
XFILLER_41_328 VGND VGND VPWR VPWR sky130_fd_sc_hd__decap_3
X_5907_ _5907_/A _5907_/B _5973_/C _5907_/D VGND VGND VPWR VPWR _5908_/B sky130_fd_sc_hd__or4_4
XFILLER_34_380 VGND VGND VPWR VPWR sky130_fd_sc_hd__decap_3
X_6887_ _6887_/A _6887_/B VGND VGND VPWR VPWR _6887_/Y sky130_fd_sc_hd__nand2_2
XFILLER_14_24 VGND VGND VPWR VPWR sky130_fd_sc_hd__decap_3
XFILLER_22_553 VGND VGND VPWR VPWR sky130_fd_sc_hd__decap_3
X_8626_ _9227_/Q _8626_/B VGND VGND VPWR VPWR _8644_/A sky130_fd_sc_hd__xnor2_2
XFILLER_10_704 VGND VGND VPWR VPWR sky130_fd_sc_hd__decap_3
X_5838_ _5019_/X _5272_/X _5707_/B VGND VGND VPWR VPWR _5840_/A sky130_fd_sc_hd__a21o_2
XPHY_EDGE_ROW_40_Right_40 VGND VGND VPWR VPWR sky130_fd_sc_hd__decap_3
XFILLER_10_737 VGND VGND VPWR VPWR sky130_fd_sc_hd__decap_3
X_8557_ _9225_/Q _8557_/B VGND VGND VPWR VPWR _8557_/Y sky130_fd_sc_hd__nor2_2
X_5769_ _5768_/B _5765_/X _5912_/A VGND VGND VPWR VPWR _5770_/B sky130_fd_sc_hd__a21bo_2
XFILLER_6_719 VGND VGND VPWR VPWR sky130_fd_sc_hd__decap_3
X_7508_ _7508_/A _7508_/B VGND VGND VPWR VPWR _7508_/X sky130_fd_sc_hd__and2_2
XFILLER_107_102 VGND VGND VPWR VPWR sky130_fd_sc_hd__fill_1
XFILLER_107_113 VGND VGND VPWR VPWR sky130_fd_sc_hd__fill_2
X_8488_ _8350_/A _8421_/X _8313_/B VGND VGND VPWR VPWR _8493_/A sky130_fd_sc_hd__o21a_2
XTAP_TAPCELL_ROW_118_1878 VGND VPWR sky130_fd_sc_hd__tapvpwrvgnd_1
XPHY_EDGE_ROW_15_Left_146 VGND VGND VPWR VPWR sky130_fd_sc_hd__decap_3
XFILLER_108_669 VGND VGND VPWR VPWR sky130_fd_sc_hd__decap_3
X_7439_ _7624_/C _7624_/B _7624_/A VGND VGND VPWR VPWR _7439_/X sky130_fd_sc_hd__a21o_4
XFILLER_123_606 VGND VGND VPWR VPWR sky130_fd_sc_hd__decap_3
XFILLER_107_157 VGND VGND VPWR VPWR sky130_fd_sc_hd__fill_1
XFILLER_123_617 VGND VGND VPWR VPWR sky130_fd_sc_hd__fill_1
XFILLER_123_628 VGND VGND VPWR VPWR sky130_fd_sc_hd__fill_1
Xhold760 _8797_/X VGND VGND VPWR VPWR _8798_/A sky130_fd_sc_hd__dlygate4sd3_1
Xhold771 _8812_/X VGND VGND VPWR VPWR _8813_/A sky130_fd_sc_hd__dlygate4sd3_1
XFILLER_122_127 VGND VGND VPWR VPWR sky130_fd_sc_hd__decap_3
Xhold782 _9187_/Q VGND VGND VPWR VPWR hold782/X sky130_fd_sc_hd__dlygate4sd3_1
XFILLER_1_435 VGND VGND VPWR VPWR sky130_fd_sc_hd__decap_3
XFILLER_103_330 VGND VGND VPWR VPWR sky130_fd_sc_hd__decap_3
Xhold793 _9188_/Q VGND VGND VPWR VPWR hold793/X sky130_fd_sc_hd__dlygate4sd3_1
X_9109_ _9345_/CLK _9109_/D fanout387/X VGND VGND VPWR VPWR _9109_/Q sky130_fd_sc_hd__dfrtp_2
XFILLER_77_715 VGND VGND VPWR VPWR sky130_fd_sc_hd__decap_3
XFILLER_49_406 VGND VGND VPWR VPWR sky130_fd_sc_hd__fill_2
XFILLER_1_479 VGND VGND VPWR VPWR sky130_fd_sc_hd__decap_3
XFILLER_89_586 VGND VGND VPWR VPWR sky130_fd_sc_hd__decap_3
XFILLER_77_748 VGND VGND VPWR VPWR sky130_fd_sc_hd__decap_3
XFILLER_103_396 VGND VGND VPWR VPWR sky130_fd_sc_hd__decap_3
XFILLER_39_87 VGND VGND VPWR VPWR sky130_fd_sc_hd__decap_3
XFILLER_130_193 VGND VGND VPWR VPWR sky130_fd_sc_hd__decap_3
XFILLER_29_130 VGND VGND VPWR VPWR sky130_fd_sc_hd__decap_3
XFILLER_92_718 VGND VGND VPWR VPWR sky130_fd_sc_hd__fill_2
XFILLER_57_461 VGND VGND VPWR VPWR sky130_fd_sc_hd__decap_3
XPHY_EDGE_ROW_24_Left_155 VGND VGND VPWR VPWR sky130_fd_sc_hd__decap_3
XFILLER_45_612 VGND VGND VPWR VPWR sky130_fd_sc_hd__decap_3
XFILLER_29_163 VGND VGND VPWR VPWR sky130_fd_sc_hd__fill_2
XFILLER_55_31 VGND VGND VPWR VPWR sky130_fd_sc_hd__fill_2
XFILLER_45_623 VGND VGND VPWR VPWR sky130_fd_sc_hd__decap_3
XFILLER_45_634 VGND VGND VPWR VPWR sky130_fd_sc_hd__decap_3
XFILLER_55_42 VGND VGND VPWR VPWR sky130_fd_sc_hd__decap_3
XFILLER_72_431 VGND VGND VPWR VPWR sky130_fd_sc_hd__decap_3
XFILLER_44_144 VGND VGND VPWR VPWR sky130_fd_sc_hd__decap_3
XFILLER_60_604 VGND VGND VPWR VPWR sky130_fd_sc_hd__decap_3
XFILLER_72_464 VGND VGND VPWR VPWR sky130_fd_sc_hd__decap_3
XFILLER_72_486 VGND VGND VPWR VPWR sky130_fd_sc_hd__fill_2
XFILLER_44_177 VGND VGND VPWR VPWR sky130_fd_sc_hd__decap_3
XFILLER_60_648 VGND VGND VPWR VPWR sky130_fd_sc_hd__decap_3
XFILLER_13_520 VGND VGND VPWR VPWR sky130_fd_sc_hd__decap_3
XTAP_TAPCELL_ROW_43_857 VGND VPWR sky130_fd_sc_hd__tapvpwrvgnd_1
XFILLER_25_391 VGND VGND VPWR VPWR sky130_fd_sc_hd__fill_1
XFILLER_111_81 VGND VGND VPWR VPWR sky130_fd_sc_hd__decap_3
XTAP_TAPCELL_ROW_43_868 VGND VPWR sky130_fd_sc_hd__tapvpwrvgnd_1
XFILLER_9_502 VGND VGND VPWR VPWR sky130_fd_sc_hd__fill_2
XFILLER_71_52 VGND VGND VPWR VPWR sky130_fd_sc_hd__decap_3
XFILLER_9_546 VGND VGND VPWR VPWR sky130_fd_sc_hd__fill_1
XFILLER_71_85 VGND VGND VPWR VPWR sky130_fd_sc_hd__fill_1
XTAP_TAPCELL_ROW_23_592 VGND VPWR sky130_fd_sc_hd__tapvpwrvgnd_1
XFILLER_9_568 VGND VGND VPWR VPWR sky130_fd_sc_hd__decap_3
XPHY_EDGE_ROW_33_Left_164 VGND VGND VPWR VPWR sky130_fd_sc_hd__decap_3
XFILLER_5_741 VGND VGND VPWR VPWR sky130_fd_sc_hd__decap_3
XTAP_TAPCELL_ROW_93_1539 VGND VPWR sky130_fd_sc_hd__tapvpwrvgnd_1
XFILLER_126_477 VGND VGND VPWR VPWR sky130_fd_sc_hd__fill_2
XFILLER_4_262 VGND VGND VPWR VPWR sky130_fd_sc_hd__decap_3
XFILLER_107_691 VGND VGND VPWR VPWR sky130_fd_sc_hd__decap_3
XFILLER_122_672 VGND VGND VPWR VPWR sky130_fd_sc_hd__decap_3
XFILLER_68_737 VGND VGND VPWR VPWR sky130_fd_sc_hd__decap_3
XFILLER_95_556 VGND VGND VPWR VPWR sky130_fd_sc_hd__decap_3
XFILLER_121_193 VGND VGND VPWR VPWR sky130_fd_sc_hd__decap_3
XPHY_EDGE_ROW_42_Left_173 VGND VGND VPWR VPWR sky130_fd_sc_hd__decap_3
XFILLER_67_258 VGND VGND VPWR VPWR sky130_fd_sc_hd__fill_1
XFILLER_95_578 VGND VGND VPWR VPWR sky130_fd_sc_hd__decap_3
XFILLER_48_450 VGND VGND VPWR VPWR sky130_fd_sc_hd__decap_3
XFILLER_35_100 VGND VGND VPWR VPWR sky130_fd_sc_hd__decap_3
XFILLER_91_751 VGND VGND VPWR VPWR sky130_fd_sc_hd__fill_2
XFILLER_63_442 VGND VGND VPWR VPWR sky130_fd_sc_hd__fill_1
XFILLER_35_133 VGND VGND VPWR VPWR sky130_fd_sc_hd__fill_1
X_6810_ _6436_/Y _6805_/B _6806_/X _7181_/A _6809_/Y VGND VGND VPWR VPWR _6810_/X
+ sky130_fd_sc_hd__a221o_2
X_7790_ _7790_/A _7790_/B VGND VGND VPWR VPWR _7791_/B sky130_fd_sc_hd__xnor2_2
XFILLER_51_626 VGND VGND VPWR VPWR sky130_fd_sc_hd__decap_3
X_6741_ _6741_/A _6741_/B VGND VGND VPWR VPWR _8411_/A sky130_fd_sc_hd__nand2_2
XFILLER_50_147 VGND VGND VPWR VPWR sky130_fd_sc_hd__decap_3
XTAP_TAPCELL_ROW_102_1657 VGND VPWR sky130_fd_sc_hd__tapvpwrvgnd_1
X_6672_ _6666_/Y _6907_/A _6670_/X _6671_/Y VGND VGND VPWR VPWR _6774_/A sky130_fd_sc_hd__a211oi_2
X_8411_ _8411_/A _8411_/B VGND VGND VPWR VPWR _8411_/Y sky130_fd_sc_hd__xnor2_2
XPHY_EDGE_ROW_51_Left_182 VGND VGND VPWR VPWR sky130_fd_sc_hd__decap_3
X_5623_ _5621_/X _5622_/X _5623_/B1 VGND VGND VPWR VPWR _5626_/B sky130_fd_sc_hd__o21a_2
XFILLER_129_260 VGND VGND VPWR VPWR sky130_fd_sc_hd__decap_3
XFILLER_117_400 VGND VGND VPWR VPWR sky130_fd_sc_hd__decap_3
X_8342_ _8177_/A _8177_/B _8340_/X _8341_/Y _8222_/Y VGND VGND VPWR VPWR _8446_/B
+ sky130_fd_sc_hd__a221o_2
X_5554_ _5804_/A _5546_/B _5521_/A VGND VGND VPWR VPWR _5554_/X sky130_fd_sc_hd__a21o_2
XFILLER_117_433 VGND VGND VPWR VPWR sky130_fd_sc_hd__fill_2
X_5485_ _9202_/Q _8050_/A VGND VGND VPWR VPWR _5485_/Y sky130_fd_sc_hd__xnor2_2
X_8273_ _9220_/Q _8272_/X _8350_/B VGND VGND VPWR VPWR _8273_/Y sky130_fd_sc_hd__a21oi_2
XFILLER_117_466 VGND VGND VPWR VPWR sky130_fd_sc_hd__decap_3
XFILLER_105_617 VGND VGND VPWR VPWR sky130_fd_sc_hd__decap_3
X_7224_ _5097_/X _5228_/Y _6873_/Y _7221_/X _7223_/Y VGND VGND VPWR VPWR _7233_/A
+ sky130_fd_sc_hd__a32o_2
XFILLER_117_499 VGND VGND VPWR VPWR sky130_fd_sc_hd__decap_3
XFILLER_104_127 VGND VGND VPWR VPWR sky130_fd_sc_hd__decap_3
XFILLER_116_15 VGND VGND VPWR VPWR sky130_fd_sc_hd__decap_3
X_7155_ _7256_/A _6861_/B _7212_/A VGND VGND VPWR VPWR _7155_/X sky130_fd_sc_hd__mux2_2
XFILLER_98_361 VGND VGND VPWR VPWR sky130_fd_sc_hd__decap_3
XFILLER_59_715 VGND VGND VPWR VPWR sky130_fd_sc_hd__decap_3
XFILLER_116_59 VGND VGND VPWR VPWR sky130_fd_sc_hd__decap_3
XFILLER_58_203 VGND VGND VPWR VPWR sky130_fd_sc_hd__fill_2
X_6106_ _6470_/A _6106_/B VGND VGND VPWR VPWR _6107_/B sky130_fd_sc_hd__xnor2_2
XPHY_EDGE_ROW_60_Left_191 VGND VGND VPWR VPWR sky130_fd_sc_hd__decap_3
XFILLER_98_383 VGND VGND VPWR VPWR sky130_fd_sc_hd__fill_2
XFILLER_113_694 VGND VGND VPWR VPWR sky130_fd_sc_hd__decap_3
X_7086_ _7404_/B _7416_/B _7086_/C _7086_/D VGND VGND VPWR VPWR _7088_/A sky130_fd_sc_hd__nand4_2
XFILLER_58_236 VGND VGND VPWR VPWR sky130_fd_sc_hd__decap_3
XFILLER_74_707 VGND VGND VPWR VPWR sky130_fd_sc_hd__decap_3
XFILLER_46_409 VGND VGND VPWR VPWR sky130_fd_sc_hd__decap_3
X_6037_ _7095_/A _8405_/A _8405_/B _5855_/A VGND VGND VPWR VPWR _6038_/B sky130_fd_sc_hd__a211o_2
XFILLER_86_589 VGND VGND VPWR VPWR sky130_fd_sc_hd__decap_3
XFILLER_27_612 VGND VGND VPWR VPWR sky130_fd_sc_hd__decap_3
XFILLER_39_483 VGND VGND VPWR VPWR sky130_fd_sc_hd__decap_3
XFILLER_27_623 VGND VGND VPWR VPWR sky130_fd_sc_hd__fill_1
XFILLER_82_751 VGND VGND VPWR VPWR sky130_fd_sc_hd__decap_3
XFILLER_54_442 VGND VGND VPWR VPWR sky130_fd_sc_hd__decap_3
XFILLER_54_464 VGND VGND VPWR VPWR sky130_fd_sc_hd__decap_3
XFILLER_42_604 VGND VGND VPWR VPWR sky130_fd_sc_hd__decap_3
X_7988_ _7989_/A _7989_/B VGND VGND VPWR VPWR _7990_/A sky130_fd_sc_hd__nor2_2
XTAP_TAPCELL_ROW_1_298 VGND VPWR sky130_fd_sc_hd__tapvpwrvgnd_1
XFILLER_81_294 VGND VGND VPWR VPWR sky130_fd_sc_hd__decap_3
XFILLER_42_648 VGND VGND VPWR VPWR sky130_fd_sc_hd__decap_3
XFILLER_41_125 VGND VGND VPWR VPWR sky130_fd_sc_hd__decap_3
X_6939_ _6939_/A _6939_/B _6939_/C VGND VGND VPWR VPWR _6939_/X sky130_fd_sc_hd__or3_2
XFILLER_41_169 VGND VGND VPWR VPWR sky130_fd_sc_hd__fill_2
XTAP_TAPCELL_ROW_40_816 VGND VPWR sky130_fd_sc_hd__tapvpwrvgnd_1
XTAP_TAPCELL_ROW_40_827 VGND VPWR sky130_fd_sc_hd__tapvpwrvgnd_1
XFILLER_10_501 VGND VGND VPWR VPWR sky130_fd_sc_hd__decap_3
XFILLER_10_523 VGND VGND VPWR VPWR sky130_fd_sc_hd__decap_3
X_8609_ _8607_/Y _8608_/Y _8688_/S VGND VGND VPWR VPWR _9227_/D sky130_fd_sc_hd__mux2_4
XFILLER_41_33 VGND VGND VPWR VPWR sky130_fd_sc_hd__fill_2
XFILLER_127_208 VGND VGND VPWR VPWR sky130_fd_sc_hd__decap_3
XFILLER_108_411 VGND VGND VPWR VPWR sky130_fd_sc_hd__fill_1
XTAP_TAPCELL_ROW_20_551 VGND VPWR sky130_fd_sc_hd__tapvpwrvgnd_1
XFILLER_6_527 VGND VGND VPWR VPWR sky130_fd_sc_hd__decap_3
XTAP_TAPCELL_ROW_79_1350 VGND VPWR sky130_fd_sc_hd__tapvpwrvgnd_1
XFILLER_6_549 VGND VGND VPWR VPWR sky130_fd_sc_hd__decap_3
XFILLER_108_499 VGND VGND VPWR VPWR sky130_fd_sc_hd__decap_3
XFILLER_123_425 VGND VGND VPWR VPWR sky130_fd_sc_hd__decap_3
XFILLER_2_722 VGND VGND VPWR VPWR sky130_fd_sc_hd__decap_3
XFILLER_2_755 VGND VGND VPWR VPWR sky130_fd_sc_hd__fill_1
XFILLER_123_458 VGND VGND VPWR VPWR sky130_fd_sc_hd__decap_3
XFILLER_1_232 VGND VGND VPWR VPWR sky130_fd_sc_hd__fill_2
XFILLER_2_766 VGND VGND VPWR VPWR sky130_fd_sc_hd__decap_3
XFILLER_104_672 VGND VGND VPWR VPWR sky130_fd_sc_hd__decap_3
XTAP_TAPCELL_ROW_9_398 VGND VPWR sky130_fd_sc_hd__tapvpwrvgnd_1
XFILLER_77_512 VGND VGND VPWR VPWR sky130_fd_sc_hd__fill_1
XFILLER_2_27 VGND VGND VPWR VPWR sky130_fd_sc_hd__fill_1
XFILLER_2_38 VGND VGND VPWR VPWR sky130_fd_sc_hd__decap_3
XFILLER_103_193 VGND VGND VPWR VPWR sky130_fd_sc_hd__fill_1
XFILLER_65_707 VGND VGND VPWR VPWR sky130_fd_sc_hd__decap_3
XFILLER_64_206 VGND VGND VPWR VPWR sky130_fd_sc_hd__decap_3
XTAP_TAPCELL_ROW_48_927 VGND VPWR sky130_fd_sc_hd__tapvpwrvgnd_1
XFILLER_58_770 VGND VGND VPWR VPWR sky130_fd_sc_hd__decap_3
XFILLER_18_601 VGND VGND VPWR VPWR sky130_fd_sc_hd__decap_3
XFILLER_18_623 VGND VGND VPWR VPWR sky130_fd_sc_hd__decap_3
XFILLER_66_85 VGND VGND VPWR VPWR sky130_fd_sc_hd__decap_3
XFILLER_45_453 VGND VGND VPWR VPWR sky130_fd_sc_hd__decap_3
XFILLER_45_464 VGND VGND VPWR VPWR sky130_fd_sc_hd__decap_3
XTAP_TAPCELL_ROW_28_662 VGND VPWR sky130_fd_sc_hd__tapvpwrvgnd_1
XFILLER_18_689 VGND VGND VPWR VPWR sky130_fd_sc_hd__decap_3
XFILLER_122_80 VGND VGND VPWR VPWR sky130_fd_sc_hd__decap_3
XFILLER_45_486 VGND VGND VPWR VPWR sky130_fd_sc_hd__decap_3
XFILLER_122_91 VGND VGND VPWR VPWR sky130_fd_sc_hd__decap_3
XFILLER_72_283 VGND VGND VPWR VPWR sky130_fd_sc_hd__fill_1
XFILLER_60_467 VGND VGND VPWR VPWR sky130_fd_sc_hd__decap_3
XFILLER_20_309 VGND VGND VPWR VPWR sky130_fd_sc_hd__decap_3
XFILLER_13_372 VGND VGND VPWR VPWR sky130_fd_sc_hd__decap_3
XFILLER_9_332 VGND VGND VPWR VPWR sky130_fd_sc_hd__decap_3
XFILLER_9_365 VGND VGND VPWR VPWR sky130_fd_sc_hd__fill_2
XFILLER_9_387 VGND VGND VPWR VPWR sky130_fd_sc_hd__decap_3
XPHY_EDGE_ROW_124_Right_124 VGND VGND VPWR VPWR sky130_fd_sc_hd__decap_3
XFILLER_127_753 VGND VGND VPWR VPWR sky130_fd_sc_hd__decap_3
XFILLER_126_230 VGND VGND VPWR VPWR sky130_fd_sc_hd__decap_3
XTAP_TAPCELL_ROW_130_2031 VGND VPWR sky130_fd_sc_hd__tapvpwrvgnd_1
XFILLER_5_571 VGND VGND VPWR VPWR sky130_fd_sc_hd__decap_3
X_5270_ _8780_/A _4978_/Y _5269_/X wire172/X _9119_/Q VGND VGND VPWR VPWR _5271_/A
+ sky130_fd_sc_hd__a32o_2
XTAP_TAPCELL_ROW_130_2042 VGND VPWR sky130_fd_sc_hd__tapvpwrvgnd_1
XTAP_TAPCELL_ROW_130_2053 VGND VPWR sky130_fd_sc_hd__tapvpwrvgnd_1
XFILLER_114_436 VGND VGND VPWR VPWR sky130_fd_sc_hd__decap_3
XFILLER_99_136 VGND VGND VPWR VPWR sky130_fd_sc_hd__decap_3
XFILLER_49_3 VGND VGND VPWR VPWR sky130_fd_sc_hd__decap_3
XFILLER_68_501 VGND VGND VPWR VPWR sky130_fd_sc_hd__decap_3
XFILLER_122_480 VGND VGND VPWR VPWR sky130_fd_sc_hd__decap_3
XFILLER_68_545 VGND VGND VPWR VPWR sky130_fd_sc_hd__decap_3
XFILLER_68_556 VGND VGND VPWR VPWR sky130_fd_sc_hd__decap_3
XFILLER_110_642 VGND VGND VPWR VPWR sky130_fd_sc_hd__fill_2
X_8960_ _8960_/A VGND VGND VPWR VPWR _9321_/D sky130_fd_sc_hd__buf_1
XFILLER_56_729 VGND VGND VPWR VPWR sky130_fd_sc_hd__decap_3
XFILLER_110_675 VGND VGND VPWR VPWR sky130_fd_sc_hd__decap_3
XFILLER_49_770 VGND VGND VPWR VPWR sky130_fd_sc_hd__decap_3
XFILLER_110_697 VGND VGND VPWR VPWR sky130_fd_sc_hd__decap_3
X_7911_ _7924_/A _8566_/A VGND VGND VPWR VPWR _7911_/Y sky130_fd_sc_hd__nand2_2
XFILLER_83_548 VGND VGND VPWR VPWR sky130_fd_sc_hd__decap_3
X_8891_ _8891_/A VGND VGND VPWR VPWR _9288_/D sky130_fd_sc_hd__buf_1
XFILLER_70_209 VGND VGND VPWR VPWR sky130_fd_sc_hd__decap_3
X_7842_ _7840_/B _7913_/A _7836_/C _7841_/X _8345_/A VGND VGND VPWR VPWR _7842_/X
+ sky130_fd_sc_hd__o32a_2
XFILLER_64_773 VGND VGND VPWR VPWR sky130_fd_sc_hd__decap_3
XFILLER_91_570 VGND VGND VPWR VPWR sky130_fd_sc_hd__decap_3
XFILLER_36_475 VGND VGND VPWR VPWR sky130_fd_sc_hd__fill_1
XFILLER_23_103 VGND VGND VPWR VPWR sky130_fd_sc_hd__fill_2
XFILLER_24_648 VGND VGND VPWR VPWR sky130_fd_sc_hd__decap_3
XFILLER_63_294 VGND VGND VPWR VPWR sky130_fd_sc_hd__decap_3
XFILLER_51_434 VGND VGND VPWR VPWR sky130_fd_sc_hd__decap_3
X_7773_ _7773_/A VGND VGND VPWR VPWR _7775_/A sky130_fd_sc_hd__clkbuf_1
X_4985_ _9067_/Q _9131_/Q _5739_/S VGND VGND VPWR VPWR _4985_/X sky130_fd_sc_hd__mux2_2
XFILLER_51_467 VGND VGND VPWR VPWR sky130_fd_sc_hd__fill_2
X_6724_ _6723_/B _6723_/C _6723_/A VGND VGND VPWR VPWR _6727_/B sky130_fd_sc_hd__a21oi_2
XFILLER_23_169 VGND VGND VPWR VPWR sky130_fd_sc_hd__fill_1
XFILLER_32_681 VGND VGND VPWR VPWR sky130_fd_sc_hd__decap_3
X_6655_ _6651_/B _6652_/A _6651_/A VGND VGND VPWR VPWR _6655_/Y sky130_fd_sc_hd__a21boi_4
XFILLER_31_191 VGND VGND VPWR VPWR sky130_fd_sc_hd__decap_3
X_5606_ _5606_/A _5760_/C VGND VGND VPWR VPWR _5607_/A sky130_fd_sc_hd__xor2_2
XFILLER_118_731 VGND VGND VPWR VPWR sky130_fd_sc_hd__decap_3
X_6586_ _6585_/X _6584_/Y _7117_/A VGND VGND VPWR VPWR _6595_/B sky130_fd_sc_hd__a21oi_4
X_8325_ _8245_/A _8321_/Y _8324_/X VGND VGND VPWR VPWR _8325_/X sky130_fd_sc_hd__o21a_2
XFILLER_11_36 VGND VGND VPWR VPWR sky130_fd_sc_hd__decap_3
XFILLER_117_241 VGND VGND VPWR VPWR sky130_fd_sc_hd__decap_3
X_5537_ _6406_/B _5537_/B VGND VGND VPWR VPWR _5537_/X sky130_fd_sc_hd__and2_2
XFILLER_118_775 VGND VGND VPWR VPWR sky130_fd_sc_hd__fill_2
XFILLER_105_403 VGND VGND VPWR VPWR sky130_fd_sc_hd__decap_3
XTAP_TAPCELL_ROW_115_1837 VGND VPWR sky130_fd_sc_hd__tapvpwrvgnd_1
XFILLER_127_36 VGND VGND VPWR VPWR sky130_fd_sc_hd__decap_3
XFILLER_11_69 VGND VGND VPWR VPWR sky130_fd_sc_hd__decap_3
XFILLER_105_436 VGND VGND VPWR VPWR sky130_fd_sc_hd__decap_3
X_8256_ _8219_/B _8184_/X _8185_/A VGND VGND VPWR VPWR _8264_/A sky130_fd_sc_hd__a21o_4
X_5468_ _5463_/C _5466_/X _5467_/X _6607_/C VGND VGND VPWR VPWR _5473_/B sky130_fd_sc_hd__o211a_2
XFILLER_127_69 VGND VGND VPWR VPWR sky130_fd_sc_hd__decap_3
XFILLER_2_9 VGND VGND VPWR VPWR sky130_fd_sc_hd__decap_3
X_7207_ _7207_/A VGND VGND VPWR VPWR _7209_/A sky130_fd_sc_hd__inv_2
X_8187_ _8187_/A _8187_/B VGND VGND VPWR VPWR _8286_/S sky130_fd_sc_hd__xnor2_2
Xfanout311 _8461_/A1 VGND VGND VPWR VPWR _8045_/S sky130_fd_sc_hd__clkdlybuf4s25_1
X_5399_ _9201_/Q wire84/A _5281_/A VGND VGND VPWR VPWR _5399_/Y sky130_fd_sc_hd__a21oi_2
XTAP_TAPCELL_ROW_74_1280 VGND VPWR sky130_fd_sc_hd__tapvpwrvgnd_1
XFILLER_59_523 VGND VGND VPWR VPWR sky130_fd_sc_hd__decap_3
XFILLER_120_439 VGND VGND VPWR VPWR sky130_fd_sc_hd__decap_3
XFILLER_101_620 VGND VGND VPWR VPWR sky130_fd_sc_hd__decap_3
X_7138_ _7279_/A _7278_/B VGND VGND VPWR VPWR _7285_/B sky130_fd_sc_hd__nand2_2
Xfanout344 _6116_/B VGND VGND VPWR VPWR _6416_/B sky130_fd_sc_hd__buf_2
Xfanout355 hold751/X VGND VGND VPWR VPWR _5793_/S sky130_fd_sc_hd__clkbuf_2
XTAP_TAPCELL_ROW_6_357 VGND VPWR sky130_fd_sc_hd__tapvpwrvgnd_1
XTAP_TAPCELL_ROW_6_368 VGND VPWR sky130_fd_sc_hd__tapvpwrvgnd_1
XFILLER_59_567 VGND VGND VPWR VPWR sky130_fd_sc_hd__decap_3
Xfanout377 fanout379/A VGND VGND VPWR VPWR fanout377/X sky130_fd_sc_hd__clkdlybuf4s25_1
XFILLER_86_353 VGND VGND VPWR VPWR sky130_fd_sc_hd__decap_3
XFILLER_19_409 VGND VGND VPWR VPWR sky130_fd_sc_hd__fill_1
XFILLER_100_141 VGND VGND VPWR VPWR sky130_fd_sc_hd__decap_3
X_7069_ _7069_/A _7069_/B VGND VGND VPWR VPWR _7069_/Y sky130_fd_sc_hd__xnor2_2
XFILLER_47_729 VGND VGND VPWR VPWR sky130_fd_sc_hd__fill_1
XFILLER_86_386 VGND VGND VPWR VPWR sky130_fd_sc_hd__fill_2
XFILLER_36_11 VGND VGND VPWR VPWR sky130_fd_sc_hd__fill_2
XFILLER_36_44 VGND VGND VPWR VPWR sky130_fd_sc_hd__decap_3
XFILLER_55_762 VGND VGND VPWR VPWR sky130_fd_sc_hd__fill_1
XFILLER_61_209 VGND VGND VPWR VPWR sky130_fd_sc_hd__decap_3
XTAP_TAPCELL_ROW_126_1977 VGND VPWR sky130_fd_sc_hd__tapvpwrvgnd_1
XTAP_TAPCELL_ROW_126_1988 VGND VPWR sky130_fd_sc_hd__tapvpwrvgnd_1
XFILLER_42_401 VGND VGND VPWR VPWR sky130_fd_sc_hd__decap_3
XFILLER_36_77 VGND VGND VPWR VPWR sky130_fd_sc_hd__decap_3
XFILLER_15_626 VGND VGND VPWR VPWR sky130_fd_sc_hd__decap_3
XFILLER_82_581 VGND VGND VPWR VPWR sky130_fd_sc_hd__decap_3
XFILLER_36_88 VGND VGND VPWR VPWR sky130_fd_sc_hd__decap_3
XTAP_TAPCELL_ROW_25_621 VGND VPWR sky130_fd_sc_hd__tapvpwrvgnd_1
XFILLER_70_743 VGND VGND VPWR VPWR sky130_fd_sc_hd__decap_3
XFILLER_54_294 VGND VGND VPWR VPWR sky130_fd_sc_hd__decap_3
XFILLER_42_434 VGND VGND VPWR VPWR sky130_fd_sc_hd__decap_3
XFILLER_14_136 VGND VGND VPWR VPWR sky130_fd_sc_hd__decap_3
XFILLER_14_147 VGND VGND VPWR VPWR sky130_fd_sc_hd__decap_3
XFILLER_52_21 VGND VGND VPWR VPWR sky130_fd_sc_hd__decap_3
XFILLER_42_467 VGND VGND VPWR VPWR sky130_fd_sc_hd__decap_3
XFILLER_52_32 VGND VGND VPWR VPWR sky130_fd_sc_hd__fill_2
XFILLER_30_629 VGND VGND VPWR VPWR sky130_fd_sc_hd__decap_3
XTAP_TAPCELL_ROW_53_996 VGND VPWR sky130_fd_sc_hd__tapvpwrvgnd_1
XFILLER_52_76 VGND VGND VPWR VPWR sky130_fd_sc_hd__decap_3
XFILLER_109_720 VGND VGND VPWR VPWR sky130_fd_sc_hd__decap_3
XFILLER_10_375 VGND VGND VPWR VPWR sky130_fd_sc_hd__decap_3
XFILLER_10_386 VGND VGND VPWR VPWR sky130_fd_sc_hd__decap_3
XFILLER_124_701 VGND VGND VPWR VPWR sky130_fd_sc_hd__decap_3
XFILLER_124_734 VGND VGND VPWR VPWR sky130_fd_sc_hd__decap_3
XFILLER_123_211 VGND VGND VPWR VPWR sky130_fd_sc_hd__decap_3
XFILLER_2_530 VGND VGND VPWR VPWR sky130_fd_sc_hd__fill_2
XFILLER_96_106 VGND VGND VPWR VPWR sky130_fd_sc_hd__fill_2
XFILLER_111_428 VGND VGND VPWR VPWR sky130_fd_sc_hd__fill_1
XFILLER_38_707 VGND VGND VPWR VPWR sky130_fd_sc_hd__decap_3
XFILLER_37_206 VGND VGND VPWR VPWR sky130_fd_sc_hd__decap_3
XFILLER_18_431 VGND VGND VPWR VPWR sky130_fd_sc_hd__decap_3
XFILLER_80_529 VGND VGND VPWR VPWR sky130_fd_sc_hd__decap_3
XFILLER_73_570 VGND VGND VPWR VPWR sky130_fd_sc_hd__decap_3
XFILLER_73_581 VGND VGND VPWR VPWR sky130_fd_sc_hd__decap_3
XFILLER_61_732 VGND VGND VPWR VPWR sky130_fd_sc_hd__decap_3
XFILLER_33_434 VGND VGND VPWR VPWR sky130_fd_sc_hd__decap_3
XFILLER_45_294 VGND VGND VPWR VPWR sky130_fd_sc_hd__decap_3
XFILLER_60_231 VGND VGND VPWR VPWR sky130_fd_sc_hd__fill_1
XFILLER_61_776 VGND VGND VPWR VPWR sky130_fd_sc_hd__fill_1
XFILLER_60_253 VGND VGND VPWR VPWR sky130_fd_sc_hd__decap_3
X_4770_ _4770_/A VGND VGND VPWR VPWR _9131_/D sky130_fd_sc_hd__buf_1
XFILLER_20_117 VGND VGND VPWR VPWR sky130_fd_sc_hd__decap_3
XFILLER_14_692 VGND VGND VPWR VPWR sky130_fd_sc_hd__decap_3
XFILLER_13_180 VGND VGND VPWR VPWR sky130_fd_sc_hd__decap_3
XFILLER_119_539 VGND VGND VPWR VPWR sky130_fd_sc_hd__decap_3
X_6440_ _6440_/A _6440_/B _6123_/B VGND VGND VPWR VPWR _6440_/X sky130_fd_sc_hd__or3b_2
XFILLER_9_195 VGND VGND VPWR VPWR sky130_fd_sc_hd__decap_3
X_6371_ _6369_/A _6369_/B _6370_/A VGND VGND VPWR VPWR _6371_/Y sky130_fd_sc_hd__a21oi_2
XFILLER_127_561 VGND VGND VPWR VPWR sky130_fd_sc_hd__fill_1
X_8110_ _8111_/A _8111_/B _7984_/B VGND VGND VPWR VPWR _8112_/B sky130_fd_sc_hd__o21a_2
XFILLER_127_583 VGND VGND VPWR VPWR sky130_fd_sc_hd__decap_3
X_5322_ _4970_/X _5320_/Y _5328_/B VGND VGND VPWR VPWR _5322_/X sky130_fd_sc_hd__o21ba_2
X_9090_ _9341_/CLK _9090_/D fanout379/A VGND VGND VPWR VPWR _9090_/Q sky130_fd_sc_hd__dfrtp_2
XFILLER_5_390 VGND VGND VPWR VPWR sky130_fd_sc_hd__fill_2
X_8041_ _7895_/A _7894_/A _7894_/B VGND VGND VPWR VPWR _8041_/X sky130_fd_sc_hd__a21o_2
XFILLER_130_704 VGND VGND VPWR VPWR sky130_fd_sc_hd__decap_3
X_5253_ _5247_/X _5407_/A _5252_/X VGND VGND VPWR VPWR _5253_/Y sky130_fd_sc_hd__a21boi_2
XFILLER_102_417 VGND VGND VPWR VPWR sky130_fd_sc_hd__decap_3
XFILLER_114_277 VGND VGND VPWR VPWR sky130_fd_sc_hd__decap_3
XFILLER_87_128 VGND VGND VPWR VPWR sky130_fd_sc_hd__decap_3
X_5184_ _9290_/Q _9086_/Q _5266_/S VGND VGND VPWR VPWR _5185_/C sky130_fd_sc_hd__mux2_2
XTAP_TAPCELL_ROW_110_1767 VGND VPWR sky130_fd_sc_hd__tapvpwrvgnd_1
XFILLER_96_651 VGND VGND VPWR VPWR sky130_fd_sc_hd__decap_3
XTAP_TAPCELL_ROW_3_316 VGND VPWR sky130_fd_sc_hd__tapvpwrvgnd_1
XFILLER_3_81 VGND VGND VPWR VPWR sky130_fd_sc_hd__decap_3
XFILLER_29_718 VGND VGND VPWR VPWR sky130_fd_sc_hd__decap_3
XTAP_TAPCELL_ROW_3_327 VGND VPWR sky130_fd_sc_hd__tapvpwrvgnd_1
XFILLER_29_729 VGND VGND VPWR VPWR sky130_fd_sc_hd__decap_3
XFILLER_68_375 VGND VGND VPWR VPWR sky130_fd_sc_hd__fill_1
XFILLER_56_515 VGND VGND VPWR VPWR sky130_fd_sc_hd__decap_3
XFILLER_110_461 VGND VGND VPWR VPWR sky130_fd_sc_hd__decap_3
XFILLER_83_323 VGND VGND VPWR VPWR sky130_fd_sc_hd__decap_3
XFILLER_95_183 VGND VGND VPWR VPWR sky130_fd_sc_hd__fill_2
XFILLER_28_239 VGND VGND VPWR VPWR sky130_fd_sc_hd__decap_3
XFILLER_113_27 VGND VGND VPWR VPWR sky130_fd_sc_hd__decap_3
X_8943_ _8943_/A VGND VGND VPWR VPWR _9313_/D sky130_fd_sc_hd__buf_1
XFILLER_95_194 VGND VGND VPWR VPWR sky130_fd_sc_hd__fill_2
XFILLER_36_250 VGND VGND VPWR VPWR sky130_fd_sc_hd__fill_2
X_8874_ _8874_/A VGND VGND VPWR VPWR _9280_/D sky130_fd_sc_hd__buf_1
Xwire43 wire44/X VGND VGND VPWR VPWR wire43/X sky130_fd_sc_hd__clkdlybuf4s25_1
XFILLER_83_389 VGND VGND VPWR VPWR sky130_fd_sc_hd__decap_3
XFILLER_24_412 VGND VGND VPWR VPWR sky130_fd_sc_hd__fill_1
XFILLER_64_592 VGND VGND VPWR VPWR sky130_fd_sc_hd__decap_3
X_7825_ _7825_/A _7825_/B VGND VGND VPWR VPWR _7826_/B sky130_fd_sc_hd__xor2_2
Xwire76 wire76/A VGND VGND VPWR VPWR wire76/X sky130_fd_sc_hd__buf_2
XFILLER_12_618 VGND VGND VPWR VPWR sky130_fd_sc_hd__decap_3
X_7756_ _7620_/A _7754_/Y _7755_/X VGND VGND VPWR VPWR _7812_/A sky130_fd_sc_hd__o21ai_2
XFILLER_12_629 VGND VGND VPWR VPWR sky130_fd_sc_hd__decap_3
X_4968_ _5530_/S _5044_/B _4968_/S VGND VGND VPWR VPWR _4968_/X sky130_fd_sc_hd__mux2_2
X_6707_ _6707_/A _7099_/B VGND VGND VPWR VPWR _6736_/C sky130_fd_sc_hd__xnor2_4
XTAP_TAPCELL_ROW_50_955 VGND VPWR sky130_fd_sc_hd__tapvpwrvgnd_1
X_7687_ _7711_/B _7893_/C VGND VGND VPWR VPWR _7688_/B sky130_fd_sc_hd__xor2_2
X_4899_ _9221_/Q _4899_/B VGND VGND VPWR VPWR _4899_/Y sky130_fd_sc_hd__nor2_2
XFILLER_22_24 VGND VGND VPWR VPWR sky130_fd_sc_hd__decap_3
XFILLER_20_651 VGND VGND VPWR VPWR sky130_fd_sc_hd__decap_3
XFILLER_22_46 VGND VGND VPWR VPWR sky130_fd_sc_hd__decap_3
X_6638_ _6643_/B _6644_/S VGND VGND VPWR VPWR _6640_/B sky130_fd_sc_hd__and2_2
XFILLER_22_79 VGND VGND VPWR VPWR sky130_fd_sc_hd__decap_3
XTAP_TAPCELL_ROW_30_690 VGND VPWR sky130_fd_sc_hd__tapvpwrvgnd_1
XFILLER_118_550 VGND VGND VPWR VPWR sky130_fd_sc_hd__fill_1
XFILLER_106_701 VGND VGND VPWR VPWR sky130_fd_sc_hd__decap_3
XFILLER_118_6 VGND VGND VPWR VPWR sky130_fd_sc_hd__decap_3
XFILLER_106_712 VGND VGND VPWR VPWR sky130_fd_sc_hd__decap_3
X_8308_ _8327_/S VGND VGND VPWR VPWR _8416_/A sky130_fd_sc_hd__clkbuf_1
XFILLER_3_327 VGND VGND VPWR VPWR sky130_fd_sc_hd__decap_3
X_9288_ clkload5/A _9288_/D fanout373/X VGND VGND VPWR VPWR _9288_/Q sky130_fd_sc_hd__dfrtp_2
XFILLER_3_349 VGND VGND VPWR VPWR sky130_fd_sc_hd__decap_3
XFILLER_0_6 VGND VGND VPWR VPWR sky130_fd_sc_hd__decap_3
X_8239_ _8239_/A _8239_/B _8239_/C VGND VGND VPWR VPWR _8245_/A sky130_fd_sc_hd__or3_4
XFILLER_79_629 VGND VGND VPWR VPWR sky130_fd_sc_hd__decap_3
XFILLER_105_299 VGND VGND VPWR VPWR sky130_fd_sc_hd__decap_3
XFILLER_121_759 VGND VGND VPWR VPWR sky130_fd_sc_hd__decap_3
XFILLER_120_236 VGND VGND VPWR VPWR sky130_fd_sc_hd__decap_3
XFILLER_93_109 VGND VGND VPWR VPWR sky130_fd_sc_hd__decap_3
XFILLER_59_375 VGND VGND VPWR VPWR sky130_fd_sc_hd__fill_2
XFILLER_47_32 VGND VGND VPWR VPWR sky130_fd_sc_hd__decap_3
XFILLER_74_312 VGND VGND VPWR VPWR sky130_fd_sc_hd__fill_1
XFILLER_86_183 VGND VGND VPWR VPWR sky130_fd_sc_hd__decap_3
XFILLER_74_334 VGND VGND VPWR VPWR sky130_fd_sc_hd__fill_2
XFILLER_74_345 VGND VGND VPWR VPWR sky130_fd_sc_hd__decap_3
XTAP_TAPCELL_ROW_87_1460 VGND VPWR sky130_fd_sc_hd__tapvpwrvgnd_1
XFILLER_103_60 VGND VGND VPWR VPWR sky130_fd_sc_hd__decap_3
XFILLER_55_570 VGND VGND VPWR VPWR sky130_fd_sc_hd__decap_3
XTAP_TAPCELL_ROW_38_790 VGND VPWR sky130_fd_sc_hd__tapvpwrvgnd_1
XFILLER_27_294 VGND VGND VPWR VPWR sky130_fd_sc_hd__decap_3
XPHY_EDGE_ROW_69_Right_69 VGND VGND VPWR VPWR sky130_fd_sc_hd__decap_3
XFILLER_42_242 VGND VGND VPWR VPWR sky130_fd_sc_hd__fill_1
XFILLER_43_776 VGND VGND VPWR VPWR sky130_fd_sc_hd__fill_1
XFILLER_63_75 VGND VGND VPWR VPWR sky130_fd_sc_hd__decap_3
XFILLER_30_415 VGND VGND VPWR VPWR sky130_fd_sc_hd__decap_3
XFILLER_42_286 VGND VGND VPWR VPWR sky130_fd_sc_hd__fill_2
XFILLER_8_15 VGND VGND VPWR VPWR sky130_fd_sc_hd__decap_3
XFILLER_42_297 VGND VGND VPWR VPWR sky130_fd_sc_hd__decap_3
XFILLER_30_437 VGND VGND VPWR VPWR sky130_fd_sc_hd__decap_3
XFILLER_128_303 VGND VGND VPWR VPWR sky130_fd_sc_hd__decap_3
XPHY_EDGE_ROW_7_Left_138 VGND VGND VPWR VPWR sky130_fd_sc_hd__decap_3
XFILLER_8_59 VGND VGND VPWR VPWR sky130_fd_sc_hd__decap_3
XFILLER_11_673 VGND VGND VPWR VPWR sky130_fd_sc_hd__decap_3
XFILLER_11_684 VGND VGND VPWR VPWR sky130_fd_sc_hd__decap_3
XFILLER_124_520 VGND VGND VPWR VPWR sky130_fd_sc_hd__decap_3
XPHY_EDGE_ROW_78_Right_78 VGND VGND VPWR VPWR sky130_fd_sc_hd__decap_3
XFILLER_88_72 VGND VGND VPWR VPWR sky130_fd_sc_hd__decap_3
XFILLER_124_597 VGND VGND VPWR VPWR sky130_fd_sc_hd__decap_3
XFILLER_2_371 VGND VGND VPWR VPWR sky130_fd_sc_hd__decap_3
XFILLER_78_651 VGND VGND VPWR VPWR sky130_fd_sc_hd__fill_2
XFILLER_78_662 VGND VGND VPWR VPWR sky130_fd_sc_hd__decap_3
XFILLER_38_526 VGND VGND VPWR VPWR sky130_fd_sc_hd__decap_3
XFILLER_93_676 VGND VGND VPWR VPWR sky130_fd_sc_hd__decap_3
XFILLER_19_762 VGND VGND VPWR VPWR sky130_fd_sc_hd__decap_3
XFILLER_80_304 VGND VGND VPWR VPWR sky130_fd_sc_hd__decap_3
X_5940_ _5940_/A1 _6826_/A1 _5936_/Y _5939_/X _6084_/A VGND VGND VPWR VPWR _6134_/B
+ sky130_fd_sc_hd__a32o_2
XFILLER_53_529 VGND VGND VPWR VPWR sky130_fd_sc_hd__fill_2
XFILLER_80_315 VGND VGND VPWR VPWR sky130_fd_sc_hd__decap_3
XFILLER_34_710 VGND VGND VPWR VPWR sky130_fd_sc_hd__decap_3
XPHY_EDGE_ROW_87_Right_87 VGND VGND VPWR VPWR sky130_fd_sc_hd__decap_3
XFILLER_92_197 VGND VGND VPWR VPWR sky130_fd_sc_hd__decap_3
X_5871_ _5729_/A _5729_/B _5749_/B _5870_/X VGND VGND VPWR VPWR _5872_/C sky130_fd_sc_hd__a31o_2
XFILLER_34_754 VGND VGND VPWR VPWR sky130_fd_sc_hd__fill_2
XFILLER_33_231 VGND VGND VPWR VPWR sky130_fd_sc_hd__fill_2
X_7610_ _7773_/A _8312_/A VGND VGND VPWR VPWR _7614_/A sky130_fd_sc_hd__nand2_2
X_4822_ _4822_/A0 _9140_/Q _4840_/S VGND VGND VPWR VPWR _4822_/X sky130_fd_sc_hd__mux2_2
X_8590_ _9226_/Q wire61/X _8695_/B VGND VGND VPWR VPWR _8590_/X sky130_fd_sc_hd__or3_2
XFILLER_61_595 VGND VGND VPWR VPWR sky130_fd_sc_hd__fill_2
XTAP_TAPCELL_ROW_16_495 VGND VPWR sky130_fd_sc_hd__tapvpwrvgnd_1
X_7541_ _7881_/C _7715_/B _7540_/X VGND VGND VPWR VPWR _7543_/B sky130_fd_sc_hd__o21a_2
X_4753_ _4753_/A VGND VGND VPWR VPWR _9123_/D sky130_fd_sc_hd__buf_1
X_7472_ _7472_/A _8780_/C VGND VGND VPWR VPWR _7472_/Y sky130_fd_sc_hd__nand2_2
X_4684_ _4684_/A VGND VGND VPWR VPWR _9090_/D sky130_fd_sc_hd__buf_1
X_9211_ _9215_/CLK _9211_/D fanout418/X VGND VGND VPWR VPWR _9211_/Q sky130_fd_sc_hd__dfrtp_2
X_6423_ _6423_/A _6423_/B VGND VGND VPWR VPWR _6443_/A sky130_fd_sc_hd__xnor2_2
XPHY_EDGE_ROW_96_Right_96 VGND VGND VPWR VPWR sky130_fd_sc_hd__decap_3
XFILLER_108_27 VGND VGND VPWR VPWR sky130_fd_sc_hd__fill_1
X_9142_ _9142_/CLK _9142_/D wire406/X VGND VGND VPWR VPWR _9142_/Q sky130_fd_sc_hd__dfrtp_2
XFILLER_108_38 VGND VGND VPWR VPWR sky130_fd_sc_hd__decap_3
X_6354_ _6354_/A _6354_/B VGND VGND VPWR VPWR _7422_/B sky130_fd_sc_hd__and2_2
XFILLER_127_391 VGND VGND VPWR VPWR sky130_fd_sc_hd__fill_1
XFILLER_115_531 VGND VGND VPWR VPWR sky130_fd_sc_hd__decap_3
XTAP_TAPCELL_ROW_58_1061 VGND VPWR sky130_fd_sc_hd__tapvpwrvgnd_1
X_5305_ _5305_/A _5305_/B VGND VGND VPWR VPWR _5493_/B sky130_fd_sc_hd__nor2_2
X_9073_ _9293_/CLK _9073_/D fanout381/X VGND VGND VPWR VPWR _9073_/Q sky130_fd_sc_hd__dfrtp_2
XFILLER_130_501 VGND VGND VPWR VPWR sky130_fd_sc_hd__decap_3
XFILLER_0_319 VGND VGND VPWR VPWR sky130_fd_sc_hd__decap_3
X_6285_ _6285_/A _6285_/B VGND VGND VPWR VPWR _6286_/B sky130_fd_sc_hd__xnor2_2
XFILLER_115_586 VGND VGND VPWR VPWR sky130_fd_sc_hd__decap_3
XFILLER_88_426 VGND VGND VPWR VPWR sky130_fd_sc_hd__fill_2
XFILLER_130_523 VGND VGND VPWR VPWR sky130_fd_sc_hd__fill_1
X_8024_ _7889_/A _8010_/A _8022_/X VGND VGND VPWR VPWR _8024_/Y sky130_fd_sc_hd__a21oi_2
X_5236_ _5216_/B _5236_/B VGND VGND VPWR VPWR _5312_/A sky130_fd_sc_hd__and2b_2
XFILLER_130_545 VGND VGND VPWR VPWR sky130_fd_sc_hd__decap_3
XFILLER_124_15 VGND VGND VPWR VPWR sky130_fd_sc_hd__decap_3
XFILLER_130_567 VGND VGND VPWR VPWR sky130_fd_sc_hd__decap_3
XFILLER_130_589 VGND VGND VPWR VPWR sky130_fd_sc_hd__decap_3
X_5167_ _9198_/Q _5167_/B VGND VGND VPWR VPWR _5167_/Y sky130_fd_sc_hd__nand2_2
XFILLER_124_59 VGND VGND VPWR VPWR sky130_fd_sc_hd__decap_3
XFILLER_56_312 VGND VGND VPWR VPWR sky130_fd_sc_hd__fill_1
XFILLER_29_526 VGND VGND VPWR VPWR sky130_fd_sc_hd__decap_3
XFILLER_68_194 VGND VGND VPWR VPWR sky130_fd_sc_hd__fill_2
XFILLER_29_559 VGND VGND VPWR VPWR sky130_fd_sc_hd__fill_1
X_5098_ _5033_/A _5095_/X _7528_/B2 VGND VGND VPWR VPWR _5098_/X sky130_fd_sc_hd__a21o_2
XFILLER_56_356 VGND VGND VPWR VPWR sky130_fd_sc_hd__decap_3
XFILLER_17_24 VGND VGND VPWR VPWR sky130_fd_sc_hd__decap_3
XFILLER_44_518 VGND VGND VPWR VPWR sky130_fd_sc_hd__decap_3
X_8926_ _8926_/A VGND VGND VPWR VPWR _9305_/D sky130_fd_sc_hd__buf_1
XFILLER_84_698 VGND VGND VPWR VPWR sky130_fd_sc_hd__fill_2
XFILLER_37_570 VGND VGND VPWR VPWR sky130_fd_sc_hd__decap_3
XFILLER_25_710 VGND VGND VPWR VPWR sky130_fd_sc_hd__decap_3
XTAP_TAPCELL_ROW_123_1936 VGND VPWR sky130_fd_sc_hd__tapvpwrvgnd_1
XFILLER_37_592 VGND VGND VPWR VPWR sky130_fd_sc_hd__decap_3
XTAP_TAPCELL_ROW_123_1947 VGND VPWR sky130_fd_sc_hd__tapvpwrvgnd_1
X_8857_ _8857_/A VGND VGND VPWR VPWR _9272_/D sky130_fd_sc_hd__buf_1
XFILLER_25_765 VGND VGND VPWR VPWR sky130_fd_sc_hd__decap_3
XFILLER_24_253 VGND VGND VPWR VPWR sky130_fd_sc_hd__decap_3
X_7808_ _7440_/X _7801_/X _7807_/X VGND VGND VPWR VPWR _7809_/B sky130_fd_sc_hd__a21o_2
XTAP_TAPCELL_ROW_35_760 VGND VPWR sky130_fd_sc_hd__tapvpwrvgnd_1
X_8788_ _8788_/A VGND VGND VPWR VPWR _9239_/D sky130_fd_sc_hd__buf_1
XFILLER_12_437 VGND VGND VPWR VPWR sky130_fd_sc_hd__fill_2
XFILLER_24_297 VGND VGND VPWR VPWR sky130_fd_sc_hd__decap_3
XTAP_TAPCELL_ROW_82_1390 VGND VPWR sky130_fd_sc_hd__tapvpwrvgnd_1
XFILLER_40_757 VGND VGND VPWR VPWR sky130_fd_sc_hd__fill_2
X_7739_ _7739_/A _7739_/B VGND VGND VPWR VPWR _7740_/B sky130_fd_sc_hd__xnor2_2
XFILLER_125_306 VGND VGND VPWR VPWR sky130_fd_sc_hd__fill_2
XFILLER_116_3 VGND VGND VPWR VPWR sky130_fd_sc_hd__decap_3
XFILLER_3_102 VGND VGND VPWR VPWR sky130_fd_sc_hd__decap_3
XFILLER_3_113 VGND VGND VPWR VPWR sky130_fd_sc_hd__decap_3
XFILLER_118_380 VGND VGND VPWR VPWR sky130_fd_sc_hd__decap_3
XFILLER_106_542 VGND VGND VPWR VPWR sky130_fd_sc_hd__decap_3
XFILLER_4_658 VGND VGND VPWR VPWR sky130_fd_sc_hd__decap_3
XFILLER_106_575 VGND VGND VPWR VPWR sky130_fd_sc_hd__decap_3
XFILLER_121_567 VGND VGND VPWR VPWR sky130_fd_sc_hd__fill_2
XFILLER_59_161 VGND VGND VPWR VPWR sky130_fd_sc_hd__decap_3
XFILLER_47_334 VGND VGND VPWR VPWR sky130_fd_sc_hd__fill_2
XFILLER_75_676 VGND VGND VPWR VPWR sky130_fd_sc_hd__fill_1
XFILLER_74_153 VGND VGND VPWR VPWR sky130_fd_sc_hd__decap_3
XFILLER_47_378 VGND VGND VPWR VPWR sky130_fd_sc_hd__decap_3
XFILLER_62_315 VGND VGND VPWR VPWR sky130_fd_sc_hd__decap_3
XFILLER_16_710 VGND VGND VPWR VPWR sky130_fd_sc_hd__decap_3
XFILLER_28_570 VGND VGND VPWR VPWR sky130_fd_sc_hd__decap_3
XFILLER_28_592 VGND VGND VPWR VPWR sky130_fd_sc_hd__decap_3
XFILLER_90_657 VGND VGND VPWR VPWR sky130_fd_sc_hd__fill_1
XFILLER_74_85 VGND VGND VPWR VPWR sky130_fd_sc_hd__fill_1
XFILLER_16_743 VGND VGND VPWR VPWR sky130_fd_sc_hd__decap_3
XFILLER_31_713 VGND VGND VPWR VPWR sky130_fd_sc_hd__fill_1
XFILLER_15_264 VGND VGND VPWR VPWR sky130_fd_sc_hd__decap_3
XFILLER_31_735 VGND VGND VPWR VPWR sky130_fd_sc_hd__decap_3
XFILLER_15_297 VGND VGND VPWR VPWR sky130_fd_sc_hd__decap_3
XFILLER_130_91 VGND VGND VPWR VPWR sky130_fd_sc_hd__decap_3
XFILLER_30_245 VGND VGND VPWR VPWR sky130_fd_sc_hd__decap_3
XFILLER_129_612 VGND VGND VPWR VPWR sky130_fd_sc_hd__decap_3
XTAP_TAPCELL_ROW_13_454 VGND VPWR sky130_fd_sc_hd__tapvpwrvgnd_1
XFILLER_129_623 VGND VGND VPWR VPWR sky130_fd_sc_hd__decap_3
XFILLER_128_100 VGND VGND VPWR VPWR sky130_fd_sc_hd__decap_3
XFILLER_30_289 VGND VGND VPWR VPWR sky130_fd_sc_hd__decap_3
XFILLER_129_656 VGND VGND VPWR VPWR sky130_fd_sc_hd__decap_3
XFILLER_128_133 VGND VGND VPWR VPWR sky130_fd_sc_hd__decap_3
XFILLER_128_144 VGND VGND VPWR VPWR sky130_fd_sc_hd__decap_3
XFILLER_116_306 VGND VGND VPWR VPWR sky130_fd_sc_hd__fill_2
Xwire372 wire372/A VGND VGND VPWR VPWR wire372/X sky130_fd_sc_hd__clkbuf_4
Xmax_cap105 _8812_/S VGND VGND VPWR VPWR _8820_/S sky130_fd_sc_hd__buf_2
XFILLER_128_177 VGND VGND VPWR VPWR sky130_fd_sc_hd__decap_3
XFILLER_7_485 VGND VGND VPWR VPWR sky130_fd_sc_hd__fill_1
Xmax_cap127 _6992_/A VGND VGND VPWR VPWR _5707_/B sky130_fd_sc_hd__buf_2
XFILLER_99_60 VGND VGND VPWR VPWR sky130_fd_sc_hd__fill_2
Xmax_cap138 _4631_/A VGND VGND VPWR VPWR _9015_/S sky130_fd_sc_hd__buf_2
Xmax_cap149 _5844_/X VGND VGND VPWR VPWR _8070_/A sky130_fd_sc_hd__buf_2
XFILLER_98_713 VGND VGND VPWR VPWR sky130_fd_sc_hd__decap_3
XFILLER_124_361 VGND VGND VPWR VPWR sky130_fd_sc_hd__decap_3
Xload_slew300 _6431_/A VGND VGND VPWR VPWR _7728_/A sky130_fd_sc_hd__clkbuf_4
XFILLER_98_757 VGND VGND VPWR VPWR sky130_fd_sc_hd__fill_2
XFILLER_3_691 VGND VGND VPWR VPWR sky130_fd_sc_hd__decap_3
XFILLER_31_3 VGND VGND VPWR VPWR sky130_fd_sc_hd__decap_3
X_6070_ _6070_/A _6070_/B VGND VGND VPWR VPWR _6071_/B sky130_fd_sc_hd__nand2_2
Xload_slew333 _7871_/A VGND VGND VPWR VPWR _6873_/A sky130_fd_sc_hd__buf_6
XFILLER_112_545 VGND VGND VPWR VPWR sky130_fd_sc_hd__decap_3
X_5021_ _5021_/A VGND VGND VPWR VPWR _6705_/D sky130_fd_sc_hd__clkbuf_2
Xload_slew366 hold749/X VGND VGND VPWR VPWR fanout360/A sky130_fd_sc_hd__buf_6
Xhold1108 _9156_/Q VGND VGND VPWR VPWR _4822_/A0 sky130_fd_sc_hd__dlygate4sd3_1
XFILLER_57_109 VGND VGND VPWR VPWR sky130_fd_sc_hd__decap_3
Xhold1119 _9278_/Q VGND VGND VPWR VPWR _8902_/A1 sky130_fd_sc_hd__dlygate4sd3_1
XFILLER_112_589 VGND VGND VPWR VPWR sky130_fd_sc_hd__decap_3
Xload_slew388 fanout387/X VGND VGND VPWR VPWR load_slew388/X sky130_fd_sc_hd__buf_4
XFILLER_66_621 VGND VGND VPWR VPWR sky130_fd_sc_hd__decap_3
Xload_slew399 fanout398/X VGND VGND VPWR VPWR load_slew399/X sky130_fd_sc_hd__clkbuf_4
XFILLER_66_654 VGND VGND VPWR VPWR sky130_fd_sc_hd__decap_3
XFILLER_66_676 VGND VGND VPWR VPWR sky130_fd_sc_hd__fill_1
XFILLER_26_507 VGND VGND VPWR VPWR sky130_fd_sc_hd__fill_2
XFILLER_93_473 VGND VGND VPWR VPWR sky130_fd_sc_hd__decap_3
XFILLER_65_164 VGND VGND VPWR VPWR sky130_fd_sc_hd__decap_3
XFILLER_81_624 VGND VGND VPWR VPWR sky130_fd_sc_hd__decap_3
XFILLER_26_529 VGND VGND VPWR VPWR sky130_fd_sc_hd__decap_3
X_6972_ _6972_/A _7329_/C VGND VGND VPWR VPWR _7073_/A sky130_fd_sc_hd__nand2_2
XFILLER_65_175 VGND VGND VPWR VPWR sky130_fd_sc_hd__fill_1
XFILLER_19_570 VGND VGND VPWR VPWR sky130_fd_sc_hd__decap_3
XFILLER_81_646 VGND VGND VPWR VPWR sky130_fd_sc_hd__decap_3
XFILLER_53_337 VGND VGND VPWR VPWR sky130_fd_sc_hd__decap_3
XFILLER_19_592 VGND VGND VPWR VPWR sky130_fd_sc_hd__decap_3
X_8711_ _8711_/A VGND VGND VPWR VPWR _8728_/S sky130_fd_sc_hd__inv_6
X_5923_ _5088_/A _5922_/Y _5923_/S VGND VGND VPWR VPWR _5923_/X sky130_fd_sc_hd__mux2_2
XFILLER_81_668 VGND VGND VPWR VPWR sky130_fd_sc_hd__decap_3
XFILLER_34_551 VGND VGND VPWR VPWR sky130_fd_sc_hd__decap_3
X_8642_ _8642_/A VGND VGND VPWR VPWR _8642_/Y sky130_fd_sc_hd__inv_2
X_5854_ _7430_/C VGND VGND VPWR VPWR _5855_/B sky130_fd_sc_hd__clkbuf_1
XFILLER_61_370 VGND VGND VPWR VPWR sky130_fd_sc_hd__decap_3
XFILLER_21_201 VGND VGND VPWR VPWR sky130_fd_sc_hd__decap_3
XTAP_TAPCELL_ROW_105_1699 VGND VPWR sky130_fd_sc_hd__tapvpwrvgnd_1
XFILLER_21_212 VGND VGND VPWR VPWR sky130_fd_sc_hd__decap_3
XFILLER_22_746 VGND VGND VPWR VPWR sky130_fd_sc_hd__decap_3
XFILLER_22_757 VGND VGND VPWR VPWR sky130_fd_sc_hd__decap_3
X_4805_ _9148_/Q hold947/X _4819_/S VGND VGND VPWR VPWR _4805_/X sky130_fd_sc_hd__mux2_2
X_8573_ _8585_/A _8573_/B VGND VGND VPWR VPWR _8575_/B sky130_fd_sc_hd__xnor2_2
XFILLER_21_245 VGND VGND VPWR VPWR sky130_fd_sc_hd__decap_3
X_5785_ _5519_/B _7534_/B _5784_/X _6436_/B VGND VGND VPWR VPWR _5785_/X sky130_fd_sc_hd__a22o_2
XFILLER_9_80 VGND VGND VPWR VPWR sky130_fd_sc_hd__decap_3
X_7524_ _7233_/A _7520_/Y _7523_/X VGND VGND VPWR VPWR _7548_/A sky130_fd_sc_hd__a21o_2
Xrebuffer505 _7900_/A VGND VGND VPWR VPWR _7650_/A sky130_fd_sc_hd__buf_2
XFILLER_119_111 VGND VGND VPWR VPWR sky130_fd_sc_hd__fill_1
X_4736_ _4736_/A VGND VGND VPWR VPWR _9115_/D sky130_fd_sc_hd__buf_1
Xrebuffer516 _4516_/A VGND VGND VPWR VPWR _5374_/A2 sky130_fd_sc_hd__buf_2
XFILLER_9_91 VGND VGND VPWR VPWR sky130_fd_sc_hd__decap_3
XFILLER_119_122 VGND VGND VPWR VPWR sky130_fd_sc_hd__decap_3
Xrebuffer527 _5629_/A VGND VGND VPWR VPWR _6963_/D sky130_fd_sc_hd__buf_2
Xrebuffer538 _6203_/A VGND VGND VPWR VPWR _6290_/B sky130_fd_sc_hd__buf_2
XFILLER_119_15 VGND VGND VPWR VPWR sky130_fd_sc_hd__decap_3
Xrebuffer549 _5724_/B VGND VGND VPWR VPWR _5863_/B sky130_fd_sc_hd__buf_2
X_7455_ _7454_/B _7454_/C _7454_/A VGND VGND VPWR VPWR _7455_/Y sky130_fd_sc_hd__a21oi_2
XFILLER_119_48 VGND VGND VPWR VPWR sky130_fd_sc_hd__decap_3
X_4667_ _4667_/A VGND VGND VPWR VPWR _9082_/D sky130_fd_sc_hd__buf_1
X_6406_ _5803_/A _6406_/B VGND VGND VPWR VPWR _6406_/X sky130_fd_sc_hd__and2b_2
Xhold920 _9060_/Q VGND VGND VPWR VPWR hold920/X sky130_fd_sc_hd__dlygate4sd3_1
XFILLER_102_9 VGND VGND VPWR VPWR sky130_fd_sc_hd__decap_3
X_7386_ _7385_/A _7381_/X _7383_/X _7385_/Y VGND VGND VPWR VPWR _7387_/B sky130_fd_sc_hd__a211o_2
Xhold931 _8869_/X VGND VGND VPWR VPWR _8870_/A sky130_fd_sc_hd__dlygate4sd3_1
X_4598_ _9050_/Q _4598_/A1 _4608_/S VGND VGND VPWR VPWR _4598_/X sky130_fd_sc_hd__mux2_2
Xhold942 _9173_/Q VGND VGND VPWR VPWR hold942/X sky130_fd_sc_hd__dlygate4sd3_1
Xhold953 _4909_/X VGND VGND VPWR VPWR _4910_/A sky130_fd_sc_hd__dlygate4sd3_1
X_9125_ _9159_/CLK _9125_/D fanout387/X VGND VGND VPWR VPWR _9125_/Q sky130_fd_sc_hd__dfrtp_2
XFILLER_1_606 VGND VGND VPWR VPWR sky130_fd_sc_hd__decap_3
XFILLER_103_501 VGND VGND VPWR VPWR sky130_fd_sc_hd__decap_3
X_6337_ _9159_/Q _6754_/B _6604_/C VGND VGND VPWR VPWR _6337_/X sky130_fd_sc_hd__and3_2
Xhold964 _9035_/Q VGND VGND VPWR VPWR hold964/X sky130_fd_sc_hd__dlygate4sd3_1
XFILLER_89_724 VGND VGND VPWR VPWR sky130_fd_sc_hd__decap_3
XFILLER_1_617 VGND VGND VPWR VPWR sky130_fd_sc_hd__decap_3
Xhold975 _4836_/X VGND VGND VPWR VPWR _4837_/A sky130_fd_sc_hd__dlygate4sd3_1
Xhold986 _4843_/X VGND VGND VPWR VPWR _4844_/A sky130_fd_sc_hd__dlygate4sd3_1
XFILLER_89_735 VGND VGND VPWR VPWR sky130_fd_sc_hd__decap_3
XFILLER_115_372 VGND VGND VPWR VPWR sky130_fd_sc_hd__fill_2
XFILLER_0_116 VGND VGND VPWR VPWR sky130_fd_sc_hd__decap_3
XFILLER_115_383 VGND VGND VPWR VPWR sky130_fd_sc_hd__fill_2
Xhold997 _9019_/Q VGND VGND VPWR VPWR hold997/X sky130_fd_sc_hd__dlygate4sd3_1
XFILLER_88_234 VGND VGND VPWR VPWR sky130_fd_sc_hd__decap_3
X_9056_ _9168_/CLK _9056_/D fanout377/X VGND VGND VPWR VPWR _9056_/Q sky130_fd_sc_hd__dfrtp_2
XFILLER_103_556 VGND VGND VPWR VPWR sky130_fd_sc_hd__decap_3
X_6268_ _6070_/A _6069_/A _6267_/X VGND VGND VPWR VPWR _6269_/B sky130_fd_sc_hd__a21oi_2
XFILLER_103_567 VGND VGND VPWR VPWR sky130_fd_sc_hd__decap_3
XFILLER_88_256 VGND VGND VPWR VPWR sky130_fd_sc_hd__decap_3
XFILLER_76_407 VGND VGND VPWR VPWR sky130_fd_sc_hd__decap_3
X_8007_ _8005_/X _8009_/B _8007_/S VGND VGND VPWR VPWR _8007_/X sky130_fd_sc_hd__mux2_2
XFILLER_76_418 VGND VGND VPWR VPWR sky130_fd_sc_hd__fill_2
X_5219_ _5514_/A _6434_/B VGND VGND VPWR VPWR _5219_/Y sky130_fd_sc_hd__nor2_2
X_6199_ _6041_/B _6041_/A _6042_/A VGND VGND VPWR VPWR _6199_/X sky130_fd_sc_hd__a21o_2
XFILLER_28_23 VGND VGND VPWR VPWR sky130_fd_sc_hd__decap_3
XFILLER_29_323 VGND VGND VPWR VPWR sky130_fd_sc_hd__decap_3
XFILLER_84_440 VGND VGND VPWR VPWR sky130_fd_sc_hd__fill_2
XFILLER_28_56 VGND VGND VPWR VPWR sky130_fd_sc_hd__decap_3
XFILLER_57_687 VGND VGND VPWR VPWR sky130_fd_sc_hd__decap_3
XFILLER_56_153 VGND VGND VPWR VPWR sky130_fd_sc_hd__decap_3
XFILLER_56_175 VGND VGND VPWR VPWR sky130_fd_sc_hd__decap_3
XFILLER_29_389 VGND VGND VPWR VPWR sky130_fd_sc_hd__decap_3
XFILLER_71_123 VGND VGND VPWR VPWR sky130_fd_sc_hd__decap_3
XFILLER_44_348 VGND VGND VPWR VPWR sky130_fd_sc_hd__decap_3
XPHY_EDGE_ROW_88_Left_219 VGND VGND VPWR VPWR sky130_fd_sc_hd__decap_3
X_8909_ _8942_/A1 _9281_/Q _8925_/S VGND VGND VPWR VPWR _8909_/X sky130_fd_sc_hd__mux2_2
XFILLER_71_167 VGND VGND VPWR VPWR sky130_fd_sc_hd__fill_1
XFILLER_44_66 VGND VGND VPWR VPWR sky130_fd_sc_hd__fill_2
XFILLER_13_724 VGND VGND VPWR VPWR sky130_fd_sc_hd__decap_3
XFILLER_44_77 VGND VGND VPWR VPWR sky130_fd_sc_hd__decap_3
XFILLER_13_735 VGND VGND VPWR VPWR sky130_fd_sc_hd__decap_3
XFILLER_80_690 VGND VGND VPWR VPWR sky130_fd_sc_hd__decap_3
XFILLER_44_88 VGND VGND VPWR VPWR sky130_fd_sc_hd__decap_3
XFILLER_12_223 VGND VGND VPWR VPWR sky130_fd_sc_hd__decap_3
XFILLER_9_706 VGND VGND VPWR VPWR sky130_fd_sc_hd__decap_3
XFILLER_40_554 VGND VGND VPWR VPWR sky130_fd_sc_hd__decap_3
XFILLER_13_768 VGND VGND VPWR VPWR sky130_fd_sc_hd__decap_3
XFILLER_100_50 VGND VGND VPWR VPWR sky130_fd_sc_hd__decap_3
XFILLER_12_256 VGND VGND VPWR VPWR sky130_fd_sc_hd__decap_3
XFILLER_60_21 VGND VGND VPWR VPWR sky130_fd_sc_hd__decap_3
XFILLER_100_83 VGND VGND VPWR VPWR sky130_fd_sc_hd__fill_1
XFILLER_60_32 VGND VGND VPWR VPWR sky130_fd_sc_hd__fill_2
XTAP_TAPCELL_ROW_10_413 VGND VPWR sky130_fd_sc_hd__tapvpwrvgnd_1
XFILLER_60_76 VGND VGND VPWR VPWR sky130_fd_sc_hd__decap_3
XFILLER_126_615 VGND VGND VPWR VPWR sky130_fd_sc_hd__decap_3
XFILLER_126_648 VGND VGND VPWR VPWR sky130_fd_sc_hd__decap_3
XFILLER_125_125 VGND VGND VPWR VPWR sky130_fd_sc_hd__decap_3
XPHY_EDGE_ROW_97_Left_228 VGND VGND VPWR VPWR sky130_fd_sc_hd__decap_3
XFILLER_5_27 VGND VGND VPWR VPWR sky130_fd_sc_hd__decap_3
XTAP_TAPCELL_ROW_95_1570 VGND VPWR sky130_fd_sc_hd__tapvpwrvgnd_1
XFILLER_125_158 VGND VGND VPWR VPWR sky130_fd_sc_hd__decap_3
XFILLER_4_466 VGND VGND VPWR VPWR sky130_fd_sc_hd__fill_2
XFILLER_125_169 VGND VGND VPWR VPWR sky130_fd_sc_hd__decap_3
XFILLER_69_52 VGND VGND VPWR VPWR sky130_fd_sc_hd__decap_3
XFILLER_95_716 VGND VGND VPWR VPWR sky130_fd_sc_hd__decap_3
XFILLER_79_267 VGND VGND VPWR VPWR sky130_fd_sc_hd__decap_3
XFILLER_67_418 VGND VGND VPWR VPWR sky130_fd_sc_hd__decap_3
XFILLER_39_109 VGND VGND VPWR VPWR sky130_fd_sc_hd__decap_3
XFILLER_121_364 VGND VGND VPWR VPWR sky130_fd_sc_hd__decap_3
XFILLER_0_694 VGND VGND VPWR VPWR sky130_fd_sc_hd__decap_3
Xclkbuf_2_3__f_clk clkbuf_0_clk/X VGND VGND VPWR VPWR clkload2/A sky130_fd_sc_hd__clkbuf_16
XFILLER_47_153 VGND VGND VPWR VPWR sky130_fd_sc_hd__fill_2
XFILLER_47_175 VGND VGND VPWR VPWR sky130_fd_sc_hd__decap_3
XFILLER_35_326 VGND VGND VPWR VPWR sky130_fd_sc_hd__decap_3
XTAP_TAPCELL_ROW_18_524 VGND VPWR sky130_fd_sc_hd__tapvpwrvgnd_1
XFILLER_90_421 VGND VGND VPWR VPWR sky130_fd_sc_hd__decap_3
XFILLER_63_657 VGND VGND VPWR VPWR sky130_fd_sc_hd__fill_2
XFILLER_63_679 VGND VGND VPWR VPWR sky130_fd_sc_hd__decap_3
XTAP_TAPCELL_ROW_46_899 VGND VPWR sky130_fd_sc_hd__tapvpwrvgnd_1
XFILLER_90_498 VGND VGND VPWR VPWR sky130_fd_sc_hd__decap_3
XFILLER_62_189 VGND VGND VPWR VPWR sky130_fd_sc_hd__decap_3
XFILLER_43_370 VGND VGND VPWR VPWR sky130_fd_sc_hd__decap_3
XFILLER_16_595 VGND VGND VPWR VPWR sky130_fd_sc_hd__decap_3
XFILLER_31_554 VGND VGND VPWR VPWR sky130_fd_sc_hd__decap_3
XFILLER_31_598 VGND VGND VPWR VPWR sky130_fd_sc_hd__decap_3
X_5570_ _5482_/A _5479_/B _7945_/A _9203_/Q VGND VGND VPWR VPWR _5570_/X sky130_fd_sc_hd__a211o_2
XFILLER_129_431 VGND VGND VPWR VPWR sky130_fd_sc_hd__fill_2
XFILLER_117_604 VGND VGND VPWR VPWR sky130_fd_sc_hd__decap_3
X_4521_ _6336_/B VGND VGND VPWR VPWR _4521_/X sky130_fd_sc_hd__clkbuf_1
XFILLER_8_772 VGND VGND VPWR VPWR sky130_fd_sc_hd__decap_3
XFILLER_116_103 VGND VGND VPWR VPWR sky130_fd_sc_hd__decap_3
Xwire180 _4521_/X VGND VGND VPWR VPWR _6757_/B sky130_fd_sc_hd__clkbuf_4
XFILLER_7_271 VGND VGND VPWR VPWR sky130_fd_sc_hd__decap_3
X_7240_ _7661_/B _7240_/B VGND VGND VPWR VPWR _7254_/A sky130_fd_sc_hd__xnor2_2
XFILLER_7_293 VGND VGND VPWR VPWR sky130_fd_sc_hd__decap_3
X_7171_ _6825_/B _7169_/X _7170_/X _6872_/A VGND VGND VPWR VPWR _7194_/A sky130_fd_sc_hd__a22o_2
XTAP_TAPCELL_ROW_55_1020 VGND VPWR sky130_fd_sc_hd__tapvpwrvgnd_1
XFILLER_125_670 VGND VGND VPWR VPWR sky130_fd_sc_hd__fill_2
XFILLER_98_521 VGND VGND VPWR VPWR sky130_fd_sc_hd__decap_3
XFILLER_125_692 VGND VGND VPWR VPWR sky130_fd_sc_hd__decap_3
X_6122_ _6122_/A _6438_/B VGND VGND VPWR VPWR _6123_/B sky130_fd_sc_hd__nand2_2
XFILLER_124_180 VGND VGND VPWR VPWR sky130_fd_sc_hd__decap_3
XFILLER_58_407 VGND VGND VPWR VPWR sky130_fd_sc_hd__decap_3
X_6053_ wire62/X _6053_/B VGND VGND VPWR VPWR _6151_/B sky130_fd_sc_hd__or2_2
XFILLER_100_548 VGND VGND VPWR VPWR sky130_fd_sc_hd__decap_3
XFILLER_39_632 VGND VGND VPWR VPWR sky130_fd_sc_hd__decap_3
X_5004_ _5879_/C VGND VGND VPWR VPWR _6604_/C sky130_fd_sc_hd__buf_2
XFILLER_38_131 VGND VGND VPWR VPWR sky130_fd_sc_hd__decap_3
XFILLER_39_676 VGND VGND VPWR VPWR sky130_fd_sc_hd__fill_1
XFILLER_54_624 VGND VGND VPWR VPWR sky130_fd_sc_hd__decap_3
XFILLER_26_315 VGND VGND VPWR VPWR sky130_fd_sc_hd__decap_3
XTAP_TAPCELL_ROW_107_1728 VGND VPWR sky130_fd_sc_hd__tapvpwrvgnd_1
XFILLER_53_101 VGND VGND VPWR VPWR sky130_fd_sc_hd__decap_3
XFILLER_93_281 VGND VGND VPWR VPWR sky130_fd_sc_hd__decap_3
XFILLER_81_432 VGND VGND VPWR VPWR sky130_fd_sc_hd__decap_3
XFILLER_38_197 VGND VGND VPWR VPWR sky130_fd_sc_hd__decap_3
XFILLER_121_27 VGND VGND VPWR VPWR sky130_fd_sc_hd__decap_3
X_6955_ _6952_/S _7012_/B _6954_/X VGND VGND VPWR VPWR _6955_/X sky130_fd_sc_hd__o21a_2
XFILLER_54_679 VGND VGND VPWR VPWR sky130_fd_sc_hd__decap_3
XFILLER_53_145 VGND VGND VPWR VPWR sky130_fd_sc_hd__decap_3
XFILLER_81_465 VGND VGND VPWR VPWR sky130_fd_sc_hd__decap_3
XFILLER_41_307 VGND VGND VPWR VPWR sky130_fd_sc_hd__decap_3
XTAP_TAPCELL_ROW_120_1906 VGND VPWR sky130_fd_sc_hd__tapvpwrvgnd_1
X_5906_ _5907_/B _5907_/A _5907_/D _5906_/B1 VGND VGND VPWR VPWR _5908_/A sky130_fd_sc_hd__o31ai_2
XTAP_TAPCELL_ROW_66_1171 VGND VPWR sky130_fd_sc_hd__tapvpwrvgnd_1
X_6886_ _6886_/A _6886_/B input6/X VGND VGND VPWR VPWR _6887_/B sky130_fd_sc_hd__or3_2
XFILLER_34_392 VGND VGND VPWR VPWR sky130_fd_sc_hd__decap_3
X_8625_ _8649_/B VGND VGND VPWR VPWR _8625_/Y sky130_fd_sc_hd__inv_2
X_5837_ _7445_/A _7413_/A VGND VGND VPWR VPWR _5841_/A sky130_fd_sc_hd__nand2_2
XFILLER_10_716 VGND VGND VPWR VPWR sky130_fd_sc_hd__decap_3
X_8556_ _8547_/Y _8551_/X _8552_/X _8555_/Y VGND VGND VPWR VPWR _8636_/A sky130_fd_sc_hd__o2bb2a_2
X_5768_ _5768_/A _5768_/B _5768_/C VGND VGND VPWR VPWR _5912_/A sky130_fd_sc_hd__or3_4
XFILLER_10_749 VGND VGND VPWR VPWR sky130_fd_sc_hd__decap_3
X_7507_ _7507_/A _7507_/B _7507_/C VGND VGND VPWR VPWR _7507_/X sky130_fd_sc_hd__or3_2
X_4719_ _9107_/Q hold831/X _4735_/S VGND VGND VPWR VPWR _4719_/X sky130_fd_sc_hd__mux2_2
XFILLER_5_208 VGND VGND VPWR VPWR sky130_fd_sc_hd__fill_2
X_8487_ _8482_/A _8482_/B _8483_/X _8486_/A _8486_/Y VGND VGND VPWR VPWR _8547_/A
+ sky130_fd_sc_hd__o221a_2
X_5699_ _5699_/A _5699_/B VGND VGND VPWR VPWR _5700_/B sky130_fd_sc_hd__xnor2_2
XFILLER_108_648 VGND VGND VPWR VPWR sky130_fd_sc_hd__decap_3
XTAP_TAPCELL_ROW_118_1868 VGND VPWR sky130_fd_sc_hd__tapvpwrvgnd_1
X_7438_ _7624_/A _7438_/B _7624_/C VGND VGND VPWR VPWR _7438_/Y sky130_fd_sc_hd__nand3_2
XTAP_TAPCELL_ROW_118_1879 VGND VPWR sky130_fd_sc_hd__tapvpwrvgnd_1
XFILLER_100_6 VGND VGND VPWR VPWR sky130_fd_sc_hd__decap_3
XFILLER_107_169 VGND VGND VPWR VPWR sky130_fd_sc_hd__decap_3
Xhold750 _8789_/X VGND VGND VPWR VPWR _8790_/A sky130_fd_sc_hd__dlygate4sd3_1
XFILLER_122_106 VGND VGND VPWR VPWR sky130_fd_sc_hd__decap_3
X_7369_ _7369_/A _7369_/B VGND VGND VPWR VPWR _7370_/B sky130_fd_sc_hd__xor2_2
Xhold761 _6416_/A VGND VGND VPWR VPWR _5953_/A sky130_fd_sc_hd__dlygate4sd3_1
XFILLER_1_414 VGND VGND VPWR VPWR sky130_fd_sc_hd__decap_3
Xhold772 _9197_/Q VGND VGND VPWR VPWR hold772/X sky130_fd_sc_hd__dlygate4sd3_1
XFILLER_122_139 VGND VGND VPWR VPWR sky130_fd_sc_hd__fill_1
Xhold783 _4894_/X VGND VGND VPWR VPWR _9187_/D sky130_fd_sc_hd__dlygate4sd3_1
X_9108_ _9296_/CLK _9108_/D fanout379/X VGND VGND VPWR VPWR _9108_/Q sky130_fd_sc_hd__dfrtp_2
Xhold794 _4896_/X VGND VGND VPWR VPWR _9188_/D sky130_fd_sc_hd__dlygate4sd3_1
XFILLER_103_364 VGND VGND VPWR VPWR sky130_fd_sc_hd__decap_3
XFILLER_77_727 VGND VGND VPWR VPWR sky130_fd_sc_hd__fill_1
XFILLER_130_150 VGND VGND VPWR VPWR sky130_fd_sc_hd__decap_3
X_9039_ _9135_/CLK _9039_/D load_slew384/X VGND VGND VPWR VPWR _9039_/Q sky130_fd_sc_hd__dfrtp_2
XFILLER_77_738 VGND VGND VPWR VPWR sky130_fd_sc_hd__decap_3
XFILLER_39_66 VGND VGND VPWR VPWR sky130_fd_sc_hd__decap_3
XFILLER_130_172 VGND VGND VPWR VPWR sky130_fd_sc_hd__decap_3
XFILLER_76_237 VGND VGND VPWR VPWR sky130_fd_sc_hd__fill_2
XFILLER_76_248 VGND VGND VPWR VPWR sky130_fd_sc_hd__decap_3
XFILLER_39_99 VGND VGND VPWR VPWR sky130_fd_sc_hd__fill_2
XFILLER_57_440 VGND VGND VPWR VPWR sky130_fd_sc_hd__decap_3
XFILLER_29_142 VGND VGND VPWR VPWR sky130_fd_sc_hd__decap_3
XFILLER_17_304 VGND VGND VPWR VPWR sky130_fd_sc_hd__decap_3
XFILLER_91_229 VGND VGND VPWR VPWR sky130_fd_sc_hd__decap_3
XFILLER_57_473 VGND VGND VPWR VPWR sky130_fd_sc_hd__decap_3
XFILLER_29_186 VGND VGND VPWR VPWR sky130_fd_sc_hd__decap_3
XFILLER_17_337 VGND VGND VPWR VPWR sky130_fd_sc_hd__decap_3
XFILLER_55_54 VGND VGND VPWR VPWR sky130_fd_sc_hd__fill_2
XFILLER_45_679 VGND VGND VPWR VPWR sky130_fd_sc_hd__decap_3
XFILLER_60_616 VGND VGND VPWR VPWR sky130_fd_sc_hd__decap_3
XPHY_EDGE_ROW_105_Right_105 VGND VGND VPWR VPWR sky130_fd_sc_hd__decap_3
XFILLER_72_498 VGND VGND VPWR VPWR sky130_fd_sc_hd__decap_3
XFILLER_44_189 VGND VGND VPWR VPWR sky130_fd_sc_hd__decap_3
XFILLER_111_60 VGND VGND VPWR VPWR sky130_fd_sc_hd__decap_3
XTAP_TAPCELL_ROW_43_858 VGND VPWR sky130_fd_sc_hd__tapvpwrvgnd_1
XFILLER_13_532 VGND VGND VPWR VPWR sky130_fd_sc_hd__decap_3
XFILLER_71_42 VGND VGND VPWR VPWR sky130_fd_sc_hd__decap_3
XFILLER_111_93 VGND VGND VPWR VPWR sky130_fd_sc_hd__decap_3
XFILLER_9_514 VGND VGND VPWR VPWR sky130_fd_sc_hd__decap_3
XFILLER_13_598 VGND VGND VPWR VPWR sky130_fd_sc_hd__decap_3
XTAP_TAPCELL_ROW_23_593 VGND VPWR sky130_fd_sc_hd__tapvpwrvgnd_1
XFILLER_126_412 VGND VGND VPWR VPWR sky130_fd_sc_hd__decap_3
XFILLER_65_9 VGND VGND VPWR VPWR sky130_fd_sc_hd__decap_3
XFILLER_126_434 VGND VGND VPWR VPWR sky130_fd_sc_hd__decap_3
XFILLER_5_753 VGND VGND VPWR VPWR sky130_fd_sc_hd__decap_3
XFILLER_113_106 VGND VGND VPWR VPWR sky130_fd_sc_hd__decap_3
XFILLER_4_274 VGND VGND VPWR VPWR sky130_fd_sc_hd__decap_3
XFILLER_106_180 VGND VGND VPWR VPWR sky130_fd_sc_hd__decap_3
XFILLER_68_716 VGND VGND VPWR VPWR sky130_fd_sc_hd__decap_3
XFILLER_122_684 VGND VGND VPWR VPWR sky130_fd_sc_hd__decap_3
XFILLER_121_161 VGND VGND VPWR VPWR sky130_fd_sc_hd__decap_3
XFILLER_95_535 VGND VGND VPWR VPWR sky130_fd_sc_hd__decap_3
XFILLER_121_172 VGND VGND VPWR VPWR sky130_fd_sc_hd__decap_3
XFILLER_0_480 VGND VGND VPWR VPWR sky130_fd_sc_hd__decap_3
XFILLER_76_760 VGND VGND VPWR VPWR sky130_fd_sc_hd__decap_3
XFILLER_48_462 VGND VGND VPWR VPWR sky130_fd_sc_hd__fill_1
XFILLER_36_635 VGND VGND VPWR VPWR sky130_fd_sc_hd__decap_3
XFILLER_75_281 VGND VGND VPWR VPWR sky130_fd_sc_hd__decap_3
XFILLER_63_421 VGND VGND VPWR VPWR sky130_fd_sc_hd__decap_3
XFILLER_51_605 VGND VGND VPWR VPWR sky130_fd_sc_hd__decap_3
XFILLER_35_156 VGND VGND VPWR VPWR sky130_fd_sc_hd__decap_3
XFILLER_90_251 VGND VGND VPWR VPWR sky130_fd_sc_hd__fill_1
XFILLER_90_262 VGND VGND VPWR VPWR sky130_fd_sc_hd__decap_3
XFILLER_63_476 VGND VGND VPWR VPWR sky130_fd_sc_hd__decap_3
XFILLER_35_167 VGND VGND VPWR VPWR sky130_fd_sc_hd__fill_1
XFILLER_50_104 VGND VGND VPWR VPWR sky130_fd_sc_hd__fill_1
XFILLER_23_318 VGND VGND VPWR VPWR sky130_fd_sc_hd__decap_3
X_6740_ _6620_/B _6764_/A _6739_/Y _6624_/B VGND VGND VPWR VPWR _6740_/X sky130_fd_sc_hd__a31o_2
XFILLER_35_189 VGND VGND VPWR VPWR sky130_fd_sc_hd__fill_1
X_6671_ _6666_/A _6670_/A _6669_/C _6669_/B _6669_/A VGND VGND VPWR VPWR _6671_/Y
+ sky130_fd_sc_hd__a2111oi_2
XTAP_TAPCELL_ROW_102_1658 VGND VPWR sky130_fd_sc_hd__tapvpwrvgnd_1
XFILLER_31_340 VGND VGND VPWR VPWR sky130_fd_sc_hd__decap_3
X_8410_ _8408_/Y _8409_/X _8410_/S VGND VGND VPWR VPWR _8411_/B sky130_fd_sc_hd__mux2_2
X_5622_ _6231_/B _9170_/Q _6232_/C VGND VGND VPWR VPWR _5622_/X sky130_fd_sc_hd__and3b_2
X_8341_ _8341_/A VGND VGND VPWR VPWR _8341_/Y sky130_fd_sc_hd__inv_2
X_5553_ _5553_/A _5553_/B VGND VGND VPWR VPWR _5559_/A sky130_fd_sc_hd__xnor2_2
XFILLER_129_272 VGND VGND VPWR VPWR sky130_fd_sc_hd__decap_3
XFILLER_8_580 VGND VGND VPWR VPWR sky130_fd_sc_hd__fill_1
X_8272_ _8268_/S _5048_/B wire66/X _8271_/X _8350_/B VGND VGND VPWR VPWR _8272_/X
+ sky130_fd_sc_hd__a311o_2
X_5484_ _6279_/B VGND VGND VPWR VPWR _8050_/A sky130_fd_sc_hd__clkbuf_4
XFILLER_117_478 VGND VGND VPWR VPWR sky130_fd_sc_hd__decap_3
X_7223_ _6807_/A _6817_/Y _7222_/Y _5320_/Y _5220_/X VGND VGND VPWR VPWR _7223_/Y
+ sky130_fd_sc_hd__o2111ai_2
XFILLER_116_27 VGND VGND VPWR VPWR sky130_fd_sc_hd__fill_1
X_7154_ wire91/X VGND VGND VPWR VPWR _7154_/Y sky130_fd_sc_hd__inv_2
XFILLER_116_38 VGND VGND VPWR VPWR sky130_fd_sc_hd__decap_3
XFILLER_113_640 VGND VGND VPWR VPWR sky130_fd_sc_hd__decap_3
X_6105_ _6482_/A _6788_/A VGND VGND VPWR VPWR _6106_/B sky130_fd_sc_hd__nand2_2
XFILLER_59_727 VGND VGND VPWR VPWR sky130_fd_sc_hd__fill_1
XFILLER_113_673 VGND VGND VPWR VPWR sky130_fd_sc_hd__decap_3
XFILLER_59_738 VGND VGND VPWR VPWR sky130_fd_sc_hd__decap_3
X_7085_ _7071_/A _7329_/C _6211_/B _6279_/B VGND VGND VPWR VPWR _7086_/D sky130_fd_sc_hd__a211o_2
X_6036_ _6211_/B VGND VGND VPWR VPWR _8405_/B sky130_fd_sc_hd__buf_4
XFILLER_74_719 VGND VGND VPWR VPWR sky130_fd_sc_hd__decap_3
XTAP_TAPCELL_ROW_68_1200 VGND VPWR sky130_fd_sc_hd__tapvpwrvgnd_1
XFILLER_66_281 VGND VGND VPWR VPWR sky130_fd_sc_hd__decap_3
XFILLER_54_421 VGND VGND VPWR VPWR sky130_fd_sc_hd__decap_3
XFILLER_39_495 VGND VGND VPWR VPWR sky130_fd_sc_hd__fill_1
XFILLER_27_646 VGND VGND VPWR VPWR sky130_fd_sc_hd__decap_3
XFILLER_27_679 VGND VGND VPWR VPWR sky130_fd_sc_hd__decap_3
X_7987_ _7846_/A _7845_/B _7986_/X VGND VGND VPWR VPWR _7989_/B sky130_fd_sc_hd__o21ai_2
XFILLER_42_616 VGND VGND VPWR VPWR sky130_fd_sc_hd__decap_3
XFILLER_26_167 VGND VGND VPWR VPWR sky130_fd_sc_hd__decap_3
XFILLER_25_24 VGND VGND VPWR VPWR sky130_fd_sc_hd__decap_3
XTAP_TAPCELL_ROW_1_299 VGND VPWR sky130_fd_sc_hd__tapvpwrvgnd_1
XFILLER_54_487 VGND VGND VPWR VPWR sky130_fd_sc_hd__decap_3
XFILLER_14_318 VGND VGND VPWR VPWR sky130_fd_sc_hd__decap_3
XFILLER_54_498 VGND VGND VPWR VPWR sky130_fd_sc_hd__decap_3
X_6938_ _5633_/A _6933_/X _6937_/Y VGND VGND VPWR VPWR _7029_/A sky130_fd_sc_hd__o21ai_2
XFILLER_25_46 VGND VGND VPWR VPWR sky130_fd_sc_hd__decap_3
XFILLER_35_690 VGND VGND VPWR VPWR sky130_fd_sc_hd__decap_3
XFILLER_41_137 VGND VGND VPWR VPWR sky130_fd_sc_hd__fill_2
XFILLER_41_148 VGND VGND VPWR VPWR sky130_fd_sc_hd__decap_3
X_6869_ _7174_/A _7225_/B VGND VGND VPWR VPWR _7186_/A sky130_fd_sc_hd__xnor2_2
XTAP_TAPCELL_ROW_40_817 VGND VPWR sky130_fd_sc_hd__tapvpwrvgnd_1
XTAP_TAPCELL_ROW_40_828 VGND VPWR sky130_fd_sc_hd__tapvpwrvgnd_1
XFILLER_50_682 VGND VGND VPWR VPWR sky130_fd_sc_hd__decap_3
X_8608_ wire313/X _8654_/S _8687_/B1 VGND VGND VPWR VPWR _8608_/Y sky130_fd_sc_hd__o21ai_2
XFILLER_41_12 VGND VGND VPWR VPWR sky130_fd_sc_hd__decap_3
XFILLER_22_384 VGND VGND VPWR VPWR sky130_fd_sc_hd__decap_3
XFILLER_10_557 VGND VGND VPWR VPWR sky130_fd_sc_hd__decap_3
X_8539_ _8539_/A _8539_/B VGND VGND VPWR VPWR _8578_/A sky130_fd_sc_hd__xnor2_4
XTAP_TAPCELL_ROW_20_552 VGND VPWR sky130_fd_sc_hd__tapvpwrvgnd_1
XFILLER_6_539 VGND VGND VPWR VPWR sky130_fd_sc_hd__decap_3
XTAP_TAPCELL_ROW_79_1351 VGND VPWR sky130_fd_sc_hd__tapvpwrvgnd_1
XFILLER_2_701 VGND VGND VPWR VPWR sky130_fd_sc_hd__decap_3
XFILLER_123_437 VGND VGND VPWR VPWR sky130_fd_sc_hd__decap_3
XFILLER_9_3 VGND VGND VPWR VPWR sky130_fd_sc_hd__decap_3
XFILLER_2_734 VGND VGND VPWR VPWR sky130_fd_sc_hd__decap_3
XTAP_TAPCELL_ROW_9_399 VGND VPWR sky130_fd_sc_hd__tapvpwrvgnd_1
XFILLER_89_384 VGND VGND VPWR VPWR sky130_fd_sc_hd__fill_1
XFILLER_106_60 VGND VGND VPWR VPWR sky130_fd_sc_hd__decap_3
XFILLER_49_237 VGND VGND VPWR VPWR sky130_fd_sc_hd__decap_3
XFILLER_77_557 VGND VGND VPWR VPWR sky130_fd_sc_hd__decap_3
XTAP_TAPCELL_ROW_48_928 VGND VPWR sky130_fd_sc_hd__tapvpwrvgnd_1
XFILLER_92_527 VGND VGND VPWR VPWR sky130_fd_sc_hd__decap_3
XFILLER_92_549 VGND VGND VPWR VPWR sky130_fd_sc_hd__decap_3
XFILLER_66_97 VGND VGND VPWR VPWR sky130_fd_sc_hd__decap_3
XFILLER_18_635 VGND VGND VPWR VPWR sky130_fd_sc_hd__decap_3
XFILLER_73_741 VGND VGND VPWR VPWR sky130_fd_sc_hd__decap_3
XFILLER_17_123 VGND VGND VPWR VPWR sky130_fd_sc_hd__decap_3
XFILLER_33_605 VGND VGND VPWR VPWR sky130_fd_sc_hd__fill_1
XFILLER_18_679 VGND VGND VPWR VPWR sky130_fd_sc_hd__decap_3
XTAP_TAPCELL_ROW_28_663 VGND VPWR sky130_fd_sc_hd__tapvpwrvgnd_1
XFILLER_17_167 VGND VGND VPWR VPWR sky130_fd_sc_hd__fill_1
XFILLER_72_262 VGND VGND VPWR VPWR sky130_fd_sc_hd__decap_3
XFILLER_32_104 VGND VGND VPWR VPWR sky130_fd_sc_hd__decap_3
XFILLER_82_52 VGND VGND VPWR VPWR sky130_fd_sc_hd__decap_3
XFILLER_60_424 VGND VGND VPWR VPWR sky130_fd_sc_hd__fill_1
XFILLER_33_638 VGND VGND VPWR VPWR sky130_fd_sc_hd__decap_3
XFILLER_32_126 VGND VGND VPWR VPWR sky130_fd_sc_hd__decap_3
XFILLER_60_446 VGND VGND VPWR VPWR sky130_fd_sc_hd__decap_3
XFILLER_82_85 VGND VGND VPWR VPWR sky130_fd_sc_hd__decap_3
XFILLER_13_340 VGND VGND VPWR VPWR sky130_fd_sc_hd__fill_2
XFILLER_15_90 VGND VGND VPWR VPWR sky130_fd_sc_hd__decap_3
XFILLER_13_384 VGND VGND VPWR VPWR sky130_fd_sc_hd__decap_3
XFILLER_40_181 VGND VGND VPWR VPWR sky130_fd_sc_hd__decap_3
XFILLER_127_721 VGND VGND VPWR VPWR sky130_fd_sc_hd__decap_3
XFILLER_127_732 VGND VGND VPWR VPWR sky130_fd_sc_hd__decap_3
XFILLER_63_6 VGND VGND VPWR VPWR sky130_fd_sc_hd__fill_1
XFILLER_127_765 VGND VGND VPWR VPWR sky130_fd_sc_hd__decap_3
XFILLER_126_242 VGND VGND VPWR VPWR sky130_fd_sc_hd__decap_3
XFILLER_99_104 VGND VGND VPWR VPWR sky130_fd_sc_hd__decap_3
XFILLER_114_404 VGND VGND VPWR VPWR sky130_fd_sc_hd__decap_3
XTAP_TAPCELL_ROW_130_2032 VGND VPWR sky130_fd_sc_hd__tapvpwrvgnd_1
XTAP_TAPCELL_ROW_130_2043 VGND VPWR sky130_fd_sc_hd__tapvpwrvgnd_1
XFILLER_126_286 VGND VGND VPWR VPWR sky130_fd_sc_hd__decap_3
XTAP_TAPCELL_ROW_130_2054 VGND VPWR sky130_fd_sc_hd__tapvpwrvgnd_1
XFILLER_114_459 VGND VGND VPWR VPWR sky130_fd_sc_hd__decap_3
XFILLER_68_513 VGND VGND VPWR VPWR sky130_fd_sc_hd__decap_3
XFILLER_56_708 VGND VGND VPWR VPWR sky130_fd_sc_hd__decap_3
XFILLER_110_654 VGND VGND VPWR VPWR sky130_fd_sc_hd__decap_3
XFILLER_68_568 VGND VGND VPWR VPWR sky130_fd_sc_hd__fill_2
XFILLER_83_505 VGND VGND VPWR VPWR sky130_fd_sc_hd__decap_3
XFILLER_83_527 VGND VGND VPWR VPWR sky130_fd_sc_hd__decap_3
X_7910_ _8345_/A VGND VGND VPWR VPWR _8566_/A sky130_fd_sc_hd__clkbuf_2
X_8890_ _9288_/Q hold970/X _8904_/S VGND VGND VPWR VPWR _8890_/X sky130_fd_sc_hd__mux2_2
X_7841_ _7924_/A _7913_/A _7840_/X VGND VGND VPWR VPWR _7841_/X sky130_fd_sc_hd__o21a_2
XFILLER_24_605 VGND VGND VPWR VPWR sky130_fd_sc_hd__decap_3
XFILLER_51_402 VGND VGND VPWR VPWR sky130_fd_sc_hd__decap_3
XFILLER_91_582 VGND VGND VPWR VPWR sky130_fd_sc_hd__decap_3
X_7772_ _7772_/A _7772_/B VGND VGND VPWR VPWR _7777_/A sky130_fd_sc_hd__xor2_2
XFILLER_23_126 VGND VGND VPWR VPWR sky130_fd_sc_hd__decap_3
X_4984_ _9196_/Q VGND VGND VPWR VPWR _4984_/Y sky130_fd_sc_hd__inv_2
XFILLER_51_446 VGND VGND VPWR VPWR sky130_fd_sc_hd__fill_2
XTAP_TAPCELL_ROW_63_1130 VGND VPWR sky130_fd_sc_hd__tapvpwrvgnd_1
X_6723_ _6723_/A _6723_/B _6723_/C VGND VGND VPWR VPWR _6727_/A sky130_fd_sc_hd__and3_4
X_6654_ _6654_/A VGND VGND VPWR VPWR _9210_/D sky130_fd_sc_hd__buf_1
X_5605_ _5605_/A _5605_/B VGND VGND VPWR VPWR _5605_/Y sky130_fd_sc_hd__xnor2_4
XFILLER_118_710 VGND VGND VPWR VPWR sky130_fd_sc_hd__decap_3
X_6585_ _6953_/A _7095_/A VGND VGND VPWR VPWR _6585_/X sky130_fd_sc_hd__or2_4
XFILLER_11_15 VGND VGND VPWR VPWR sky130_fd_sc_hd__decap_3
XFILLER_118_743 VGND VGND VPWR VPWR sky130_fd_sc_hd__decap_3
X_8324_ _8322_/X _8323_/X _8222_/A VGND VGND VPWR VPWR _8324_/X sky130_fd_sc_hd__a21o_2
X_5536_ _6414_/A _5790_/A VGND VGND VPWR VPWR _5537_/B sky130_fd_sc_hd__nor2_2
XFILLER_127_15 VGND VGND VPWR VPWR sky130_fd_sc_hd__decap_3
XFILLER_11_48 VGND VGND VPWR VPWR sky130_fd_sc_hd__decap_3
XFILLER_117_253 VGND VGND VPWR VPWR sky130_fd_sc_hd__fill_2
XTAP_TAPCELL_ROW_115_1838 VGND VPWR sky130_fd_sc_hd__tapvpwrvgnd_1
XFILLER_117_264 VGND VGND VPWR VPWR sky130_fd_sc_hd__decap_3
XFILLER_105_415 VGND VGND VPWR VPWR sky130_fd_sc_hd__decap_3
X_8255_ _8337_/B _8255_/B VGND VGND VPWR VPWR wire45/A sky130_fd_sc_hd__xnor2_2
XFILLER_127_48 VGND VGND VPWR VPWR sky130_fd_sc_hd__decap_3
X_5467_ _5611_/S _9137_/Q _5463_/C VGND VGND VPWR VPWR _5467_/X sky130_fd_sc_hd__a21bo_2
XFILLER_105_459 VGND VGND VPWR VPWR sky130_fd_sc_hd__decap_3
X_7206_ _7208_/A _7208_/B VGND VGND VPWR VPWR _7207_/A sky130_fd_sc_hd__nand2_2
X_8186_ _8186_/A _8219_/A VGND VGND VPWR VPWR _8187_/B sky130_fd_sc_hd__xnor2_2
X_5398_ _9200_/Q _7764_/A _5281_/A VGND VGND VPWR VPWR _5398_/Y sky130_fd_sc_hd__a21oi_2
XTAP_TAPCELL_ROW_74_1281 VGND VPWR sky130_fd_sc_hd__tapvpwrvgnd_1
XFILLER_59_502 VGND VGND VPWR VPWR sky130_fd_sc_hd__fill_2
X_7137_ _7279_/A _7278_/B VGND VGND VPWR VPWR _7142_/C sky130_fd_sc_hd__nor2_2
XFILLER_113_470 VGND VGND VPWR VPWR sky130_fd_sc_hd__decap_3
XFILLER_113_481 VGND VGND VPWR VPWR sky130_fd_sc_hd__decap_3
XFILLER_101_632 VGND VGND VPWR VPWR sky130_fd_sc_hd__decap_3
XTAP_TAPCELL_ROW_6_358 VGND VPWR sky130_fd_sc_hd__tapvpwrvgnd_1
XFILLER_86_332 VGND VGND VPWR VPWR sky130_fd_sc_hd__decap_3
XFILLER_59_546 VGND VGND VPWR VPWR sky130_fd_sc_hd__decap_3
Xfanout367 fanout391/A VGND VGND VPWR VPWR fanout367/X sky130_fd_sc_hd__clkdlybuf4s25_1
XTAP_TAPCELL_ROW_6_369 VGND VPWR sky130_fd_sc_hd__tapvpwrvgnd_1
XFILLER_59_557 VGND VGND VPWR VPWR sky130_fd_sc_hd__decap_3
XFILLER_47_708 VGND VGND VPWR VPWR sky130_fd_sc_hd__decap_3
X_7068_ _7326_/A _7326_/B VGND VGND VPWR VPWR _7069_/B sky130_fd_sc_hd__xnor2_2
Xfanout389 fanout391/X VGND VGND VPWR VPWR fanout389/X sky130_fd_sc_hd__clkdlybuf4s25_1
XFILLER_59_579 VGND VGND VPWR VPWR sky130_fd_sc_hd__decap_3
XFILLER_101_676 VGND VGND VPWR VPWR sky130_fd_sc_hd__decap_3
XFILLER_86_365 VGND VGND VPWR VPWR sky130_fd_sc_hd__decap_3
X_6019_ _5041_/B _7604_/A _7065_/B _5343_/A _6017_/Y VGND VGND VPWR VPWR _6019_/Y
+ sky130_fd_sc_hd__o221ai_2
XFILLER_100_197 VGND VGND VPWR VPWR sky130_fd_sc_hd__decap_3
XFILLER_27_421 VGND VGND VPWR VPWR sky130_fd_sc_hd__decap_3
XFILLER_36_56 VGND VGND VPWR VPWR sky130_fd_sc_hd__decap_3
XTAP_TAPCELL_ROW_126_1978 VGND VPWR sky130_fd_sc_hd__tapvpwrvgnd_1
XFILLER_55_774 VGND VGND VPWR VPWR sky130_fd_sc_hd__decap_3
XFILLER_15_605 VGND VGND VPWR VPWR sky130_fd_sc_hd__fill_1
XFILLER_70_711 VGND VGND VPWR VPWR sky130_fd_sc_hd__decap_3
XTAP_TAPCELL_ROW_126_1989 VGND VPWR sky130_fd_sc_hd__tapvpwrvgnd_1
XFILLER_42_413 VGND VGND VPWR VPWR sky130_fd_sc_hd__decap_3
XFILLER_15_638 VGND VGND VPWR VPWR sky130_fd_sc_hd__decap_3
XFILLER_14_115 VGND VGND VPWR VPWR sky130_fd_sc_hd__decap_3
XTAP_TAPCELL_ROW_25_622 VGND VPWR sky130_fd_sc_hd__tapvpwrvgnd_1
XFILLER_70_755 VGND VGND VPWR VPWR sky130_fd_sc_hd__fill_1
XFILLER_42_446 VGND VGND VPWR VPWR sky130_fd_sc_hd__decap_3
XFILLER_30_619 VGND VGND VPWR VPWR sky130_fd_sc_hd__decap_3
XTAP_TAPCELL_ROW_53_997 VGND VPWR sky130_fd_sc_hd__tapvpwrvgnd_1
XFILLER_52_88 VGND VGND VPWR VPWR sky130_fd_sc_hd__fill_2
XFILLER_128_518 VGND VGND VPWR VPWR sky130_fd_sc_hd__decap_3
XFILLER_10_343 VGND VGND VPWR VPWR sky130_fd_sc_hd__decap_3
XFILLER_10_365 VGND VGND VPWR VPWR sky130_fd_sc_hd__decap_3
XFILLER_109_732 VGND VGND VPWR VPWR sky130_fd_sc_hd__fill_2
XFILLER_6_336 VGND VGND VPWR VPWR sky130_fd_sc_hd__decap_3
XFILLER_108_242 VGND VGND VPWR VPWR sky130_fd_sc_hd__decap_3
XFILLER_108_253 VGND VGND VPWR VPWR sky130_fd_sc_hd__decap_3
XFILLER_124_713 VGND VGND VPWR VPWR sky130_fd_sc_hd__decap_3
XFILLER_124_746 VGND VGND VPWR VPWR sky130_fd_sc_hd__decap_3
XFILLER_124_757 VGND VGND VPWR VPWR sky130_fd_sc_hd__decap_3
XFILLER_123_223 VGND VGND VPWR VPWR sky130_fd_sc_hd__fill_1
XFILLER_117_81 VGND VGND VPWR VPWR sky130_fd_sc_hd__decap_3
XFILLER_77_41 VGND VGND VPWR VPWR sky130_fd_sc_hd__decap_3
XFILLER_77_332 VGND VGND VPWR VPWR sky130_fd_sc_hd__decap_3
XFILLER_28_9 VGND VGND VPWR VPWR sky130_fd_sc_hd__fill_2
XFILLER_65_505 VGND VGND VPWR VPWR sky130_fd_sc_hd__decap_3
XFILLER_77_387 VGND VGND VPWR VPWR sky130_fd_sc_hd__fill_1
XFILLER_37_218 VGND VGND VPWR VPWR sky130_fd_sc_hd__decap_3
XFILLER_65_549 VGND VGND VPWR VPWR sky130_fd_sc_hd__decap_3
XFILLER_46_752 VGND VGND VPWR VPWR sky130_fd_sc_hd__decap_3
XFILLER_18_443 VGND VGND VPWR VPWR sky130_fd_sc_hd__decap_3
XFILLER_61_700 VGND VGND VPWR VPWR sky130_fd_sc_hd__decap_3
XFILLER_45_251 VGND VGND VPWR VPWR sky130_fd_sc_hd__decap_3
XFILLER_93_95 VGND VGND VPWR VPWR sky130_fd_sc_hd__decap_3
XFILLER_33_413 VGND VGND VPWR VPWR sky130_fd_sc_hd__decap_3
XFILLER_45_284 VGND VGND VPWR VPWR sky130_fd_sc_hd__decap_3
XFILLER_61_744 VGND VGND VPWR VPWR sky130_fd_sc_hd__decap_3
XFILLER_33_446 VGND VGND VPWR VPWR sky130_fd_sc_hd__fill_2
XFILLER_33_457 VGND VGND VPWR VPWR sky130_fd_sc_hd__decap_3
XFILLER_33_479 VGND VGND VPWR VPWR sky130_fd_sc_hd__decap_3
XFILLER_20_107 VGND VGND VPWR VPWR sky130_fd_sc_hd__fill_2
XFILLER_14_671 VGND VGND VPWR VPWR sky130_fd_sc_hd__decap_3
XFILLER_9_141 VGND VGND VPWR VPWR sky130_fd_sc_hd__decap_3
XFILLER_13_192 VGND VGND VPWR VPWR sky130_fd_sc_hd__decap_3
XFILLER_119_518 VGND VGND VPWR VPWR sky130_fd_sc_hd__decap_3
XFILLER_9_163 VGND VGND VPWR VPWR sky130_fd_sc_hd__fill_2
X_6370_ _6370_/A _6370_/B _6528_/B _6542_/A VGND VGND VPWR VPWR _6370_/X sky130_fd_sc_hd__and4_2
XFILLER_61_3 VGND VGND VPWR VPWR sky130_fd_sc_hd__decap_3
XFILLER_115_713 VGND VGND VPWR VPWR sky130_fd_sc_hd__decap_3
X_5321_ _6406_/B _6084_/A VGND VGND VPWR VPWR _5328_/B sky130_fd_sc_hd__nor2b_2
XFILLER_127_595 VGND VGND VPWR VPWR sky130_fd_sc_hd__decap_3
XFILLER_114_212 VGND VGND VPWR VPWR sky130_fd_sc_hd__fill_2
X_8040_ _8040_/A _8040_/B VGND VGND VPWR VPWR _8043_/A sky130_fd_sc_hd__xnor2_2
X_5252_ _9200_/Q _5410_/A _5410_/B _5247_/A VGND VGND VPWR VPWR _5252_/X sky130_fd_sc_hd__a211o_2
XFILLER_130_716 VGND VGND VPWR VPWR sky130_fd_sc_hd__decap_3
XFILLER_130_738 VGND VGND VPWR VPWR sky130_fd_sc_hd__decap_3
X_5183_ _5187_/C _6604_/C _5179_/X _5183_/B1 _5182_/X VGND VGND VPWR VPWR _5429_/B
+ sky130_fd_sc_hd__a311o_2
XTAP_TAPCELL_ROW_110_1768 VGND VPWR sky130_fd_sc_hd__tapvpwrvgnd_1
XFILLER_96_641 VGND VGND VPWR VPWR sky130_fd_sc_hd__decap_3
XFILLER_3_60 VGND VGND VPWR VPWR sky130_fd_sc_hd__decap_3
XTAP_TAPCELL_ROW_3_317 VGND VPWR sky130_fd_sc_hd__tapvpwrvgnd_1
XFILLER_68_365 VGND VGND VPWR VPWR sky130_fd_sc_hd__fill_1
XTAP_TAPCELL_ROW_3_328 VGND VPWR sky130_fd_sc_hd__tapvpwrvgnd_1
XFILLER_3_93 VGND VGND VPWR VPWR sky130_fd_sc_hd__decap_3
XFILLER_28_207 VGND VGND VPWR VPWR sky130_fd_sc_hd__fill_2
XFILLER_28_218 VGND VGND VPWR VPWR sky130_fd_sc_hd__decap_3
XFILLER_110_473 VGND VGND VPWR VPWR sky130_fd_sc_hd__decap_3
XFILLER_96_696 VGND VGND VPWR VPWR sky130_fd_sc_hd__decap_3
XFILLER_95_173 VGND VGND VPWR VPWR sky130_fd_sc_hd__fill_1
X_8942_ _8976_/A1 _8942_/A1 _8946_/S VGND VGND VPWR VPWR _8943_/A sky130_fd_sc_hd__mux2_2
XFILLER_113_39 VGND VGND VPWR VPWR sky130_fd_sc_hd__decap_3
XFILLER_49_590 VGND VGND VPWR VPWR sky130_fd_sc_hd__decap_3
X_8873_ hold981/X _9264_/Q _8883_/S VGND VGND VPWR VPWR _8873_/X sky130_fd_sc_hd__mux2_2
Xwire44 wire44/A VGND VGND VPWR VPWR wire44/X sky130_fd_sc_hd__clkbuf_2
Xwire55 wire55/A VGND VGND VPWR VPWR wire55/X sky130_fd_sc_hd__clkbuf_2
XFILLER_36_273 VGND VGND VPWR VPWR sky130_fd_sc_hd__decap_3
Xwire66 wire66/A VGND VGND VPWR VPWR wire66/X sky130_fd_sc_hd__clkbuf_4
XFILLER_24_424 VGND VGND VPWR VPWR sky130_fd_sc_hd__decap_3
X_7824_ _7824_/A _7824_/B VGND VGND VPWR VPWR _7825_/B sky130_fd_sc_hd__xnor2_2
XFILLER_52_744 VGND VGND VPWR VPWR sky130_fd_sc_hd__decap_3
XFILLER_51_221 VGND VGND VPWR VPWR sky130_fd_sc_hd__decap_3
Xwire88 wire88/A VGND VGND VPWR VPWR wire88/X sky130_fd_sc_hd__buf_4
XFILLER_24_457 VGND VGND VPWR VPWR sky130_fd_sc_hd__decap_3
XFILLER_51_254 VGND VGND VPWR VPWR sky130_fd_sc_hd__decap_3
X_4967_ _5029_/S VGND VGND VPWR VPWR _4968_/S sky130_fd_sc_hd__clkbuf_2
X_7755_ _7620_/A _7754_/Y _7621_/A VGND VGND VPWR VPWR _7755_/X sky130_fd_sc_hd__a21bo_2
X_6706_ _6704_/X _5016_/A _6705_/X VGND VGND VPWR VPWR _6707_/A sky130_fd_sc_hd__a21oi_4
X_7686_ _7667_/A _8035_/S _7685_/X VGND VGND VPWR VPWR _7893_/C sky130_fd_sc_hd__o21a_2
Xclkbuf_leaf_31_clk clkload2/A VGND VGND VPWR VPWR _9223_/CLK sky130_fd_sc_hd__clkbuf_8
XTAP_TAPCELL_ROW_50_956 VGND VPWR sky130_fd_sc_hd__tapvpwrvgnd_1
X_4898_ _4876_/X _4897_/Y _4878_/X hold791/X VGND VGND VPWR VPWR _4898_/X sky130_fd_sc_hd__a2bb2o_2
X_6637_ _6658_/A _6658_/B VGND VGND VPWR VPWR _6644_/S sky130_fd_sc_hd__xnor2_2
XFILLER_20_663 VGND VGND VPWR VPWR sky130_fd_sc_hd__decap_3
XTAP_TAPCELL_ROW_30_680 VGND VPWR sky130_fd_sc_hd__tapvpwrvgnd_1
X_6568_ _6568_/A _6568_/B VGND VGND VPWR VPWR _6666_/A sky130_fd_sc_hd__and2_2
XTAP_TAPCELL_ROW_30_691 VGND VPWR sky130_fd_sc_hd__tapvpwrvgnd_1
XTAP_TAPCELL_ROW_76_1310 VGND VPWR sky130_fd_sc_hd__tapvpwrvgnd_1
XFILLER_106_724 VGND VGND VPWR VPWR sky130_fd_sc_hd__decap_3
X_5519_ _5804_/A _5519_/B VGND VGND VPWR VPWR _5520_/B sky130_fd_sc_hd__xnor2_2
X_8307_ _8405_/A _8313_/B VGND VGND VPWR VPWR _8327_/S sky130_fd_sc_hd__nand2_2
XFILLER_3_317 VGND VGND VPWR VPWR sky130_fd_sc_hd__decap_3
XFILLER_118_584 VGND VGND VPWR VPWR sky130_fd_sc_hd__decap_3
X_9287_ clkload6/A _9287_/D load_slew376/X VGND VGND VPWR VPWR _9287_/Q sky130_fd_sc_hd__dfrtp_2
X_6499_ _7877_/A VGND VGND VPWR VPWR _6885_/B sky130_fd_sc_hd__inv_2
XFILLER_105_234 VGND VGND VPWR VPWR sky130_fd_sc_hd__decap_3
X_8238_ _8322_/B _8237_/C _7784_/B VGND VGND VPWR VPWR _8239_/C sky130_fd_sc_hd__a21oi_2
XFILLER_105_278 VGND VGND VPWR VPWR sky130_fd_sc_hd__fill_2
XFILLER_121_738 VGND VGND VPWR VPWR sky130_fd_sc_hd__decap_3
X_8169_ _5584_/X _8170_/B _8309_/A VGND VGND VPWR VPWR _8169_/Y sky130_fd_sc_hd__o21ai_2
XFILLER_59_332 VGND VGND VPWR VPWR sky130_fd_sc_hd__decap_3
XFILLER_59_343 VGND VGND VPWR VPWR sky130_fd_sc_hd__decap_3
XFILLER_101_440 VGND VGND VPWR VPWR sky130_fd_sc_hd__fill_1
XFILLER_59_354 VGND VGND VPWR VPWR sky130_fd_sc_hd__decap_3
XFILLER_47_505 VGND VGND VPWR VPWR sky130_fd_sc_hd__decap_3
XFILLER_86_151 VGND VGND VPWR VPWR sky130_fd_sc_hd__fill_2
XFILLER_86_162 VGND VGND VPWR VPWR sky130_fd_sc_hd__decap_3
XFILLER_59_387 VGND VGND VPWR VPWR sky130_fd_sc_hd__decap_3
XFILLER_47_527 VGND VGND VPWR VPWR sky130_fd_sc_hd__decap_3
XFILLER_47_44 VGND VGND VPWR VPWR sky130_fd_sc_hd__decap_3
XFILLER_101_484 VGND VGND VPWR VPWR sky130_fd_sc_hd__fill_1
XFILLER_74_324 VGND VGND VPWR VPWR sky130_fd_sc_hd__decap_3
XFILLER_28_741 VGND VGND VPWR VPWR sky130_fd_sc_hd__fill_2
XFILLER_74_368 VGND VGND VPWR VPWR sky130_fd_sc_hd__decap_3
XFILLER_62_508 VGND VGND VPWR VPWR sky130_fd_sc_hd__decap_3
XFILLER_28_763 VGND VGND VPWR VPWR sky130_fd_sc_hd__decap_3
XTAP_TAPCELL_ROW_87_1450 VGND VPWR sky130_fd_sc_hd__tapvpwrvgnd_1
XTAP_TAPCELL_ROW_87_1461 VGND VPWR sky130_fd_sc_hd__tapvpwrvgnd_1
XFILLER_43_700 VGND VGND VPWR VPWR sky130_fd_sc_hd__decap_3
XFILLER_15_402 VGND VGND VPWR VPWR sky130_fd_sc_hd__decap_3
XFILLER_63_10 VGND VGND VPWR VPWR sky130_fd_sc_hd__decap_3
XFILLER_55_582 VGND VGND VPWR VPWR sky130_fd_sc_hd__fill_1
XFILLER_43_722 VGND VGND VPWR VPWR sky130_fd_sc_hd__decap_3
XFILLER_27_273 VGND VGND VPWR VPWR sky130_fd_sc_hd__decap_3
XFILLER_42_210 VGND VGND VPWR VPWR sky130_fd_sc_hd__decap_3
XTAP_TAPCELL_ROW_38_791 VGND VPWR sky130_fd_sc_hd__tapvpwrvgnd_1
XFILLER_70_541 VGND VGND VPWR VPWR sky130_fd_sc_hd__decap_3
XFILLER_63_43 VGND VGND VPWR VPWR sky130_fd_sc_hd__fill_2
XFILLER_43_755 VGND VGND VPWR VPWR sky130_fd_sc_hd__decap_3
XFILLER_70_563 VGND VGND VPWR VPWR sky130_fd_sc_hd__decap_3
XFILLER_15_479 VGND VGND VPWR VPWR sky130_fd_sc_hd__decap_3
XFILLER_70_585 VGND VGND VPWR VPWR sky130_fd_sc_hd__decap_3
XFILLER_70_596 VGND VGND VPWR VPWR sky130_fd_sc_hd__fill_1
XFILLER_8_27 VGND VGND VPWR VPWR sky130_fd_sc_hd__fill_1
XFILLER_30_449 VGND VGND VPWR VPWR sky130_fd_sc_hd__decap_3
Xclkbuf_leaf_22_clk clkbuf_leaf_9_clk/A VGND VGND VPWR VPWR _9232_/CLK sky130_fd_sc_hd__clkbuf_8
XFILLER_8_38 VGND VGND VPWR VPWR sky130_fd_sc_hd__decap_3
XFILLER_11_652 VGND VGND VPWR VPWR sky130_fd_sc_hd__decap_3
XFILLER_7_623 VGND VGND VPWR VPWR sky130_fd_sc_hd__decap_3
XFILLER_11_696 VGND VGND VPWR VPWR sky130_fd_sc_hd__decap_3
XFILLER_7_656 VGND VGND VPWR VPWR sky130_fd_sc_hd__decap_3
XFILLER_109_551 VGND VGND VPWR VPWR sky130_fd_sc_hd__decap_3
XFILLER_6_144 VGND VGND VPWR VPWR sky130_fd_sc_hd__decap_3
XFILLER_7_689 VGND VGND VPWR VPWR sky130_fd_sc_hd__decap_3
XFILLER_128_80 VGND VGND VPWR VPWR sky130_fd_sc_hd__decap_3
XFILLER_128_91 VGND VGND VPWR VPWR sky130_fd_sc_hd__decap_3
XFILLER_124_576 VGND VGND VPWR VPWR sky130_fd_sc_hd__decap_3
XFILLER_112_716 VGND VGND VPWR VPWR sky130_fd_sc_hd__decap_3
XFILLER_124_587 VGND VGND VPWR VPWR sky130_fd_sc_hd__fill_1
XFILLER_111_215 VGND VGND VPWR VPWR sky130_fd_sc_hd__decap_3
XFILLER_97_449 VGND VGND VPWR VPWR sky130_fd_sc_hd__decap_3
XFILLER_78_630 VGND VGND VPWR VPWR sky130_fd_sc_hd__decap_3
XFILLER_78_674 VGND VGND VPWR VPWR sky130_fd_sc_hd__decap_3
XFILLER_77_151 VGND VGND VPWR VPWR sky130_fd_sc_hd__fill_2
XFILLER_38_505 VGND VGND VPWR VPWR sky130_fd_sc_hd__decap_3
XFILLER_120_760 VGND VGND VPWR VPWR sky130_fd_sc_hd__decap_3
XFILLER_77_162 VGND VGND VPWR VPWR sky130_fd_sc_hd__decap_3
XFILLER_65_302 VGND VGND VPWR VPWR sky130_fd_sc_hd__decap_3
XPHY_EDGE_ROW_108_Left_239 VGND VGND VPWR VPWR sky130_fd_sc_hd__decap_3
XFILLER_65_313 VGND VGND VPWR VPWR sky130_fd_sc_hd__fill_1
XFILLER_93_655 VGND VGND VPWR VPWR sky130_fd_sc_hd__decap_3
XFILLER_65_346 VGND VGND VPWR VPWR sky130_fd_sc_hd__decap_3
XFILLER_19_741 VGND VGND VPWR VPWR sky130_fd_sc_hd__decap_3
XFILLER_53_508 VGND VGND VPWR VPWR sky130_fd_sc_hd__decap_3
XFILLER_18_240 VGND VGND VPWR VPWR sky130_fd_sc_hd__decap_3
XFILLER_93_688 VGND VGND VPWR VPWR sky130_fd_sc_hd__decap_3
XFILLER_65_379 VGND VGND VPWR VPWR sky130_fd_sc_hd__fill_1
XFILLER_19_774 VGND VGND VPWR VPWR sky130_fd_sc_hd__decap_3
XFILLER_92_187 VGND VGND VPWR VPWR sky130_fd_sc_hd__fill_1
XFILLER_46_582 VGND VGND VPWR VPWR sky130_fd_sc_hd__decap_3
X_5870_ _9205_/Q _6246_/A _7604_/A VGND VGND VPWR VPWR _5870_/X sky130_fd_sc_hd__or3_2
XFILLER_34_766 VGND VGND VPWR VPWR sky130_fd_sc_hd__decap_3
X_4821_ _4842_/A VGND VGND VPWR VPWR _4840_/S sky130_fd_sc_hd__clkbuf_2
XFILLER_33_265 VGND VGND VPWR VPWR sky130_fd_sc_hd__fill_2
X_7540_ _7881_/C _7715_/B _7716_/A VGND VGND VPWR VPWR _7540_/X sky130_fd_sc_hd__a21o_2
XFILLER_21_438 VGND VGND VPWR VPWR sky130_fd_sc_hd__fill_1
X_4752_ _9123_/Q _4752_/A1 _4756_/S VGND VGND VPWR VPWR _4752_/X sky130_fd_sc_hd__mux2_2
XTAP_TAPCELL_ROW_16_496 VGND VPWR sky130_fd_sc_hd__tapvpwrvgnd_1
Xclkbuf_leaf_13_clk clkbuf_leaf_9_clk/A VGND VGND VPWR VPWR _9341_/CLK sky130_fd_sc_hd__clkbuf_8
XPHY_EDGE_ROW_117_Left_248 VGND VGND VPWR VPWR sky130_fd_sc_hd__decap_3
XFILLER_119_315 VGND VGND VPWR VPWR sky130_fd_sc_hd__decap_3
X_7471_ _9215_/Q VGND VGND VPWR VPWR _7836_/A sky130_fd_sc_hd__inv_2
XFILLER_119_326 VGND VGND VPWR VPWR sky130_fd_sc_hd__decap_3
X_4683_ _4717_/A1 _4683_/A1 _4693_/S VGND VGND VPWR VPWR _4684_/A sky130_fd_sc_hd__mux2_2
XFILLER_119_337 VGND VGND VPWR VPWR sky130_fd_sc_hd__decap_3
X_6422_ _6422_/A _6422_/B VGND VGND VPWR VPWR _6423_/B sky130_fd_sc_hd__xnor2_2
X_9210_ _9215_/CLK _9210_/D fanout418/X VGND VGND VPWR VPWR _9210_/Q sky130_fd_sc_hd__dfrtp_2
X_9141_ _9159_/CLK _9141_/D fanout391/X VGND VGND VPWR VPWR _9141_/Q sky130_fd_sc_hd__dfrtp_2
XFILLER_115_510 VGND VGND VPWR VPWR sky130_fd_sc_hd__decap_3
X_6353_ _6942_/A _8237_/A VGND VGND VPWR VPWR _6353_/Y sky130_fd_sc_hd__nand2_2
XFILLER_127_370 VGND VGND VPWR VPWR sky130_fd_sc_hd__decap_3
XFILLER_115_543 VGND VGND VPWR VPWR sky130_fd_sc_hd__decap_3
X_5304_ _5452_/C _5452_/B VGND VGND VPWR VPWR _5493_/A sky130_fd_sc_hd__xor2_2
XTAP_TAPCELL_ROW_58_1062 VGND VPWR sky130_fd_sc_hd__tapvpwrvgnd_1
X_9072_ _9293_/CLK _9072_/D fanout381/X VGND VGND VPWR VPWR _9072_/Q sky130_fd_sc_hd__dfrtp_2
XFILLER_103_716 VGND VGND VPWR VPWR sky130_fd_sc_hd__decap_3
X_6284_ _5975_/A _5975_/B _6939_/A VGND VGND VPWR VPWR _6285_/B sky130_fd_sc_hd__a21oi_2
XFILLER_0_309 VGND VGND VPWR VPWR sky130_fd_sc_hd__decap_3
X_8023_ _7889_/A _8016_/X _8017_/X _8010_/A _8022_/X VGND VGND VPWR VPWR _8023_/X
+ sky130_fd_sc_hd__o221a_2
XFILLER_115_598 VGND VGND VPWR VPWR sky130_fd_sc_hd__decap_3
X_5235_ _5235_/A0 _5234_/Y _5530_/S VGND VGND VPWR VPWR _5235_/X sky130_fd_sc_hd__mux2_2
XTAP_TAPCELL_ROW_71_1240 VGND VPWR sky130_fd_sc_hd__tapvpwrvgnd_1
XFILLER_69_641 VGND VGND VPWR VPWR sky130_fd_sc_hd__decap_3
XFILLER_130_557 VGND VGND VPWR VPWR sky130_fd_sc_hd__decap_3
XPHY_EDGE_ROW_126_Left_257 VGND VGND VPWR VPWR sky130_fd_sc_hd__decap_3
XFILLER_124_27 VGND VGND VPWR VPWR sky130_fd_sc_hd__fill_1
XFILLER_130_579 VGND VGND VPWR VPWR sky130_fd_sc_hd__decap_3
XFILLER_124_38 VGND VGND VPWR VPWR sky130_fd_sc_hd__decap_3
XFILLER_29_505 VGND VGND VPWR VPWR sky130_fd_sc_hd__decap_3
XFILLER_110_281 VGND VGND VPWR VPWR sky130_fd_sc_hd__decap_3
X_5097_ _6436_/B VGND VGND VPWR VPWR _5097_/X sky130_fd_sc_hd__clkbuf_1
XFILLER_83_143 VGND VGND VPWR VPWR sky130_fd_sc_hd__decap_3
XFILLER_56_368 VGND VGND VPWR VPWR sky130_fd_sc_hd__decap_3
X_8925_ _9305_/Q hold914/X _8925_/S VGND VGND VPWR VPWR _8925_/X sky130_fd_sc_hd__mux2_2
XFILLER_25_722 VGND VGND VPWR VPWR sky130_fd_sc_hd__decap_3
XTAP_TAPCELL_ROW_123_1937 VGND VPWR sky130_fd_sc_hd__tapvpwrvgnd_1
X_8856_ hold970/X hold976/X _8862_/S VGND VGND VPWR VPWR _8857_/A sky130_fd_sc_hd__mux2_2
XTAP_TAPCELL_ROW_123_1948 VGND VPWR sky130_fd_sc_hd__tapvpwrvgnd_1
XTAP_TAPCELL_ROW_35_750 VGND VPWR sky130_fd_sc_hd__tapvpwrvgnd_1
X_7807_ _7802_/X _7803_/Y _7807_/S VGND VGND VPWR VPWR _7807_/X sky130_fd_sc_hd__mux2_2
XFILLER_24_265 VGND VGND VPWR VPWR sky130_fd_sc_hd__decap_3
X_5999_ _5999_/A _5999_/B VGND VGND VPWR VPWR _6680_/B sky130_fd_sc_hd__nand2_4
X_8787_ _9239_/Q hold753/X _8799_/S VGND VGND VPWR VPWR _8787_/X sky130_fd_sc_hd__mux2_2
XFILLER_40_725 VGND VGND VPWR VPWR sky130_fd_sc_hd__fill_2
X_7738_ _7738_/A _7738_/B VGND VGND VPWR VPWR _7739_/B sky130_fd_sc_hd__xnor2_2
XTAP_TAPCELL_ROW_82_1391 VGND VPWR sky130_fd_sc_hd__tapvpwrvgnd_1
XFILLER_33_57 VGND VGND VPWR VPWR sky130_fd_sc_hd__decap_3
XFILLER_130_6 VGND VGND VPWR VPWR sky130_fd_sc_hd__decap_3
XFILLER_20_460 VGND VGND VPWR VPWR sky130_fd_sc_hd__decap_3
X_7669_ _7670_/A _7670_/B VGND VGND VPWR VPWR _7669_/X sky130_fd_sc_hd__or2_2
X_9339_ _9339_/CLK _9339_/D load_slew386/X VGND VGND VPWR VPWR _9339_/Q sky130_fd_sc_hd__dfrtp_2
XFILLER_109_3 VGND VGND VPWR VPWR sky130_fd_sc_hd__decap_3
XFILLER_3_125 VGND VGND VPWR VPWR sky130_fd_sc_hd__decap_3
XFILLER_118_392 VGND VGND VPWR VPWR sky130_fd_sc_hd__fill_2
XFILLER_106_554 VGND VGND VPWR VPWR sky130_fd_sc_hd__decap_3
XFILLER_121_502 VGND VGND VPWR VPWR sky130_fd_sc_hd__fill_2
XFILLER_106_587 VGND VGND VPWR VPWR sky130_fd_sc_hd__fill_1
XFILLER_106_598 VGND VGND VPWR VPWR sky130_fd_sc_hd__decap_3
XFILLER_79_449 VGND VGND VPWR VPWR sky130_fd_sc_hd__fill_2
XFILLER_121_557 VGND VGND VPWR VPWR sky130_fd_sc_hd__decap_3
XFILLER_102_760 VGND VGND VPWR VPWR sky130_fd_sc_hd__fill_1
XFILLER_87_460 VGND VGND VPWR VPWR sky130_fd_sc_hd__decap_3
XFILLER_75_600 VGND VGND VPWR VPWR sky130_fd_sc_hd__decap_3
XFILLER_59_184 VGND VGND VPWR VPWR sky130_fd_sc_hd__decap_3
XFILLER_101_281 VGND VGND VPWR VPWR sky130_fd_sc_hd__decap_3
XFILLER_47_357 VGND VGND VPWR VPWR sky130_fd_sc_hd__decap_3
XFILLER_114_71 VGND VGND VPWR VPWR sky130_fd_sc_hd__decap_3
XFILLER_74_165 VGND VGND VPWR VPWR sky130_fd_sc_hd__fill_2
XFILLER_90_636 VGND VGND VPWR VPWR sky130_fd_sc_hd__decap_3
XFILLER_62_327 VGND VGND VPWR VPWR sky130_fd_sc_hd__decap_3
XFILLER_16_722 VGND VGND VPWR VPWR sky130_fd_sc_hd__decap_3
XFILLER_62_349 VGND VGND VPWR VPWR sky130_fd_sc_hd__decap_3
XFILLER_15_221 VGND VGND VPWR VPWR sky130_fd_sc_hd__decap_3
XFILLER_16_755 VGND VGND VPWR VPWR sky130_fd_sc_hd__fill_1
XFILLER_43_552 VGND VGND VPWR VPWR sky130_fd_sc_hd__decap_3
XFILLER_16_766 VGND VGND VPWR VPWR sky130_fd_sc_hd__decap_3
XFILLER_30_202 VGND VGND VPWR VPWR sky130_fd_sc_hd__decap_3
XFILLER_15_276 VGND VGND VPWR VPWR sky130_fd_sc_hd__decap_3
XFILLER_130_81 VGND VGND VPWR VPWR sky130_fd_sc_hd__decap_3
XFILLER_31_769 VGND VGND VPWR VPWR sky130_fd_sc_hd__decap_3
XFILLER_90_74 VGND VGND VPWR VPWR sky130_fd_sc_hd__decap_3
XTAP_TAPCELL_ROW_13_455 VGND VPWR sky130_fd_sc_hd__tapvpwrvgnd_1
XFILLER_90_85 VGND VGND VPWR VPWR sky130_fd_sc_hd__decap_3
XFILLER_30_268 VGND VGND VPWR VPWR sky130_fd_sc_hd__decap_3
XFILLER_129_635 VGND VGND VPWR VPWR sky130_fd_sc_hd__decap_3
XFILLER_128_112 VGND VGND VPWR VPWR sky130_fd_sc_hd__decap_3
Xwire340 _5804_/B VGND VGND VPWR VPWR _5664_/A sky130_fd_sc_hd__clkbuf_4
XFILLER_129_668 VGND VGND VPWR VPWR sky130_fd_sc_hd__decap_3
XFILLER_129_679 VGND VGND VPWR VPWR sky130_fd_sc_hd__decap_3
XFILLER_128_156 VGND VGND VPWR VPWR sky130_fd_sc_hd__decap_3
Xmax_cap106 _7775_/A VGND VGND VPWR VPWR _8233_/B2 sky130_fd_sc_hd__clkbuf_2
XFILLER_116_318 VGND VGND VPWR VPWR sky130_fd_sc_hd__fill_1
XFILLER_128_189 VGND VGND VPWR VPWR sky130_fd_sc_hd__decap_3
XFILLER_109_381 VGND VGND VPWR VPWR sky130_fd_sc_hd__decap_3
Xmax_cap139 _7186_/X VGND VGND VPWR VPWR _7670_/A sky130_fd_sc_hd__buf_2
XFILLER_124_351 VGND VGND VPWR VPWR sky130_fd_sc_hd__decap_3
XFILLER_98_736 VGND VGND VPWR VPWR sky130_fd_sc_hd__decap_3
XFILLER_112_513 VGND VGND VPWR VPWR sky130_fd_sc_hd__decap_3
Xload_slew312 wire313/X VGND VGND VPWR VPWR _8210_/B sky130_fd_sc_hd__clkbuf_4
Xload_slew323 _6425_/S VGND VGND VPWR VPWR _7174_/A sky130_fd_sc_hd__buf_4
Xload_slew345 _6416_/B VGND VGND VPWR VPWR _5507_/A sky130_fd_sc_hd__buf_4
XFILLER_112_557 VGND VGND VPWR VPWR sky130_fd_sc_hd__decap_3
X_5020_ _5103_/A _5103_/B _5103_/C _5019_/X _9239_/Q VGND VGND VPWR VPWR _5021_/A
+ sky130_fd_sc_hd__o32a_4
Xload_slew356 _6084_/A VGND VGND VPWR VPWR _6434_/B sky130_fd_sc_hd__buf_4
XFILLER_112_568 VGND VGND VPWR VPWR sky130_fd_sc_hd__decap_3
Xhold1109 _4822_/X VGND VGND VPWR VPWR _4823_/A sky130_fd_sc_hd__dlygate4sd3_1
Xclkbuf_leaf_2_clk clkload0/A VGND VGND VPWR VPWR clkload3/A sky130_fd_sc_hd__clkbuf_8
XFILLER_66_600 VGND VGND VPWR VPWR sky130_fd_sc_hd__decap_3
XFILLER_24_3 VGND VGND VPWR VPWR sky130_fd_sc_hd__decap_3
Xload_slew378 fanout377/X VGND VGND VPWR VPWR load_slew378/X sky130_fd_sc_hd__buf_4
XFILLER_38_302 VGND VGND VPWR VPWR sky130_fd_sc_hd__decap_3
XFILLER_38_313 VGND VGND VPWR VPWR sky130_fd_sc_hd__decap_3
XPHY_EDGE_ROW_119_Right_119 VGND VGND VPWR VPWR sky130_fd_sc_hd__decap_3
XFILLER_38_335 VGND VGND VPWR VPWR sky130_fd_sc_hd__fill_2
XFILLER_38_346 VGND VGND VPWR VPWR sky130_fd_sc_hd__decap_3
XFILLER_93_452 VGND VGND VPWR VPWR sky130_fd_sc_hd__decap_3
XFILLER_38_368 VGND VGND VPWR VPWR sky130_fd_sc_hd__decap_3
XFILLER_66_688 VGND VGND VPWR VPWR sky130_fd_sc_hd__decap_3
X_6971_ _6971_/A _7083_/A VGND VGND VPWR VPWR _6975_/A sky130_fd_sc_hd__nand2_2
XFILLER_93_485 VGND VGND VPWR VPWR sky130_fd_sc_hd__decap_3
XFILLER_0_50 VGND VGND VPWR VPWR sky130_fd_sc_hd__decap_3
X_8710_ _8721_/B _8710_/B VGND VGND VPWR VPWR _8710_/X sky130_fd_sc_hd__xor2_2
X_5922_ _5922_/A VGND VGND VPWR VPWR _5922_/Y sky130_fd_sc_hd__inv_2
XFILLER_53_349 VGND VGND VPWR VPWR sky130_fd_sc_hd__decap_3
XFILLER_34_530 VGND VGND VPWR VPWR sky130_fd_sc_hd__fill_2
XFILLER_110_18 VGND VGND VPWR VPWR sky130_fd_sc_hd__decap_3
X_5853_ _6033_/A _6033_/B VGND VGND VPWR VPWR _7430_/C sky130_fd_sc_hd__and2_2
X_8641_ wire110/X _8639_/Y _8640_/X VGND VGND VPWR VPWR _9228_/D sky130_fd_sc_hd__a21oi_2
XFILLER_110_29 VGND VGND VPWR VPWR sky130_fd_sc_hd__decap_3
XFILLER_22_725 VGND VGND VPWR VPWR sky130_fd_sc_hd__decap_3
XFILLER_61_382 VGND VGND VPWR VPWR sky130_fd_sc_hd__decap_3
X_4804_ _4804_/A VGND VGND VPWR VPWR _9147_/D sky130_fd_sc_hd__buf_1
XTAP_TAPCELL_ROW_32_720 VGND VPWR sky130_fd_sc_hd__tapvpwrvgnd_1
XFILLER_61_393 VGND VGND VPWR VPWR sky130_fd_sc_hd__decap_3
X_5784_ _6873_/A _5936_/A _5790_/A VGND VGND VPWR VPWR _5784_/X sky130_fd_sc_hd__mux2_2
X_8572_ _8572_/A _8572_/B VGND VGND VPWR VPWR _8573_/B sky130_fd_sc_hd__xnor2_2
XFILLER_22_769 VGND VGND VPWR VPWR sky130_fd_sc_hd__decap_3
X_4735_ _9115_/Q hold860/X _4735_/S VGND VGND VPWR VPWR _4735_/X sky130_fd_sc_hd__mux2_2
X_7523_ _7233_/A _7520_/Y _7521_/Y _7522_/X VGND VGND VPWR VPWR _7523_/X sky130_fd_sc_hd__o211a_2
Xrebuffer506 _4516_/X VGND VGND VPWR VPWR _9179_/D sky130_fd_sc_hd__buf_2
Xrebuffer517 _7077_/X VGND VGND VPWR VPWR _7349_/A1 sky130_fd_sc_hd__buf_2
Xrebuffer528 _6681_/A2 VGND VGND VPWR VPWR _7612_/A2 sky130_fd_sc_hd__buf_2
XFILLER_119_134 VGND VGND VPWR VPWR sky130_fd_sc_hd__decap_3
Xrebuffer539 _6172_/B VGND VGND VPWR VPWR _6169_/B sky130_fd_sc_hd__buf_2
XFILLER_119_27 VGND VGND VPWR VPWR sky130_fd_sc_hd__decap_3
X_7454_ _7454_/A _7454_/B _7454_/C VGND VGND VPWR VPWR _7454_/X sky130_fd_sc_hd__and3_2
XFILLER_119_156 VGND VGND VPWR VPWR sky130_fd_sc_hd__decap_3
X_4666_ hold874/X hold946/X _4672_/S VGND VGND VPWR VPWR _4667_/A sky130_fd_sc_hd__mux2_2
XFILLER_119_178 VGND VGND VPWR VPWR sky130_fd_sc_hd__decap_3
X_6405_ _5950_/A _5935_/X _6085_/X _5656_/A VGND VGND VPWR VPWR _6405_/X sky130_fd_sc_hd__a211o_2
X_7385_ _7385_/A _7385_/B VGND VGND VPWR VPWR _7385_/Y sky130_fd_sc_hd__nor2_2
Xhold910 _9153_/Q VGND VGND VPWR VPWR hold910/X sky130_fd_sc_hd__dlygate4sd3_1
XFILLER_128_690 VGND VGND VPWR VPWR sky130_fd_sc_hd__decap_3
X_4597_ _4597_/A VGND VGND VPWR VPWR _9049_/D sky130_fd_sc_hd__buf_1
Xhold921 _4654_/X VGND VGND VPWR VPWR _4655_/A sky130_fd_sc_hd__dlygate4sd3_1
Xhold932 _9339_/Q VGND VGND VPWR VPWR hold932/X sky130_fd_sc_hd__dlygate4sd3_1
Xhold943 _4857_/X VGND VGND VPWR VPWR _4858_/A sky130_fd_sc_hd__dlygate4sd3_1
X_6336_ _9283_/Q _6336_/B _6336_/C VGND VGND VPWR VPWR _6336_/X sky130_fd_sc_hd__and3_2
Xhold954 _9177_/Q VGND VGND VPWR VPWR hold954/X sky130_fd_sc_hd__dlygate4sd3_1
X_9124_ _9344_/CLK _9124_/D fanout379/X VGND VGND VPWR VPWR _9124_/Q sky130_fd_sc_hd__dfrtp_2
XFILLER_89_703 VGND VGND VPWR VPWR sky130_fd_sc_hd__decap_3
XFILLER_115_340 VGND VGND VPWR VPWR sky130_fd_sc_hd__decap_3
Xhold965 _4600_/X VGND VGND VPWR VPWR _4601_/A sky130_fd_sc_hd__dlygate4sd3_1
Xhold976 _9256_/Q VGND VGND VPWR VPWR hold976/X sky130_fd_sc_hd__dlygate4sd3_1
XFILLER_1_629 VGND VGND VPWR VPWR sky130_fd_sc_hd__decap_3
Xhold987 _9200_/Q VGND VGND VPWR VPWR hold987/X sky130_fd_sc_hd__dlygate4sd3_1
XFILLER_103_535 VGND VGND VPWR VPWR sky130_fd_sc_hd__decap_3
Xhold998 _9114_/Q VGND VGND VPWR VPWR hold998/X sky130_fd_sc_hd__dlygate4sd3_1
X_9055_ _9135_/CLK _9055_/D load_slew384/X VGND VGND VPWR VPWR _9055_/Q sky130_fd_sc_hd__dfrtp_2
XFILLER_88_224 VGND VGND VPWR VPWR sky130_fd_sc_hd__fill_1
X_6267_ _6070_/A _6387_/A _6387_/B VGND VGND VPWR VPWR _6267_/X sky130_fd_sc_hd__o21a_2
XFILLER_130_321 VGND VGND VPWR VPWR sky130_fd_sc_hd__decap_3
XFILLER_130_343 VGND VGND VPWR VPWR sky130_fd_sc_hd__decap_3
XFILLER_103_579 VGND VGND VPWR VPWR sky130_fd_sc_hd__decap_3
X_5218_ _6490_/A VGND VGND VPWR VPWR _7676_/C sky130_fd_sc_hd__clkbuf_2
X_8006_ _8006_/A _8006_/B _8006_/C VGND VGND VPWR VPWR _8007_/S sky130_fd_sc_hd__and3_2
XFILLER_130_365 VGND VGND VPWR VPWR sky130_fd_sc_hd__decap_3
X_6198_ _6198_/A _6198_/B VGND VGND VPWR VPWR _6290_/A sky130_fd_sc_hd__xnor2_4
XFILLER_69_471 VGND VGND VPWR VPWR sky130_fd_sc_hd__decap_3
X_5149_ _9198_/Q _5167_/B VGND VGND VPWR VPWR _5149_/X sky130_fd_sc_hd__and2_2
XFILLER_57_644 VGND VGND VPWR VPWR sky130_fd_sc_hd__decap_3
XFILLER_29_335 VGND VGND VPWR VPWR sky130_fd_sc_hd__fill_1
XFILLER_28_68 VGND VGND VPWR VPWR sky130_fd_sc_hd__decap_3
XFILLER_84_452 VGND VGND VPWR VPWR sky130_fd_sc_hd__decap_3
XFILLER_29_368 VGND VGND VPWR VPWR sky130_fd_sc_hd__decap_3
XFILLER_17_508 VGND VGND VPWR VPWR sky130_fd_sc_hd__decap_3
XFILLER_71_113 VGND VGND VPWR VPWR sky130_fd_sc_hd__fill_1
XTAP_TAPCELL_ROW_84_1420 VGND VPWR sky130_fd_sc_hd__tapvpwrvgnd_1
X_8908_ _8908_/A VGND VGND VPWR VPWR _9296_/D sky130_fd_sc_hd__buf_1
XFILLER_72_658 VGND VGND VPWR VPWR sky130_fd_sc_hd__decap_3
XFILLER_13_703 VGND VGND VPWR VPWR sky130_fd_sc_hd__decap_3
XFILLER_71_179 VGND VGND VPWR VPWR sky130_fd_sc_hd__decap_3
X_8839_ _9264_/Q _8839_/A1 _8841_/S VGND VGND VPWR VPWR _8839_/X sky130_fd_sc_hd__mux2_2
XFILLER_40_500 VGND VGND VPWR VPWR sky130_fd_sc_hd__decap_3
XFILLER_40_533 VGND VGND VPWR VPWR sky130_fd_sc_hd__decap_3
XFILLER_13_747 VGND VGND VPWR VPWR sky130_fd_sc_hd__decap_3
XFILLER_52_393 VGND VGND VPWR VPWR sky130_fd_sc_hd__decap_3
XFILLER_9_718 VGND VGND VPWR VPWR sky130_fd_sc_hd__decap_3
XFILLER_12_235 VGND VGND VPWR VPWR sky130_fd_sc_hd__decap_3
XFILLER_9_729 VGND VGND VPWR VPWR sky130_fd_sc_hd__decap_3
XFILLER_40_566 VGND VGND VPWR VPWR sky130_fd_sc_hd__fill_1
XFILLER_12_268 VGND VGND VPWR VPWR sky130_fd_sc_hd__decap_3
XFILLER_40_599 VGND VGND VPWR VPWR sky130_fd_sc_hd__decap_3
XTAP_TAPCELL_ROW_10_414 VGND VPWR sky130_fd_sc_hd__tapvpwrvgnd_1
XFILLER_60_88 VGND VGND VPWR VPWR sky130_fd_sc_hd__decap_3
XFILLER_126_627 VGND VGND VPWR VPWR sky130_fd_sc_hd__decap_3
XFILLER_119_690 VGND VGND VPWR VPWR sky130_fd_sc_hd__decap_3
XFILLER_125_137 VGND VGND VPWR VPWR sky130_fd_sc_hd__decap_3
XFILLER_109_60 VGND VGND VPWR VPWR sky130_fd_sc_hd__decap_3
XFILLER_5_39 VGND VGND VPWR VPWR sky130_fd_sc_hd__decap_3
XTAP_TAPCELL_ROW_95_1560 VGND VPWR sky130_fd_sc_hd__tapvpwrvgnd_1
XFILLER_106_362 VGND VGND VPWR VPWR sky130_fd_sc_hd__fill_2
XFILLER_121_332 VGND VGND VPWR VPWR sky130_fd_sc_hd__decap_3
XFILLER_121_343 VGND VGND VPWR VPWR sky130_fd_sc_hd__decap_3
XFILLER_0_651 VGND VGND VPWR VPWR sky130_fd_sc_hd__decap_3
XFILLER_0_673 VGND VGND VPWR VPWR sky130_fd_sc_hd__decap_3
XFILLER_121_387 VGND VGND VPWR VPWR sky130_fd_sc_hd__decap_3
XFILLER_94_227 VGND VGND VPWR VPWR sky130_fd_sc_hd__decap_3
XFILLER_125_81 VGND VGND VPWR VPWR sky130_fd_sc_hd__decap_3
XFILLER_48_633 VGND VGND VPWR VPWR sky130_fd_sc_hd__decap_3
XFILLER_10_9 VGND VGND VPWR VPWR sky130_fd_sc_hd__decap_3
XFILLER_47_132 VGND VGND VPWR VPWR sky130_fd_sc_hd__decap_3
XFILLER_75_452 VGND VGND VPWR VPWR sky130_fd_sc_hd__decap_3
XFILLER_35_305 VGND VGND VPWR VPWR sky130_fd_sc_hd__fill_1
XFILLER_75_485 VGND VGND VPWR VPWR sky130_fd_sc_hd__decap_3
XFILLER_62_102 VGND VGND VPWR VPWR sky130_fd_sc_hd__fill_1
XFILLER_47_187 VGND VGND VPWR VPWR sky130_fd_sc_hd__decap_3
XTAP_TAPCELL_ROW_18_525 VGND VPWR sky130_fd_sc_hd__tapvpwrvgnd_1
XFILLER_90_433 VGND VGND VPWR VPWR sky130_fd_sc_hd__decap_3
XFILLER_35_349 VGND VGND VPWR VPWR sky130_fd_sc_hd__decap_3
XFILLER_16_530 VGND VGND VPWR VPWR sky130_fd_sc_hd__fill_2
XFILLER_62_157 VGND VGND VPWR VPWR sky130_fd_sc_hd__fill_1
XFILLER_16_552 VGND VGND VPWR VPWR sky130_fd_sc_hd__decap_3
XFILLER_71_680 VGND VGND VPWR VPWR sky130_fd_sc_hd__decap_3
XFILLER_16_585 VGND VGND VPWR VPWR sky130_fd_sc_hd__decap_3
XFILLER_93_6 VGND VGND VPWR VPWR sky130_fd_sc_hd__fill_1
XFILLER_43_393 VGND VGND VPWR VPWR sky130_fd_sc_hd__decap_3
XFILLER_31_577 VGND VGND VPWR VPWR sky130_fd_sc_hd__decap_3
XFILLER_8_740 VGND VGND VPWR VPWR sky130_fd_sc_hd__decap_3
X_4520_ _5175_/B VGND VGND VPWR VPWR _5469_/B sky130_fd_sc_hd__clkbuf_1
XFILLER_11_290 VGND VGND VPWR VPWR sky130_fd_sc_hd__decap_3
XFILLER_117_627 VGND VGND VPWR VPWR sky130_fd_sc_hd__fill_2
Xwire170 _5352_/Y VGND VGND VPWR VPWR _6279_/C sky130_fd_sc_hd__clkbuf_2
XFILLER_129_498 VGND VGND VPWR VPWR sky130_fd_sc_hd__fill_1
XFILLER_116_115 VGND VGND VPWR VPWR sky130_fd_sc_hd__decap_3
X_7170_ _6825_/A _6871_/B _7170_/S VGND VGND VPWR VPWR _7170_/X sky130_fd_sc_hd__mux2_2
XTAP_TAPCELL_ROW_55_1021 VGND VPWR sky130_fd_sc_hd__tapvpwrvgnd_1
X_6121_ _6131_/A _6446_/B VGND VGND VPWR VPWR _6438_/B sky130_fd_sc_hd__xor2_2
XFILLER_124_192 VGND VGND VPWR VPWR sky130_fd_sc_hd__decap_3
XFILLER_98_577 VGND VGND VPWR VPWR sky130_fd_sc_hd__decap_3
XFILLER_86_717 VGND VGND VPWR VPWR sky130_fd_sc_hd__decap_3
X_6052_ _6052_/A _6151_/A VGND VGND VPWR VPWR _6060_/A sky130_fd_sc_hd__xnor2_2
XPHY_EDGE_ROW_7_Right_7 VGND VGND VPWR VPWR sky130_fd_sc_hd__decap_3
X_5003_ _9099_/Q _5006_/B _6607_/C VGND VGND VPWR VPWR _5003_/X sky130_fd_sc_hd__and3_2
XFILLER_66_430 VGND VGND VPWR VPWR sky130_fd_sc_hd__decap_3
XFILLER_94_750 VGND VGND VPWR VPWR sky130_fd_sc_hd__decap_3
XFILLER_66_463 VGND VGND VPWR VPWR sky130_fd_sc_hd__decap_3
XFILLER_38_154 VGND VGND VPWR VPWR sky130_fd_sc_hd__decap_3
XTAP_TAPCELL_ROW_107_1729 VGND VPWR sky130_fd_sc_hd__tapvpwrvgnd_1
XFILLER_81_411 VGND VGND VPWR VPWR sky130_fd_sc_hd__fill_1
XFILLER_54_636 VGND VGND VPWR VPWR sky130_fd_sc_hd__decap_3
XFILLER_38_187 VGND VGND VPWR VPWR sky130_fd_sc_hd__decap_3
XFILLER_26_327 VGND VGND VPWR VPWR sky130_fd_sc_hd__fill_1
XFILLER_53_113 VGND VGND VPWR VPWR sky130_fd_sc_hd__decap_3
XFILLER_26_338 VGND VGND VPWR VPWR sky130_fd_sc_hd__decap_3
X_6954_ _5137_/A _6976_/C _6211_/A VGND VGND VPWR VPWR _6954_/X sky130_fd_sc_hd__a21o_2
XFILLER_81_455 VGND VGND VPWR VPWR sky130_fd_sc_hd__fill_1
XFILLER_121_39 VGND VGND VPWR VPWR sky130_fd_sc_hd__decap_3
XTAP_TAPCELL_ROW_120_1907 VGND VPWR sky130_fd_sc_hd__tapvpwrvgnd_1
XFILLER_81_477 VGND VGND VPWR VPWR sky130_fd_sc_hd__decap_3
X_5905_ _5905_/A _6143_/A VGND VGND VPWR VPWR _5973_/C sky130_fd_sc_hd__xnor2_2
XFILLER_41_319 VGND VGND VPWR VPWR sky130_fd_sc_hd__fill_1
XFILLER_22_500 VGND VGND VPWR VPWR sky130_fd_sc_hd__fill_1
XTAP_TAPCELL_ROW_66_1172 VGND VPWR sky130_fd_sc_hd__tapvpwrvgnd_1
X_6885_ _6885_/A _6885_/B _6886_/A VGND VGND VPWR VPWR _6887_/A sky130_fd_sc_hd__or3b_2
XFILLER_34_371 VGND VGND VPWR VPWR sky130_fd_sc_hd__decap_3
XFILLER_22_533 VGND VGND VPWR VPWR sky130_fd_sc_hd__decap_3
XFILLER_14_15 VGND VGND VPWR VPWR sky130_fd_sc_hd__decap_3
X_8624_ _8674_/A _8642_/A _8623_/Y VGND VGND VPWR VPWR _8624_/X sky130_fd_sc_hd__a21o_2
XFILLER_22_544 VGND VGND VPWR VPWR sky130_fd_sc_hd__decap_3
X_5836_ _5699_/A _5699_/B _5835_/X VGND VGND VPWR VPWR _5842_/A sky130_fd_sc_hd__a21oi_2
XFILLER_10_728 VGND VGND VPWR VPWR sky130_fd_sc_hd__decap_3
X_5767_ _5768_/B _5765_/X _5768_/C _5768_/A VGND VGND VPWR VPWR _5770_/A sky130_fd_sc_hd__o211a_2
X_8555_ _8572_/A _8555_/B VGND VGND VPWR VPWR _8555_/Y sky130_fd_sc_hd__nor2_2
X_7506_ _7507_/B _7507_/C _7507_/A VGND VGND VPWR VPWR _7506_/Y sky130_fd_sc_hd__o21ai_2
X_4718_ _4718_/A VGND VGND VPWR VPWR _9106_/D sky130_fd_sc_hd__buf_1
X_5698_ _5698_/A _6010_/A VGND VGND VPWR VPWR _5699_/B sky130_fd_sc_hd__nand2_2
X_8486_ _8486_/A _8486_/B VGND VGND VPWR VPWR _8486_/Y sky130_fd_sc_hd__nand2_2
XFILLER_30_25 VGND VGND VPWR VPWR sky130_fd_sc_hd__decap_3
XTAP_TAPCELL_ROW_118_1869 VGND VPWR sky130_fd_sc_hd__tapvpwrvgnd_1
X_4649_ _4649_/A VGND VGND VPWR VPWR _9074_/D sky130_fd_sc_hd__buf_1
X_7437_ _7436_/A _7436_/C _7436_/B _7436_/D VGND VGND VPWR VPWR _7624_/C sky130_fd_sc_hd__o22ai_2
X_7368_ _7124_/A _7366_/X _7367_/X VGND VGND VPWR VPWR _7369_/B sky130_fd_sc_hd__a21bo_2
Xhold751 input11/X VGND VGND VPWR VPWR hold751/X sky130_fd_sc_hd__dlygate4sd3_1
Xhold762 _8793_/X VGND VGND VPWR VPWR _8794_/A sky130_fd_sc_hd__dlygate4sd3_1
XFILLER_122_118 VGND VGND VPWR VPWR sky130_fd_sc_hd__decap_3
Xhold773 _5036_/X VGND VGND VPWR VPWR _5037_/A sky130_fd_sc_hd__dlygate4sd3_1
XFILLER_89_522 VGND VGND VPWR VPWR sky130_fd_sc_hd__decap_3
XFILLER_1_426 VGND VGND VPWR VPWR sky130_fd_sc_hd__decap_3
XFILLER_116_693 VGND VGND VPWR VPWR sky130_fd_sc_hd__decap_3
X_9107_ _9171_/CLK _9107_/D load_slew396/X VGND VGND VPWR VPWR _9107_/Q sky130_fd_sc_hd__dfrtp_2
X_6319_ _7099_/B _7430_/C _6212_/B VGND VGND VPWR VPWR _6319_/X sky130_fd_sc_hd__or3b_4
Xhold784 _9182_/Q VGND VGND VPWR VPWR hold784/X sky130_fd_sc_hd__dlygate4sd3_1
X_7299_ _7299_/A _7299_/B VGND VGND VPWR VPWR _7307_/A sky130_fd_sc_hd__xnor2_2
Xhold795 _9180_/Q VGND VGND VPWR VPWR hold795/X sky130_fd_sc_hd__dlygate4sd3_1
XFILLER_77_706 VGND VGND VPWR VPWR sky130_fd_sc_hd__decap_3
X_9038_ _9133_/CLK _9038_/D load_slew394/X VGND VGND VPWR VPWR _9038_/Q sky130_fd_sc_hd__dfrtp_2
XFILLER_89_599 VGND VGND VPWR VPWR sky130_fd_sc_hd__decap_3
XFILLER_76_216 VGND VGND VPWR VPWR sky130_fd_sc_hd__decap_3
XFILLER_130_162 VGND VGND VPWR VPWR sky130_fd_sc_hd__decap_3
XTAP_TAPCELL_ROW_90_1490 VGND VPWR sky130_fd_sc_hd__tapvpwrvgnd_1
XFILLER_39_78 VGND VGND VPWR VPWR sky130_fd_sc_hd__decap_3
XFILLER_29_110 VGND VGND VPWR VPWR sky130_fd_sc_hd__fill_2
XFILLER_130_184 VGND VGND VPWR VPWR sky130_fd_sc_hd__decap_3
XFILLER_29_121 VGND VGND VPWR VPWR sky130_fd_sc_hd__decap_3
XFILLER_92_709 VGND VGND VPWR VPWR sky130_fd_sc_hd__decap_3
XFILLER_85_750 VGND VGND VPWR VPWR sky130_fd_sc_hd__decap_3
XFILLER_57_452 VGND VGND VPWR VPWR sky130_fd_sc_hd__decap_3
XFILLER_85_772 VGND VGND VPWR VPWR sky130_fd_sc_hd__decap_3
XFILLER_45_603 VGND VGND VPWR VPWR sky130_fd_sc_hd__decap_3
XFILLER_17_316 VGND VGND VPWR VPWR sky130_fd_sc_hd__decap_3
XFILLER_72_411 VGND VGND VPWR VPWR sky130_fd_sc_hd__fill_1
XFILLER_57_485 VGND VGND VPWR VPWR sky130_fd_sc_hd__decap_3
XFILLER_84_282 VGND VGND VPWR VPWR sky130_fd_sc_hd__decap_3
XFILLER_44_124 VGND VGND VPWR VPWR sky130_fd_sc_hd__decap_3
XFILLER_72_455 VGND VGND VPWR VPWR sky130_fd_sc_hd__decap_3
XFILLER_72_477 VGND VGND VPWR VPWR sky130_fd_sc_hd__decap_3
XFILLER_44_168 VGND VGND VPWR VPWR sky130_fd_sc_hd__decap_3
XFILLER_32_319 VGND VGND VPWR VPWR sky130_fd_sc_hd__decap_3
XFILLER_53_680 VGND VGND VPWR VPWR sky130_fd_sc_hd__decap_3
XFILLER_25_371 VGND VGND VPWR VPWR sky130_fd_sc_hd__decap_3
XFILLER_71_21 VGND VGND VPWR VPWR sky130_fd_sc_hd__decap_3
XTAP_TAPCELL_ROW_43_859 VGND VPWR sky130_fd_sc_hd__tapvpwrvgnd_1
XFILLER_13_544 VGND VGND VPWR VPWR sky130_fd_sc_hd__fill_2
XFILLER_9_526 VGND VGND VPWR VPWR sky130_fd_sc_hd__fill_1
XFILLER_71_76 VGND VGND VPWR VPWR sky130_fd_sc_hd__fill_1
XTAP_TAPCELL_ROW_23_594 VGND VPWR sky130_fd_sc_hd__tapvpwrvgnd_1
XFILLER_5_721 VGND VGND VPWR VPWR sky130_fd_sc_hd__decap_3
XFILLER_5_732 VGND VGND VPWR VPWR sky130_fd_sc_hd__decap_3
XFILLER_126_468 VGND VGND VPWR VPWR sky130_fd_sc_hd__decap_3
XFILLER_5_765 VGND VGND VPWR VPWR sky130_fd_sc_hd__decap_3
XFILLER_107_660 VGND VGND VPWR VPWR sky130_fd_sc_hd__decap_3
XFILLER_106_170 VGND VGND VPWR VPWR sky130_fd_sc_hd__decap_3
XFILLER_20_91 VGND VGND VPWR VPWR sky130_fd_sc_hd__decap_3
XFILLER_106_192 VGND VGND VPWR VPWR sky130_fd_sc_hd__decap_3
XFILLER_121_140 VGND VGND VPWR VPWR sky130_fd_sc_hd__decap_3
XFILLER_68_728 VGND VGND VPWR VPWR sky130_fd_sc_hd__fill_1
XFILLER_122_696 VGND VGND VPWR VPWR sky130_fd_sc_hd__decap_3
XFILLER_95_547 VGND VGND VPWR VPWR sky130_fd_sc_hd__decap_3
XFILLER_121_184 VGND VGND VPWR VPWR sky130_fd_sc_hd__decap_3
XFILLER_82_208 VGND VGND VPWR VPWR sky130_fd_sc_hd__decap_3
XFILLER_76_772 VGND VGND VPWR VPWR sky130_fd_sc_hd__decap_3
XFILLER_75_260 VGND VGND VPWR VPWR sky130_fd_sc_hd__fill_1
XFILLER_48_474 VGND VGND VPWR VPWR sky130_fd_sc_hd__fill_2
XFILLER_48_496 VGND VGND VPWR VPWR sky130_fd_sc_hd__decap_3
XFILLER_63_433 VGND VGND VPWR VPWR sky130_fd_sc_hd__decap_3
XFILLER_51_617 VGND VGND VPWR VPWR sky130_fd_sc_hd__decap_3
XFILLER_35_179 VGND VGND VPWR VPWR sky130_fd_sc_hd__fill_2
XFILLER_44_680 VGND VGND VPWR VPWR sky130_fd_sc_hd__decap_3
X_6670_ _6670_/A _6670_/B VGND VGND VPWR VPWR _6670_/X sky130_fd_sc_hd__and2_2
XFILLER_91_3 VGND VGND VPWR VPWR sky130_fd_sc_hd__decap_3
XTAP_TAPCELL_ROW_102_1659 VGND VPWR sky130_fd_sc_hd__tapvpwrvgnd_1
X_5621_ _6232_/C _6231_/B _9262_/Q VGND VGND VPWR VPWR _5621_/X sky130_fd_sc_hd__and3b_2
XFILLER_31_363 VGND VGND VPWR VPWR sky130_fd_sc_hd__decap_3
XFILLER_31_385 VGND VGND VPWR VPWR sky130_fd_sc_hd__decap_3
XFILLER_129_240 VGND VGND VPWR VPWR sky130_fd_sc_hd__decap_3
X_5552_ _5552_/A _5552_/B VGND VGND VPWR VPWR _5553_/B sky130_fd_sc_hd__xnor2_2
X_8340_ _8178_/A _8177_/A _8137_/A VGND VGND VPWR VPWR _8340_/X sky130_fd_sc_hd__a21o_2
X_8271_ _8271_/A _8271_/B _8271_/C _8271_/D VGND VGND VPWR VPWR _8271_/X sky130_fd_sc_hd__and4_2
X_5483_ _5483_/A1 _5483_/A2 _5483_/A3 _5387_/Y VGND VGND VPWR VPWR _6279_/B sky130_fd_sc_hd__a31o_4
XFILLER_117_457 VGND VGND VPWR VPWR sky130_fd_sc_hd__decap_3
X_7222_ _5328_/B _6873_/Y _7181_/A VGND VGND VPWR VPWR _7222_/Y sky130_fd_sc_hd__o21ai_2
XFILLER_6_82 VGND VGND VPWR VPWR sky130_fd_sc_hd__fill_2
X_7153_ _7153_/A wire91/X VGND VGND VPWR VPWR _7153_/Y sky130_fd_sc_hd__xnor2_2
XFILLER_98_341 VGND VGND VPWR VPWR sky130_fd_sc_hd__decap_3
XFILLER_59_706 VGND VGND VPWR VPWR sky130_fd_sc_hd__decap_3
XFILLER_113_652 VGND VGND VPWR VPWR sky130_fd_sc_hd__decap_3
X_6104_ _6097_/X _6098_/X _6099_/Y _6103_/X _6416_/A VGND VGND VPWR VPWR _6449_/A
+ sky130_fd_sc_hd__a32o_2
X_7084_ _6972_/A _7417_/B _7430_/C _6963_/A VGND VGND VPWR VPWR _7086_/C sky130_fd_sc_hd__a211o_2
XFILLER_98_374 VGND VGND VPWR VPWR sky130_fd_sc_hd__decap_3
XFILLER_86_514 VGND VGND VPWR VPWR sky130_fd_sc_hd__decap_3
XFILLER_113_685 VGND VGND VPWR VPWR sky130_fd_sc_hd__decap_3
XFILLER_86_536 VGND VGND VPWR VPWR sky130_fd_sc_hd__decap_3
XFILLER_100_335 VGND VGND VPWR VPWR sky130_fd_sc_hd__fill_2
X_6035_ _6302_/A _6035_/B VGND VGND VPWR VPWR _6211_/B sky130_fd_sc_hd__nor2_2
XFILLER_39_463 VGND VGND VPWR VPWR sky130_fd_sc_hd__decap_3
XFILLER_27_603 VGND VGND VPWR VPWR sky130_fd_sc_hd__decap_3
XTAP_TAPCELL_ROW_68_1201 VGND VPWR sky130_fd_sc_hd__tapvpwrvgnd_1
XFILLER_94_580 VGND VGND VPWR VPWR sky130_fd_sc_hd__decap_3
XFILLER_66_293 VGND VGND VPWR VPWR sky130_fd_sc_hd__decap_3
XFILLER_26_124 VGND VGND VPWR VPWR sky130_fd_sc_hd__decap_3
X_7986_ _7846_/A _7845_/B _7845_/A VGND VGND VPWR VPWR _7986_/X sky130_fd_sc_hd__a21o_2
XTAP_TAPCELL_ROW_1_289 VGND VPWR sky130_fd_sc_hd__tapvpwrvgnd_1
X_6937_ _6934_/X _6936_/Y _6767_/A VGND VGND VPWR VPWR _6937_/Y sky130_fd_sc_hd__o21ai_2
XFILLER_42_639 VGND VGND VPWR VPWR sky130_fd_sc_hd__fill_1
XFILLER_41_116 VGND VGND VPWR VPWR sky130_fd_sc_hd__decap_3
XFILLER_22_330 VGND VGND VPWR VPWR sky130_fd_sc_hd__decap_3
XFILLER_34_190 VGND VGND VPWR VPWR sky130_fd_sc_hd__decap_3
X_6868_ _6868_/A _8020_/A VGND VGND VPWR VPWR _7225_/B sky130_fd_sc_hd__nor2_2
XTAP_TAPCELL_ROW_40_818 VGND VPWR sky130_fd_sc_hd__tapvpwrvgnd_1
XFILLER_50_661 VGND VGND VPWR VPWR sky130_fd_sc_hd__decap_3
XFILLER_22_363 VGND VGND VPWR VPWR sky130_fd_sc_hd__fill_1
X_8607_ _8607_/A _8607_/B VGND VGND VPWR VPWR _8607_/Y sky130_fd_sc_hd__xnor2_2
XFILLER_22_374 VGND VGND VPWR VPWR sky130_fd_sc_hd__fill_2
X_5819_ _5822_/B _5822_/C _5819_/C VGND VGND VPWR VPWR _5907_/B sky130_fd_sc_hd__nor3_2
X_6799_ _6797_/B _7212_/A _6798_/X _7656_/A VGND VGND VPWR VPWR _6800_/B sky130_fd_sc_hd__o22a_2
XFILLER_41_24 VGND VGND VPWR VPWR sky130_fd_sc_hd__decap_3
XFILLER_22_396 VGND VGND VPWR VPWR sky130_fd_sc_hd__decap_3
XFILLER_10_536 VGND VGND VPWR VPWR sky130_fd_sc_hd__fill_1
X_8538_ _8538_/A _8538_/B VGND VGND VPWR VPWR _8539_/A sky130_fd_sc_hd__and2_2
XFILLER_108_402 VGND VGND VPWR VPWR sky130_fd_sc_hd__decap_3
XFILLER_41_68 VGND VGND VPWR VPWR sky130_fd_sc_hd__fill_2
XTAP_TAPCELL_ROW_20_553 VGND VPWR sky130_fd_sc_hd__tapvpwrvgnd_1
XTAP_TAPCELL_ROW_79_1352 VGND VPWR sky130_fd_sc_hd__tapvpwrvgnd_1
X_8469_ _8469_/A _8482_/B VGND VGND VPWR VPWR _8469_/Y sky130_fd_sc_hd__xnor2_2
XFILLER_123_416 VGND VGND VPWR VPWR sky130_fd_sc_hd__decap_3
XFILLER_2_713 VGND VGND VPWR VPWR sky130_fd_sc_hd__decap_3
XTAP_TAPCELL_ROW_92_1530 VGND VPWR sky130_fd_sc_hd__tapvpwrvgnd_1
XFILLER_2_746 VGND VGND VPWR VPWR sky130_fd_sc_hd__decap_3
XFILLER_123_449 VGND VGND VPWR VPWR sky130_fd_sc_hd__decap_3
XFILLER_1_223 VGND VGND VPWR VPWR sky130_fd_sc_hd__fill_1
XFILLER_2_757 VGND VGND VPWR VPWR sky130_fd_sc_hd__decap_3
XFILLER_2_18 VGND VGND VPWR VPWR sky130_fd_sc_hd__decap_3
XFILLER_1_278 VGND VGND VPWR VPWR sky130_fd_sc_hd__fill_2
XFILLER_104_696 VGND VGND VPWR VPWR sky130_fd_sc_hd__decap_3
XFILLER_77_536 VGND VGND VPWR VPWR sky130_fd_sc_hd__decap_3
XFILLER_2_29 VGND VGND VPWR VPWR sky130_fd_sc_hd__decap_3
XFILLER_58_761 VGND VGND VPWR VPWR sky130_fd_sc_hd__decap_3
XTAP_TAPCELL_ROW_48_929 VGND VPWR sky130_fd_sc_hd__tapvpwrvgnd_1
XFILLER_17_102 VGND VGND VPWR VPWR sky130_fd_sc_hd__decap_3
XFILLER_17_146 VGND VGND VPWR VPWR sky130_fd_sc_hd__fill_1
XFILLER_72_241 VGND VGND VPWR VPWR sky130_fd_sc_hd__decap_3
XTAP_TAPCELL_ROW_28_653 VGND VPWR sky130_fd_sc_hd__tapvpwrvgnd_1
XFILLER_122_71 VGND VGND VPWR VPWR sky130_fd_sc_hd__decap_3
XTAP_TAPCELL_ROW_28_664 VGND VPWR sky130_fd_sc_hd__tapvpwrvgnd_1
XFILLER_33_617 VGND VGND VPWR VPWR sky130_fd_sc_hd__decap_3
XFILLER_72_274 VGND VGND VPWR VPWR sky130_fd_sc_hd__decap_3
XFILLER_60_458 VGND VGND VPWR VPWR sky130_fd_sc_hd__decap_3
XFILLER_25_190 VGND VGND VPWR VPWR sky130_fd_sc_hd__decap_3
XFILLER_9_301 VGND VGND VPWR VPWR sky130_fd_sc_hd__fill_2
XFILLER_13_363 VGND VGND VPWR VPWR sky130_fd_sc_hd__decap_3
XFILLER_9_312 VGND VGND VPWR VPWR sky130_fd_sc_hd__fill_2
XFILLER_9_323 VGND VGND VPWR VPWR sky130_fd_sc_hd__fill_1
XFILLER_41_694 VGND VGND VPWR VPWR sky130_fd_sc_hd__decap_3
XFILLER_40_193 VGND VGND VPWR VPWR sky130_fd_sc_hd__decap_3
XFILLER_127_700 VGND VGND VPWR VPWR sky130_fd_sc_hd__decap_3
XFILLER_127_744 VGND VGND VPWR VPWR sky130_fd_sc_hd__decap_3
XFILLER_126_221 VGND VGND VPWR VPWR sky130_fd_sc_hd__decap_3
XFILLER_31_90 VGND VGND VPWR VPWR sky130_fd_sc_hd__fill_1
XFILLER_56_6 VGND VGND VPWR VPWR sky130_fd_sc_hd__fill_2
XTAP_TAPCELL_ROW_130_2033 VGND VPWR sky130_fd_sc_hd__tapvpwrvgnd_1
XFILLER_114_416 VGND VGND VPWR VPWR sky130_fd_sc_hd__decap_3
XTAP_TAPCELL_ROW_130_2044 VGND VPWR sky130_fd_sc_hd__tapvpwrvgnd_1
XFILLER_114_427 VGND VGND VPWR VPWR sky130_fd_sc_hd__decap_3
XFILLER_99_127 VGND VGND VPWR VPWR sky130_fd_sc_hd__decap_3
XFILLER_126_298 VGND VGND VPWR VPWR sky130_fd_sc_hd__decap_3
XTAP_TAPCELL_ROW_130_2055 VGND VPWR sky130_fd_sc_hd__tapvpwrvgnd_1
XFILLER_110_622 VGND VGND VPWR VPWR sky130_fd_sc_hd__decap_3
XFILLER_68_536 VGND VGND VPWR VPWR sky130_fd_sc_hd__decap_3
XFILLER_110_633 VGND VGND VPWR VPWR sky130_fd_sc_hd__decap_3
XFILLER_110_666 VGND VGND VPWR VPWR sky130_fd_sc_hd__decap_3
XFILLER_110_688 VGND VGND VPWR VPWR sky130_fd_sc_hd__decap_3
XFILLER_83_539 VGND VGND VPWR VPWR sky130_fd_sc_hd__decap_3
XFILLER_76_580 VGND VGND VPWR VPWR sky130_fd_sc_hd__decap_3
XFILLER_36_411 VGND VGND VPWR VPWR sky130_fd_sc_hd__decap_3
XFILLER_64_731 VGND VGND VPWR VPWR sky130_fd_sc_hd__decap_3
X_7840_ _9215_/Q _7840_/B _8099_/C VGND VGND VPWR VPWR _7840_/X sky130_fd_sc_hd__or3_2
XFILLER_91_550 VGND VGND VPWR VPWR sky130_fd_sc_hd__decap_3
XFILLER_63_241 VGND VGND VPWR VPWR sky130_fd_sc_hd__decap_3
XFILLER_91_561 VGND VGND VPWR VPWR sky130_fd_sc_hd__decap_3
XFILLER_36_466 VGND VGND VPWR VPWR sky130_fd_sc_hd__decap_3
XFILLER_24_617 VGND VGND VPWR VPWR sky130_fd_sc_hd__decap_3
XFILLER_51_414 VGND VGND VPWR VPWR sky130_fd_sc_hd__decap_3
X_7771_ _8047_/S _8242_/A VGND VGND VPWR VPWR _7772_/B sky130_fd_sc_hd__nor2_2
XFILLER_36_499 VGND VGND VPWR VPWR sky130_fd_sc_hd__decap_3
X_4983_ _7050_/A VGND VGND VPWR VPWR _7114_/B sky130_fd_sc_hd__clkbuf_2
XFILLER_51_458 VGND VGND VPWR VPWR sky130_fd_sc_hd__decap_3
X_6722_ _6711_/C _5692_/Y _6963_/C _6963_/A VGND VGND VPWR VPWR _6723_/C sky130_fd_sc_hd__a211o_2
XTAP_TAPCELL_ROW_63_1131 VGND VPWR sky130_fd_sc_hd__tapvpwrvgnd_1
XFILLER_32_661 VGND VGND VPWR VPWR sky130_fd_sc_hd__fill_1
X_6653_ _6513_/X _6652_/Y _8117_/S VGND VGND VPWR VPWR _6654_/A sky130_fd_sc_hd__mux2_2
XFILLER_31_182 VGND VGND VPWR VPWR sky130_fd_sc_hd__decap_3
X_5604_ _5705_/B _5604_/B VGND VGND VPWR VPWR _5605_/A sky130_fd_sc_hd__xnor2_4
X_6584_ _7096_/A _7095_/A VGND VGND VPWR VPWR _6584_/Y sky130_fd_sc_hd__nand2_2
XFILLER_118_722 VGND VGND VPWR VPWR sky130_fd_sc_hd__decap_3
X_8323_ _8227_/Y _8230_/Y _8149_/A _7422_/B VGND VGND VPWR VPWR _8323_/X sky130_fd_sc_hd__a211o_2
X_5535_ _6817_/A _5535_/B VGND VGND VPWR VPWR _5544_/A sky130_fd_sc_hd__nor2_2
XFILLER_11_27 VGND VGND VPWR VPWR sky130_fd_sc_hd__decap_3
XFILLER_118_755 VGND VGND VPWR VPWR sky130_fd_sc_hd__fill_1
XFILLER_118_766 VGND VGND VPWR VPWR sky130_fd_sc_hd__decap_3
XTAP_TAPCELL_ROW_115_1828 VGND VPWR sky130_fd_sc_hd__tapvpwrvgnd_1
XTAP_TAPCELL_ROW_115_1839 VGND VPWR sky130_fd_sc_hd__tapvpwrvgnd_1
XFILLER_127_27 VGND VGND VPWR VPWR sky130_fd_sc_hd__decap_3
X_5466_ _9309_/Q _9105_/Q _5611_/S VGND VGND VPWR VPWR _5466_/X sky130_fd_sc_hd__mux2_2
X_8254_ _8254_/A _8254_/B VGND VGND VPWR VPWR _8255_/B sky130_fd_sc_hd__xnor2_2
XFILLER_105_427 VGND VGND VPWR VPWR sky130_fd_sc_hd__decap_3
X_7205_ _6882_/A _6881_/B _7204_/X VGND VGND VPWR VPWR _7208_/B sky130_fd_sc_hd__o21ai_2
X_5397_ _7408_/B VGND VGND VPWR VPWR wire84/A sky130_fd_sc_hd__clkbuf_1
X_8185_ _8185_/A _8184_/X VGND VGND VPWR VPWR _8219_/A sky130_fd_sc_hd__nor2b_2
XFILLER_101_600 VGND VGND VPWR VPWR sky130_fd_sc_hd__decap_3
XTAP_TAPCELL_ROW_74_1282 VGND VPWR sky130_fd_sc_hd__tapvpwrvgnd_1
Xfanout346 _6122_/A VGND VGND VPWR VPWR wire347/A sky130_fd_sc_hd__dlygate4sd1_1
XTAP_TAPCELL_ROW_6_359 VGND VPWR sky130_fd_sc_hd__tapvpwrvgnd_1
XFILLER_98_182 VGND VGND VPWR VPWR sky130_fd_sc_hd__decap_3
XFILLER_113_493 VGND VGND VPWR VPWR sky130_fd_sc_hd__decap_3
X_7067_ _7612_/A1 _7612_/A2 _5743_/Y _6196_/B VGND VGND VPWR VPWR _7326_/B sky130_fd_sc_hd__a211o_2
XFILLER_86_344 VGND VGND VPWR VPWR sky130_fd_sc_hd__decap_3
Xfanout379 fanout379/A VGND VGND VPWR VPWR fanout379/X sky130_fd_sc_hd__clkdlybuf4s25_1
XFILLER_101_666 VGND VGND VPWR VPWR sky130_fd_sc_hd__decap_3
XFILLER_86_377 VGND VGND VPWR VPWR sky130_fd_sc_hd__decap_3
XFILLER_74_517 VGND VGND VPWR VPWR sky130_fd_sc_hd__fill_2
X_6018_ _6177_/A _5893_/B _6017_/Y VGND VGND VPWR VPWR _6224_/A sky130_fd_sc_hd__a21o_2
XFILLER_27_400 VGND VGND VPWR VPWR sky130_fd_sc_hd__decap_3
XFILLER_86_399 VGND VGND VPWR VPWR sky130_fd_sc_hd__fill_2
XFILLER_74_539 VGND VGND VPWR VPWR sky130_fd_sc_hd__decap_3
XFILLER_39_271 VGND VGND VPWR VPWR sky130_fd_sc_hd__decap_3
XFILLER_36_24 VGND VGND VPWR VPWR sky130_fd_sc_hd__decap_3
XFILLER_36_35 VGND VGND VPWR VPWR sky130_fd_sc_hd__decap_3
XFILLER_27_455 VGND VGND VPWR VPWR sky130_fd_sc_hd__fill_2
XTAP_TAPCELL_ROW_126_1979 VGND VPWR sky130_fd_sc_hd__tapvpwrvgnd_1
XFILLER_82_561 VGND VGND VPWR VPWR sky130_fd_sc_hd__fill_1
XFILLER_70_701 VGND VGND VPWR VPWR sky130_fd_sc_hd__decap_3
XFILLER_36_68 VGND VGND VPWR VPWR sky130_fd_sc_hd__decap_3
XFILLER_15_617 VGND VGND VPWR VPWR sky130_fd_sc_hd__decap_3
XFILLER_70_734 VGND VGND VPWR VPWR sky130_fd_sc_hd__decap_3
XFILLER_42_425 VGND VGND VPWR VPWR sky130_fd_sc_hd__decap_3
X_7969_ _8780_/D _6028_/S _4978_/Y VGND VGND VPWR VPWR _7969_/X sky130_fd_sc_hd__a21o_2
XTAP_TAPCELL_ROW_25_623 VGND VPWR sky130_fd_sc_hd__tapvpwrvgnd_1
XFILLER_14_127 VGND VGND VPWR VPWR sky130_fd_sc_hd__decap_3
XFILLER_52_12 VGND VGND VPWR VPWR sky130_fd_sc_hd__decap_3
XFILLER_42_458 VGND VGND VPWR VPWR sky130_fd_sc_hd__decap_3
XTAP_TAPCELL_ROW_53_998 VGND VPWR sky130_fd_sc_hd__tapvpwrvgnd_1
XFILLER_23_694 VGND VGND VPWR VPWR sky130_fd_sc_hd__decap_3
XFILLER_50_480 VGND VGND VPWR VPWR sky130_fd_sc_hd__decap_3
XFILLER_50_491 VGND VGND VPWR VPWR sky130_fd_sc_hd__decap_3
XFILLER_109_711 VGND VGND VPWR VPWR sky130_fd_sc_hd__decap_3
XFILLER_10_355 VGND VGND VPWR VPWR sky130_fd_sc_hd__decap_3
XFILLER_6_315 VGND VGND VPWR VPWR sky130_fd_sc_hd__decap_3
XFILLER_109_755 VGND VGND VPWR VPWR sky130_fd_sc_hd__fill_1
XFILLER_124_725 VGND VGND VPWR VPWR sky130_fd_sc_hd__decap_3
XFILLER_123_202 VGND VGND VPWR VPWR sky130_fd_sc_hd__decap_3
XFILLER_108_298 VGND VGND VPWR VPWR sky130_fd_sc_hd__decap_3
XFILLER_2_521 VGND VGND VPWR VPWR sky130_fd_sc_hd__decap_3
XFILLER_124_769 VGND VGND VPWR VPWR sky130_fd_sc_hd__decap_3
XFILLER_97_609 VGND VGND VPWR VPWR sky130_fd_sc_hd__decap_3
XFILLER_2_554 VGND VGND VPWR VPWR sky130_fd_sc_hd__decap_3
XFILLER_123_257 VGND VGND VPWR VPWR sky130_fd_sc_hd__fill_2
XFILLER_117_60 VGND VGND VPWR VPWR sky130_fd_sc_hd__decap_3
XFILLER_104_460 VGND VGND VPWR VPWR sky130_fd_sc_hd__fill_2
XFILLER_77_311 VGND VGND VPWR VPWR sky130_fd_sc_hd__fill_2
XFILLER_2_587 VGND VGND VPWR VPWR sky130_fd_sc_hd__fill_1
XFILLER_117_93 VGND VGND VPWR VPWR sky130_fd_sc_hd__decap_3
XFILLER_77_53 VGND VGND VPWR VPWR sky130_fd_sc_hd__decap_3
XFILLER_2_598 VGND VGND VPWR VPWR sky130_fd_sc_hd__decap_3
XFILLER_77_322 VGND VGND VPWR VPWR sky130_fd_sc_hd__fill_2
XFILLER_77_399 VGND VGND VPWR VPWR sky130_fd_sc_hd__decap_3
XFILLER_46_720 VGND VGND VPWR VPWR sky130_fd_sc_hd__decap_3
XFILLER_92_336 VGND VGND VPWR VPWR sky130_fd_sc_hd__fill_1
XFILLER_45_230 VGND VGND VPWR VPWR sky130_fd_sc_hd__decap_3
XFILLER_18_455 VGND VGND VPWR VPWR sky130_fd_sc_hd__decap_3
XFILLER_73_561 VGND VGND VPWR VPWR sky130_fd_sc_hd__decap_3
XFILLER_46_775 VGND VGND VPWR VPWR sky130_fd_sc_hd__fill_2
XFILLER_18_499 VGND VGND VPWR VPWR sky130_fd_sc_hd__decap_3
XFILLER_61_756 VGND VGND VPWR VPWR sky130_fd_sc_hd__fill_2
XFILLER_33_469 VGND VGND VPWR VPWR sky130_fd_sc_hd__fill_2
XFILLER_13_160 VGND VGND VPWR VPWR sky130_fd_sc_hd__decap_3
XFILLER_41_480 VGND VGND VPWR VPWR sky130_fd_sc_hd__decap_3
XFILLER_9_153 VGND VGND VPWR VPWR sky130_fd_sc_hd__fill_1
XFILLER_9_186 VGND VGND VPWR VPWR sky130_fd_sc_hd__decap_3
XFILLER_127_541 VGND VGND VPWR VPWR sky130_fd_sc_hd__decap_3
X_5320_ _6436_/B _6406_/B VGND VGND VPWR VPWR _5320_/Y sky130_fd_sc_hd__nand2_2
XFILLER_54_3 VGND VGND VPWR VPWR sky130_fd_sc_hd__decap_3
XFILLER_115_725 VGND VGND VPWR VPWR sky130_fd_sc_hd__decap_3
XPHY_EDGE_ROW_39_Left_170 VGND VGND VPWR VPWR sky130_fd_sc_hd__decap_3
XFILLER_115_758 VGND VGND VPWR VPWR sky130_fd_sc_hd__decap_3
X_5251_ _5633_/A _5251_/B VGND VGND VPWR VPWR _5407_/A sky130_fd_sc_hd__nor2_2
XFILLER_88_609 VGND VGND VPWR VPWR sky130_fd_sc_hd__decap_3
XFILLER_102_408 VGND VGND VPWR VPWR sky130_fd_sc_hd__decap_3
XFILLER_114_268 VGND VGND VPWR VPWR sky130_fd_sc_hd__decap_3
XFILLER_87_119 VGND VGND VPWR VPWR sky130_fd_sc_hd__decap_3
X_5182_ _5880_/B _5990_/A _5180_/X _5181_/X _5182_/B2 VGND VGND VPWR VPWR _5182_/X
+ sky130_fd_sc_hd__a32o_2
XTAP_TAPCELL_ROW_110_1769 VGND VPWR sky130_fd_sc_hd__tapvpwrvgnd_1
XFILLER_110_430 VGND VGND VPWR VPWR sky130_fd_sc_hd__decap_3
XFILLER_3_72 VGND VGND VPWR VPWR sky130_fd_sc_hd__decap_3
XTAP_TAPCELL_ROW_3_318 VGND VPWR sky130_fd_sc_hd__tapvpwrvgnd_1
XFILLER_56_506 VGND VGND VPWR VPWR sky130_fd_sc_hd__decap_3
XFILLER_56_528 VGND VGND VPWR VPWR sky130_fd_sc_hd__decap_3
X_8941_ _8941_/A VGND VGND VPWR VPWR _9312_/D sky130_fd_sc_hd__buf_1
XFILLER_113_18 VGND VGND VPWR VPWR sky130_fd_sc_hd__decap_3
XFILLER_110_496 VGND VGND VPWR VPWR sky130_fd_sc_hd__decap_3
XFILLER_37_753 VGND VGND VPWR VPWR sky130_fd_sc_hd__decap_3
XFILLER_36_230 VGND VGND VPWR VPWR sky130_fd_sc_hd__fill_1
X_8872_ _8872_/A VGND VGND VPWR VPWR _9279_/D sky130_fd_sc_hd__buf_1
XFILLER_52_701 VGND VGND VPWR VPWR sky130_fd_sc_hd__decap_3
XFILLER_37_775 VGND VGND VPWR VPWR sky130_fd_sc_hd__fill_2
Xwire45 wire45/A VGND VGND VPWR VPWR wire45/X sky130_fd_sc_hd__buf_4
XFILLER_24_403 VGND VGND VPWR VPWR sky130_fd_sc_hd__decap_3
X_7823_ _7916_/B _7823_/B VGND VGND VPWR VPWR _7824_/B sky130_fd_sc_hd__xnor2_2
Xwire67 wire67/A VGND VGND VPWR VPWR wire67/X sky130_fd_sc_hd__clkbuf_4
XFILLER_91_391 VGND VGND VPWR VPWR sky130_fd_sc_hd__fill_1
XFILLER_24_447 VGND VGND VPWR VPWR sky130_fd_sc_hd__decap_3
XFILLER_51_233 VGND VGND VPWR VPWR sky130_fd_sc_hd__decap_3
XFILLER_12_609 VGND VGND VPWR VPWR sky130_fd_sc_hd__decap_3
X_7754_ _7754_/A VGND VGND VPWR VPWR _7754_/Y sky130_fd_sc_hd__inv_2
XFILLER_24_469 VGND VGND VPWR VPWR sky130_fd_sc_hd__decap_3
X_4966_ _5048_/B _6304_/A VGND VGND VPWR VPWR _5044_/B sky130_fd_sc_hd__nor2_2
X_6705_ _6705_/A _6705_/B _6705_/C _6705_/D VGND VGND VPWR VPWR _6705_/X sky130_fd_sc_hd__and4_2
XFILLER_32_480 VGND VGND VPWR VPWR sky130_fd_sc_hd__decap_3
X_7685_ _7667_/A _8035_/S _7666_/B VGND VGND VPWR VPWR _7685_/X sky130_fd_sc_hd__a21o_2
X_4897_ _9220_/Q _4899_/B VGND VGND VPWR VPWR _4897_/Y sky130_fd_sc_hd__nor2_2
XTAP_TAPCELL_ROW_50_957 VGND VPWR sky130_fd_sc_hd__tapvpwrvgnd_1
XFILLER_22_15 VGND VGND VPWR VPWR sky130_fd_sc_hd__decap_3
X_6636_ _6636_/A _6636_/B VGND VGND VPWR VPWR _6658_/B sky130_fd_sc_hd__xnor2_2
XFILLER_20_675 VGND VGND VPWR VPWR sky130_fd_sc_hd__decap_3
XFILLER_125_9 VGND VGND VPWR VPWR sky130_fd_sc_hd__decap_3
XTAP_TAPCELL_ROW_30_681 VGND VPWR sky130_fd_sc_hd__tapvpwrvgnd_1
XFILLER_118_541 VGND VGND VPWR VPWR sky130_fd_sc_hd__decap_3
X_6567_ _6669_/A _6567_/B VGND VGND VPWR VPWR _6908_/A sky130_fd_sc_hd__xnor2_4
XTAP_TAPCELL_ROW_30_692 VGND VPWR sky130_fd_sc_hd__tapvpwrvgnd_1
XTAP_TAPCELL_ROW_76_1311 VGND VPWR sky130_fd_sc_hd__tapvpwrvgnd_1
X_8306_ _8253_/A _8252_/A _8251_/X VGND VGND VPWR VPWR _8335_/A sky130_fd_sc_hd__o21ai_2
X_5518_ _6436_/B _5930_/C VGND VGND VPWR VPWR _5519_/B sky130_fd_sc_hd__nor2_2
XFILLER_106_736 VGND VGND VPWR VPWR sky130_fd_sc_hd__decap_3
X_9286_ _9343_/CLK _9286_/D load_slew401/X VGND VGND VPWR VPWR _9286_/Q sky130_fd_sc_hd__dfrtp_2
X_6498_ _6443_/A _6496_/X _6497_/X VGND VGND VPWR VPWR _6505_/B sky130_fd_sc_hd__a21o_2
X_8237_ _8237_/A _8322_/B _8237_/C VGND VGND VPWR VPWR _8239_/B sky130_fd_sc_hd__and3_2
XFILLER_79_609 VGND VGND VPWR VPWR sky130_fd_sc_hd__decap_3
X_5449_ _6304_/A _7951_/A VGND VGND VPWR VPWR _5450_/B sky130_fd_sc_hd__nor2_2
XFILLER_78_119 VGND VGND VPWR VPWR sky130_fd_sc_hd__fill_1
XFILLER_120_216 VGND VGND VPWR VPWR sky130_fd_sc_hd__decap_3
X_8168_ _8229_/B _8168_/B VGND VGND VPWR VPWR _8179_/A sky130_fd_sc_hd__xor2_2
XFILLER_87_620 VGND VGND VPWR VPWR sky130_fd_sc_hd__decap_3
XFILLER_120_227 VGND VGND VPWR VPWR sky130_fd_sc_hd__fill_1
XFILLER_59_322 VGND VGND VPWR VPWR sky130_fd_sc_hd__fill_1
XFILLER_120_249 VGND VGND VPWR VPWR sky130_fd_sc_hd__decap_3
X_7119_ _9211_/Q _7090_/A _7112_/Y _7116_/X _7118_/Y VGND VGND VPWR VPWR _7496_/B
+ sky130_fd_sc_hd__o311a_4
XFILLER_86_141 VGND VGND VPWR VPWR sky130_fd_sc_hd__decap_3
X_8099_ _9217_/Q _8271_/A _8099_/C VGND VGND VPWR VPWR _8099_/X sky130_fd_sc_hd__or3_2
XFILLER_59_366 VGND VGND VPWR VPWR sky130_fd_sc_hd__decap_3
XFILLER_28_720 VGND VGND VPWR VPWR sky130_fd_sc_hd__decap_3
XTAP_TAPCELL_ROW_87_1451 VGND VPWR sky130_fd_sc_hd__tapvpwrvgnd_1
XFILLER_28_775 VGND VGND VPWR VPWR sky130_fd_sc_hd__fill_2
XFILLER_103_51 VGND VGND VPWR VPWR sky130_fd_sc_hd__decap_3
XTAP_TAPCELL_ROW_87_1462 VGND VPWR sky130_fd_sc_hd__tapvpwrvgnd_1
XFILLER_55_561 VGND VGND VPWR VPWR sky130_fd_sc_hd__decap_3
XFILLER_15_414 VGND VGND VPWR VPWR sky130_fd_sc_hd__fill_2
XTAP_TAPCELL_ROW_38_792 VGND VPWR sky130_fd_sc_hd__tapvpwrvgnd_1
XFILLER_82_391 VGND VGND VPWR VPWR sky130_fd_sc_hd__decap_3
XFILLER_70_531 VGND VGND VPWR VPWR sky130_fd_sc_hd__fill_1
XFILLER_42_222 VGND VGND VPWR VPWR sky130_fd_sc_hd__fill_1
XFILLER_43_767 VGND VGND VPWR VPWR sky130_fd_sc_hd__decap_3
XFILLER_15_458 VGND VGND VPWR VPWR sky130_fd_sc_hd__fill_2
XFILLER_30_406 VGND VGND VPWR VPWR sky130_fd_sc_hd__decap_3
XFILLER_42_266 VGND VGND VPWR VPWR sky130_fd_sc_hd__decap_3
XFILLER_42_277 VGND VGND VPWR VPWR sky130_fd_sc_hd__decap_3
XFILLER_30_428 VGND VGND VPWR VPWR sky130_fd_sc_hd__decap_3
XFILLER_11_642 VGND VGND VPWR VPWR sky130_fd_sc_hd__decap_3
XFILLER_7_602 VGND VGND VPWR VPWR sky130_fd_sc_hd__decap_3
XFILLER_11_664 VGND VGND VPWR VPWR sky130_fd_sc_hd__decap_3
XFILLER_10_141 VGND VGND VPWR VPWR sky130_fd_sc_hd__decap_3
XFILLER_7_646 VGND VGND VPWR VPWR sky130_fd_sc_hd__fill_2
XFILLER_6_123 VGND VGND VPWR VPWR sky130_fd_sc_hd__decap_3
XFILLER_7_668 VGND VGND VPWR VPWR sky130_fd_sc_hd__decap_3
XFILLER_6_156 VGND VGND VPWR VPWR sky130_fd_sc_hd__decap_3
XFILLER_109_574 VGND VGND VPWR VPWR sky130_fd_sc_hd__fill_2
XFILLER_12_92 VGND VGND VPWR VPWR sky130_fd_sc_hd__fill_2
XFILLER_109_596 VGND VGND VPWR VPWR sky130_fd_sc_hd__decap_3
XFILLER_124_555 VGND VGND VPWR VPWR sky130_fd_sc_hd__decap_3
XFILLER_88_85 VGND VGND VPWR VPWR sky130_fd_sc_hd__fill_1
XFILLER_69_119 VGND VGND VPWR VPWR sky130_fd_sc_hd__decap_3
XFILLER_97_439 VGND VGND VPWR VPWR sky130_fd_sc_hd__decap_3
XFILLER_78_642 VGND VGND VPWR VPWR sky130_fd_sc_hd__fill_2
XFILLER_38_517 VGND VGND VPWR VPWR sky130_fd_sc_hd__decap_3
XFILLER_120_772 VGND VGND VPWR VPWR sky130_fd_sc_hd__decap_3
XFILLER_78_686 VGND VGND VPWR VPWR sky130_fd_sc_hd__fill_1
XFILLER_19_6 VGND VGND VPWR VPWR sky130_fd_sc_hd__decap_3
XFILLER_93_634 VGND VGND VPWR VPWR sky130_fd_sc_hd__decap_3
XFILLER_65_325 VGND VGND VPWR VPWR sky130_fd_sc_hd__fill_2
XFILLER_38_539 VGND VGND VPWR VPWR sky130_fd_sc_hd__decap_3
XFILLER_65_358 VGND VGND VPWR VPWR sky130_fd_sc_hd__decap_3
XFILLER_19_753 VGND VGND VPWR VPWR sky130_fd_sc_hd__decap_3
XFILLER_46_561 VGND VGND VPWR VPWR sky130_fd_sc_hd__decap_3
XFILLER_34_701 VGND VGND VPWR VPWR sky130_fd_sc_hd__decap_3
XFILLER_18_263 VGND VGND VPWR VPWR sky130_fd_sc_hd__fill_2
XFILLER_34_734 VGND VGND VPWR VPWR sky130_fd_sc_hd__decap_3
XFILLER_61_520 VGND VGND VPWR VPWR sky130_fd_sc_hd__decap_3
XFILLER_18_285 VGND VGND VPWR VPWR sky130_fd_sc_hd__decap_3
X_4820_ _4820_/A VGND VGND VPWR VPWR _9155_/D sky130_fd_sc_hd__buf_1
XFILLER_21_417 VGND VGND VPWR VPWR sky130_fd_sc_hd__decap_3
XFILLER_33_288 VGND VGND VPWR VPWR sky130_fd_sc_hd__decap_3
X_4751_ _4751_/A VGND VGND VPWR VPWR _9122_/D sky130_fd_sc_hd__buf_1
XFILLER_14_480 VGND VGND VPWR VPWR sky130_fd_sc_hd__decap_3
XTAP_TAPCELL_ROW_16_497 VGND VPWR sky130_fd_sc_hd__tapvpwrvgnd_1
XFILLER_14_491 VGND VGND VPWR VPWR sky130_fd_sc_hd__decap_3
X_4682_ _4682_/A VGND VGND VPWR VPWR _9089_/D sky130_fd_sc_hd__buf_1
X_7470_ _7307_/A _7307_/C _7307_/B VGND VGND VPWR VPWR _7484_/A sky130_fd_sc_hd__a21boi_2
X_6421_ _6478_/S _6421_/B VGND VGND VPWR VPWR _6422_/B sky130_fd_sc_hd__xnor2_2
X_9140_ _9296_/CLK _9140_/D load_slew384/X VGND VGND VPWR VPWR _9140_/Q sky130_fd_sc_hd__dfrtp_2
XFILLER_108_18 VGND VGND VPWR VPWR sky130_fd_sc_hd__decap_3
X_6352_ _6352_/A VGND VGND VPWR VPWR _7960_/C sky130_fd_sc_hd__buf_4
XFILLER_108_29 VGND VGND VPWR VPWR sky130_fd_sc_hd__decap_3
XFILLER_127_382 VGND VGND VPWR VPWR sky130_fd_sc_hd__decap_3
XFILLER_6_690 VGND VGND VPWR VPWR sky130_fd_sc_hd__decap_3
XFILLER_127_393 VGND VGND VPWR VPWR sky130_fd_sc_hd__decap_3
X_5303_ _5303_/A _5303_/B VGND VGND VPWR VPWR _5452_/B sky130_fd_sc_hd__xnor2_2
XTAP_TAPCELL_ROW_58_1063 VGND VPWR sky130_fd_sc_hd__tapvpwrvgnd_1
X_6283_ _5999_/A _5999_/B _7050_/B VGND VGND VPWR VPWR _6285_/A sky130_fd_sc_hd__a21o_4
X_9071_ _9135_/CLK _9071_/D load_slew384/X VGND VGND VPWR VPWR _9071_/Q sky130_fd_sc_hd__dfrtp_2
XFILLER_115_577 VGND VGND VPWR VPWR sky130_fd_sc_hd__decap_3
XFILLER_102_205 VGND VGND VPWR VPWR sky130_fd_sc_hd__decap_3
X_8022_ _7871_/Y _8021_/X _8022_/S VGND VGND VPWR VPWR _8022_/X sky130_fd_sc_hd__mux2_2
XFILLER_130_514 VGND VGND VPWR VPWR sky130_fd_sc_hd__decap_3
X_5234_ _5507_/A _5234_/B VGND VGND VPWR VPWR _5234_/Y sky130_fd_sc_hd__xnor2_2
XFILLER_88_439 VGND VGND VPWR VPWR sky130_fd_sc_hd__fill_2
XFILLER_69_620 VGND VGND VPWR VPWR sky130_fd_sc_hd__decap_3
XFILLER_130_536 VGND VGND VPWR VPWR sky130_fd_sc_hd__fill_1
XTAP_TAPCELL_ROW_71_1241 VGND VPWR sky130_fd_sc_hd__tapvpwrvgnd_1
X_5165_ _5165_/A _5165_/B VGND VGND VPWR VPWR _7311_/A sky130_fd_sc_hd__and2_2
XFILLER_69_664 VGND VGND VPWR VPWR sky130_fd_sc_hd__decap_3
XFILLER_68_141 VGND VGND VPWR VPWR sky130_fd_sc_hd__decap_3
XFILLER_69_697 VGND VGND VPWR VPWR sky130_fd_sc_hd__decap_3
XFILLER_83_100 VGND VGND VPWR VPWR sky130_fd_sc_hd__decap_3
X_5096_ _6084_/A VGND VGND VPWR VPWR _6436_/B sky130_fd_sc_hd__inv_2
XFILLER_56_325 VGND VGND VPWR VPWR sky130_fd_sc_hd__decap_3
XFILLER_56_347 VGND VGND VPWR VPWR sky130_fd_sc_hd__decap_3
XFILLER_17_15 VGND VGND VPWR VPWR sky130_fd_sc_hd__decap_3
X_8924_ _8924_/A VGND VGND VPWR VPWR _9304_/D sky130_fd_sc_hd__buf_1
XFILLER_44_509 VGND VGND VPWR VPWR sky130_fd_sc_hd__decap_3
XFILLER_37_550 VGND VGND VPWR VPWR sky130_fd_sc_hd__decap_3
XFILLER_71_306 VGND VGND VPWR VPWR sky130_fd_sc_hd__fill_2
XFILLER_37_561 VGND VGND VPWR VPWR sky130_fd_sc_hd__decap_3
XFILLER_25_701 VGND VGND VPWR VPWR sky130_fd_sc_hd__decap_3
XFILLER_17_48 VGND VGND VPWR VPWR sky130_fd_sc_hd__decap_3
X_8855_ _8855_/A VGND VGND VPWR VPWR _9271_/D sky130_fd_sc_hd__buf_1
XTAP_TAPCELL_ROW_123_1938 VGND VPWR sky130_fd_sc_hd__tapvpwrvgnd_1
XFILLER_25_756 VGND VGND VPWR VPWR sky130_fd_sc_hd__decap_3
XFILLER_52_542 VGND VGND VPWR VPWR sky130_fd_sc_hd__decap_3
X_7806_ _8341_/A _7806_/B VGND VGND VPWR VPWR _7807_/S sky130_fd_sc_hd__xnor2_2
XTAP_TAPCELL_ROW_35_751 VGND VPWR sky130_fd_sc_hd__tapvpwrvgnd_1
X_8786_ _8786_/A VGND VGND VPWR VPWR _9238_/D sky130_fd_sc_hd__buf_1
XFILLER_52_575 VGND VGND VPWR VPWR sky130_fd_sc_hd__decap_3
XFILLER_12_406 VGND VGND VPWR VPWR sky130_fd_sc_hd__decap_3
X_5998_ _5998_/A _5998_/B _5998_/C VGND VGND VPWR VPWR _5998_/Y sky130_fd_sc_hd__nor3_4
XFILLER_52_586 VGND VGND VPWR VPWR sky130_fd_sc_hd__fill_2
XFILLER_24_277 VGND VGND VPWR VPWR sky130_fd_sc_hd__decap_3
XFILLER_33_25 VGND VGND VPWR VPWR sky130_fd_sc_hd__decap_3
XFILLER_24_288 VGND VGND VPWR VPWR sky130_fd_sc_hd__decap_3
X_7737_ _8009_/A _7737_/B VGND VGND VPWR VPWR _7738_/B sky130_fd_sc_hd__xnor2_2
XFILLER_40_748 VGND VGND VPWR VPWR sky130_fd_sc_hd__fill_2
XFILLER_33_47 VGND VGND VPWR VPWR sky130_fd_sc_hd__fill_2
X_4949_ _4944_/X _4947_/X _5718_/B VGND VGND VPWR VPWR _4974_/B sky130_fd_sc_hd__o21ai_2
XTAP_TAPCELL_ROW_82_1392 VGND VPWR sky130_fd_sc_hd__tapvpwrvgnd_1
XFILLER_33_69 VGND VGND VPWR VPWR sky130_fd_sc_hd__fill_2
X_7668_ _7668_/A _7668_/B VGND VGND VPWR VPWR _7670_/B sky130_fd_sc_hd__xnor2_2
XFILLER_123_6 VGND VGND VPWR VPWR sky130_fd_sc_hd__decap_3
X_6619_ _9209_/Q _6619_/B VGND VGND VPWR VPWR _6620_/B sky130_fd_sc_hd__and2_2
X_7599_ _7599_/A _7784_/C VGND VGND VPWR VPWR _7600_/B sky130_fd_sc_hd__xnor2_2
XFILLER_118_360 VGND VGND VPWR VPWR sky130_fd_sc_hd__decap_3
X_9338_ _9338_/CLK _9338_/D fanout369/X VGND VGND VPWR VPWR _9338_/Q sky130_fd_sc_hd__dfrtp_2
XFILLER_118_371 VGND VGND VPWR VPWR sky130_fd_sc_hd__decap_3
XFILLER_106_533 VGND VGND VPWR VPWR sky130_fd_sc_hd__fill_1
XFILLER_3_148 VGND VGND VPWR VPWR sky130_fd_sc_hd__fill_2
XFILLER_106_566 VGND VGND VPWR VPWR sky130_fd_sc_hd__decap_3
X_9269_ _9334_/CLK _9269_/D load_slew401/X VGND VGND VPWR VPWR _9269_/Q sky130_fd_sc_hd__dfrtp_2
XFILLER_79_417 VGND VGND VPWR VPWR sky130_fd_sc_hd__decap_3
XFILLER_121_514 VGND VGND VPWR VPWR sky130_fd_sc_hd__decap_3
XFILLER_58_22 VGND VGND VPWR VPWR sky130_fd_sc_hd__decap_3
XFILLER_58_55 VGND VGND VPWR VPWR sky130_fd_sc_hd__decap_3
XFILLER_102_750 VGND VGND VPWR VPWR sky130_fd_sc_hd__fill_1
XFILLER_75_612 VGND VGND VPWR VPWR sky130_fd_sc_hd__decap_3
XFILLER_87_494 VGND VGND VPWR VPWR sky130_fd_sc_hd__decap_3
XFILLER_74_111 VGND VGND VPWR VPWR sky130_fd_sc_hd__decap_3
XFILLER_47_325 VGND VGND VPWR VPWR sky130_fd_sc_hd__decap_3
XFILLER_75_645 VGND VGND VPWR VPWR sky130_fd_sc_hd__decap_3
XFILLER_114_50 VGND VGND VPWR VPWR sky130_fd_sc_hd__decap_3
XFILLER_74_133 VGND VGND VPWR VPWR sky130_fd_sc_hd__decap_3
XFILLER_75_667 VGND VGND VPWR VPWR sky130_fd_sc_hd__decap_3
XFILLER_74_144 VGND VGND VPWR VPWR sky130_fd_sc_hd__decap_3
XFILLER_90_604 VGND VGND VPWR VPWR sky130_fd_sc_hd__decap_3
XFILLER_74_32 VGND VGND VPWR VPWR sky130_fd_sc_hd__decap_3
XFILLER_47_369 VGND VGND VPWR VPWR sky130_fd_sc_hd__decap_3
XFILLER_114_83 VGND VGND VPWR VPWR sky130_fd_sc_hd__fill_1
XFILLER_16_701 VGND VGND VPWR VPWR sky130_fd_sc_hd__decap_3
XFILLER_28_561 VGND VGND VPWR VPWR sky130_fd_sc_hd__decap_3
XFILLER_16_734 VGND VGND VPWR VPWR sky130_fd_sc_hd__decap_3
XFILLER_74_98 VGND VGND VPWR VPWR sky130_fd_sc_hd__decap_3
XFILLER_55_391 VGND VGND VPWR VPWR sky130_fd_sc_hd__fill_1
XFILLER_15_244 VGND VGND VPWR VPWR sky130_fd_sc_hd__decap_3
XFILLER_15_255 VGND VGND VPWR VPWR sky130_fd_sc_hd__decap_3
XFILLER_130_60 VGND VGND VPWR VPWR sky130_fd_sc_hd__decap_3
XFILLER_15_288 VGND VGND VPWR VPWR sky130_fd_sc_hd__decap_3
XFILLER_30_225 VGND VGND VPWR VPWR sky130_fd_sc_hd__decap_3
XFILLER_129_603 VGND VGND VPWR VPWR sky130_fd_sc_hd__decap_3
XTAP_TAPCELL_ROW_13_456 VGND VPWR sky130_fd_sc_hd__tapvpwrvgnd_1
XFILLER_90_97 VGND VGND VPWR VPWR sky130_fd_sc_hd__decap_3
XFILLER_129_647 VGND VGND VPWR VPWR sky130_fd_sc_hd__decap_3
XFILLER_128_124 VGND VGND VPWR VPWR sky130_fd_sc_hd__decap_3
XFILLER_7_443 VGND VGND VPWR VPWR sky130_fd_sc_hd__decap_3
XFILLER_11_494 VGND VGND VPWR VPWR sky130_fd_sc_hd__decap_3
XFILLER_128_168 VGND VGND VPWR VPWR sky130_fd_sc_hd__decap_3
Xmax_cap107 _7421_/C VGND VGND VPWR VPWR _7090_/A sky130_fd_sc_hd__buf_2
Xmax_cap118 _6717_/B VGND VGND VPWR VPWR _7417_/B sky130_fd_sc_hd__clkbuf_2
XFILLER_109_393 VGND VGND VPWR VPWR sky130_fd_sc_hd__decap_3
XFILLER_98_704 VGND VGND VPWR VPWR sky130_fd_sc_hd__decap_3
XFILLER_124_374 VGND VGND VPWR VPWR sky130_fd_sc_hd__fill_1
Xload_slew302 input3/X VGND VGND VPWR VPWR _6446_/B sky130_fd_sc_hd__buf_6
XFILLER_3_671 VGND VGND VPWR VPWR sky130_fd_sc_hd__fill_1
XFILLER_112_525 VGND VGND VPWR VPWR sky130_fd_sc_hd__decap_3
XFILLER_98_748 VGND VGND VPWR VPWR sky130_fd_sc_hd__decap_3
XFILLER_97_225 VGND VGND VPWR VPWR sky130_fd_sc_hd__decap_3
XFILLER_3_682 VGND VGND VPWR VPWR sky130_fd_sc_hd__decap_3
Xload_slew324 _6425_/S VGND VGND VPWR VPWR _5801_/B sky130_fd_sc_hd__clkbuf_2
XFILLER_112_536 VGND VGND VPWR VPWR sky130_fd_sc_hd__decap_3
Xload_slew335 _5803_/C VGND VGND VPWR VPWR _6483_/S sky130_fd_sc_hd__clkbuf_4
XFILLER_2_192 VGND VGND VPWR VPWR sky130_fd_sc_hd__decap_3
Xload_slew357 _5793_/S VGND VGND VPWR VPWR _6084_/A sky130_fd_sc_hd__buf_6
Xload_slew368 fanout367/X VGND VGND VPWR VPWR load_slew368/X sky130_fd_sc_hd__clkbuf_4
XFILLER_78_472 VGND VGND VPWR VPWR sky130_fd_sc_hd__decap_3
XFILLER_66_612 VGND VGND VPWR VPWR sky130_fd_sc_hd__decap_3
XFILLER_78_494 VGND VGND VPWR VPWR sky130_fd_sc_hd__fill_1
XFILLER_120_580 VGND VGND VPWR VPWR sky130_fd_sc_hd__decap_3
XFILLER_17_3 VGND VGND VPWR VPWR sky130_fd_sc_hd__decap_3
XFILLER_93_431 VGND VGND VPWR VPWR sky130_fd_sc_hd__decap_3
XFILLER_65_122 VGND VGND VPWR VPWR sky130_fd_sc_hd__fill_2
XFILLER_93_442 VGND VGND VPWR VPWR sky130_fd_sc_hd__decap_3
XFILLER_38_358 VGND VGND VPWR VPWR sky130_fd_sc_hd__decap_3
XFILLER_93_464 VGND VGND VPWR VPWR sky130_fd_sc_hd__decap_3
X_6970_ _6969_/B _6969_/C _6969_/A VGND VGND VPWR VPWR _7036_/B sky130_fd_sc_hd__a21o_2
XFILLER_81_615 VGND VGND VPWR VPWR sky130_fd_sc_hd__fill_1
XFILLER_19_561 VGND VGND VPWR VPWR sky130_fd_sc_hd__decap_3
XFILLER_93_497 VGND VGND VPWR VPWR sky130_fd_sc_hd__decap_3
X_5921_ _5088_/A _5923_/S _5922_/A VGND VGND VPWR VPWR _5921_/Y sky130_fd_sc_hd__a21oi_2
XFILLER_65_199 VGND VGND VPWR VPWR sky130_fd_sc_hd__decap_3
XFILLER_81_659 VGND VGND VPWR VPWR sky130_fd_sc_hd__decap_3
XFILLER_46_391 VGND VGND VPWR VPWR sky130_fd_sc_hd__decap_3
XFILLER_34_542 VGND VGND VPWR VPWR sky130_fd_sc_hd__decap_3
XFILLER_0_95 VGND VGND VPWR VPWR sky130_fd_sc_hd__decap_3
X_8640_ wire313/X _8690_/A _7561_/A _8640_/C1 VGND VGND VPWR VPWR _8640_/X sky130_fd_sc_hd__o211a_2
X_5852_ _5284_/Y _5285_/X _6206_/C VGND VGND VPWR VPWR _6033_/B sky130_fd_sc_hd__mux2_2
XFILLER_61_361 VGND VGND VPWR VPWR sky130_fd_sc_hd__decap_3
XTAP_TAPCELL_ROW_32_710 VGND VPWR sky130_fd_sc_hd__tapvpwrvgnd_1
XFILLER_22_737 VGND VGND VPWR VPWR sky130_fd_sc_hd__decap_3
X_4803_ _4803_/A0 _9131_/Q _4819_/S VGND VGND VPWR VPWR _4803_/X sky130_fd_sc_hd__mux2_2
X_8571_ _8678_/A _8571_/B VGND VGND VPWR VPWR _8572_/B sky130_fd_sc_hd__xnor2_2
XFILLER_21_225 VGND VGND VPWR VPWR sky130_fd_sc_hd__decap_3
X_5783_ _6873_/A _5926_/B VGND VGND VPWR VPWR _7534_/B sky130_fd_sc_hd__nor2_2
X_7522_ _7522_/A _7522_/B VGND VGND VPWR VPWR _7522_/X sky130_fd_sc_hd__or2_2
X_4734_ _4734_/A VGND VGND VPWR VPWR _9114_/D sky130_fd_sc_hd__buf_1
XFILLER_119_102 VGND VGND VPWR VPWR sky130_fd_sc_hd__decap_3
Xrebuffer507 _5995_/A2 VGND VGND VPWR VPWR _6332_/A2 sky130_fd_sc_hd__buf_2
XFILLER_119_113 VGND VGND VPWR VPWR sky130_fd_sc_hd__decap_3
Xrebuffer518 _7566_/A1 VGND VGND VPWR VPWR _7507_/C sky130_fd_sc_hd__buf_2
Xrebuffer529 _5476_/A VGND VGND VPWR VPWR _6963_/A sky130_fd_sc_hd__buf_2
X_7453_ _8137_/B _7576_/A _7576_/B VGND VGND VPWR VPWR _7454_/C sky130_fd_sc_hd__nand3_2
X_4665_ _4665_/A VGND VGND VPWR VPWR _9081_/D sky130_fd_sc_hd__buf_1
XFILLER_119_39 VGND VGND VPWR VPWR sky130_fd_sc_hd__decap_3
XFILLER_107_319 VGND VGND VPWR VPWR sky130_fd_sc_hd__fill_2
X_6404_ _5950_/A _5328_/B _5935_/X _5326_/X _5803_/A VGND VGND VPWR VPWR _6404_/X
+ sky130_fd_sc_hd__a221o_2
Xhold900 _9259_/Q VGND VGND VPWR VPWR hold900/X sky130_fd_sc_hd__dlygate4sd3_1
X_7384_ _7496_/A _7379_/Y _7382_/Y VGND VGND VPWR VPWR _7385_/B sky130_fd_sc_hd__o21ba_2
Xhold911 _4849_/X VGND VGND VPWR VPWR _4850_/A sky130_fd_sc_hd__dlygate4sd3_1
X_4596_ _4629_/A1 _4596_/A1 _4608_/S VGND VGND VPWR VPWR _4597_/A sky130_fd_sc_hd__mux2_2
Xhold922 _9286_/Q VGND VGND VPWR VPWR hold922/X sky130_fd_sc_hd__dlygate4sd3_1
Xhold933 _4540_/X VGND VGND VPWR VPWR _4541_/A sky130_fd_sc_hd__dlygate4sd3_1
X_9123_ _9171_/CLK _9123_/D load_slew396/X VGND VGND VPWR VPWR _9123_/Q sky130_fd_sc_hd__dfrtp_2
XFILLER_127_190 VGND VGND VPWR VPWR sky130_fd_sc_hd__decap_3
XFILLER_115_330 VGND VGND VPWR VPWR sky130_fd_sc_hd__fill_1
X_6335_ _9347_/Q _6336_/C _6607_/C VGND VGND VPWR VPWR _6335_/X sky130_fd_sc_hd__and3_2
Xhold944 _9164_/Q VGND VGND VPWR VPWR hold944/X sky130_fd_sc_hd__dlygate4sd3_1
Xhold955 _4867_/X VGND VGND VPWR VPWR _4868_/A sky130_fd_sc_hd__dlygate4sd3_1
XFILLER_89_715 VGND VGND VPWR VPWR sky130_fd_sc_hd__fill_2
Xhold966 _9337_/Q VGND VGND VPWR VPWR hold966/X sky130_fd_sc_hd__dlygate4sd3_1
Xhold977 _9047_/Q VGND VGND VPWR VPWR hold977/X sky130_fd_sc_hd__dlygate4sd3_1
XFILLER_115_363 VGND VGND VPWR VPWR sky130_fd_sc_hd__decap_3
XFILLER_0_107 VGND VGND VPWR VPWR sky130_fd_sc_hd__decap_3
XFILLER_103_514 VGND VGND VPWR VPWR sky130_fd_sc_hd__decap_3
XFILLER_130_300 VGND VGND VPWR VPWR sky130_fd_sc_hd__decap_3
Xhold988 _5225_/X VGND VGND VPWR VPWR hold988/X sky130_fd_sc_hd__dlygate4sd3_1
X_9054_ _9293_/CLK _9054_/D fanout383/X VGND VGND VPWR VPWR _9054_/Q sky130_fd_sc_hd__dfrtp_2
XFILLER_89_748 VGND VGND VPWR VPWR sky130_fd_sc_hd__decap_3
X_6266_ _6266_/A _6266_/B VGND VGND VPWR VPWR _6269_/A sky130_fd_sc_hd__xnor2_2
Xhold999 _4767_/X VGND VGND VPWR VPWR _4768_/A sky130_fd_sc_hd__dlygate4sd3_1
XFILLER_103_547 VGND VGND VPWR VPWR sky130_fd_sc_hd__decap_3
XFILLER_88_247 VGND VGND VPWR VPWR sky130_fd_sc_hd__decap_3
XFILLER_130_333 VGND VGND VPWR VPWR sky130_fd_sc_hd__decap_3
X_8005_ _8006_/A _8004_/X _8002_/Y VGND VGND VPWR VPWR _8005_/X sky130_fd_sc_hd__o21a_2
X_5217_ _5538_/A VGND VGND VPWR VPWR _6490_/A sky130_fd_sc_hd__inv_2
XFILLER_130_355 VGND VGND VPWR VPWR sky130_fd_sc_hd__decap_3
X_6197_ _6197_/A _6197_/B VGND VGND VPWR VPWR _6198_/B sky130_fd_sc_hd__xnor2_2
XFILLER_130_377 VGND VGND VPWR VPWR sky130_fd_sc_hd__decap_3
XFILLER_57_612 VGND VGND VPWR VPWR sky130_fd_sc_hd__decap_3
XFILLER_29_314 VGND VGND VPWR VPWR sky130_fd_sc_hd__decap_3
XFILLER_56_100 VGND VGND VPWR VPWR sky130_fd_sc_hd__fill_1
X_5148_ _5148_/A _5148_/B VGND VGND VPWR VPWR _5152_/A sky130_fd_sc_hd__xnor2_2
XFILLER_69_494 VGND VGND VPWR VPWR sky130_fd_sc_hd__decap_3
XFILLER_28_47 VGND VGND VPWR VPWR sky130_fd_sc_hd__decap_3
XFILLER_111_591 VGND VGND VPWR VPWR sky130_fd_sc_hd__decap_3
XFILLER_57_656 VGND VGND VPWR VPWR sky130_fd_sc_hd__decap_3
XFILLER_56_144 VGND VGND VPWR VPWR sky130_fd_sc_hd__decap_3
X_5079_ _9198_/Q _5079_/B VGND VGND VPWR VPWR _5160_/A sky130_fd_sc_hd__xnor2_2
XFILLER_84_475 VGND VGND VPWR VPWR sky130_fd_sc_hd__fill_1
XFILLER_56_166 VGND VGND VPWR VPWR sky130_fd_sc_hd__decap_3
X_8907_ hold896/X hold981/X _8925_/S VGND VGND VPWR VPWR _8908_/A sky130_fd_sc_hd__mux2_2
XTAP_TAPCELL_ROW_84_1410 VGND VPWR sky130_fd_sc_hd__tapvpwrvgnd_1
XTAP_TAPCELL_ROW_84_1421 VGND VPWR sky130_fd_sc_hd__tapvpwrvgnd_1
XFILLER_37_380 VGND VGND VPWR VPWR sky130_fd_sc_hd__decap_3
XFILLER_25_520 VGND VGND VPWR VPWR sky130_fd_sc_hd__decap_3
X_8838_ _8838_/A VGND VGND VPWR VPWR _9263_/D sky130_fd_sc_hd__buf_1
XFILLER_71_169 VGND VGND VPWR VPWR sky130_fd_sc_hd__decap_3
XFILLER_52_350 VGND VGND VPWR VPWR sky130_fd_sc_hd__fill_1
XFILLER_44_57 VGND VGND VPWR VPWR sky130_fd_sc_hd__decap_3
XFILLER_13_715 VGND VGND VPWR VPWR sky130_fd_sc_hd__decap_3
XFILLER_25_586 VGND VGND VPWR VPWR sky130_fd_sc_hd__decap_3
XFILLER_12_214 VGND VGND VPWR VPWR sky130_fd_sc_hd__fill_2
X_8769_ _8770_/B _8766_/X _8767_/X _8768_/Y VGND VGND VPWR VPWR _8772_/B sky130_fd_sc_hd__o211a_2
XFILLER_13_759 VGND VGND VPWR VPWR sky130_fd_sc_hd__decap_3
XFILLER_60_12 VGND VGND VPWR VPWR sky130_fd_sc_hd__decap_3
XFILLER_40_589 VGND VGND VPWR VPWR sky130_fd_sc_hd__decap_3
XFILLER_100_85 VGND VGND VPWR VPWR sky130_fd_sc_hd__decap_3
XTAP_TAPCELL_ROW_10_415 VGND VPWR sky130_fd_sc_hd__tapvpwrvgnd_1
XFILLER_121_3 VGND VGND VPWR VPWR sky130_fd_sc_hd__decap_3
XFILLER_60_67 VGND VGND VPWR VPWR sky130_fd_sc_hd__decap_3
XFILLER_20_280 VGND VGND VPWR VPWR sky130_fd_sc_hd__decap_3
XFILLER_126_606 VGND VGND VPWR VPWR sky130_fd_sc_hd__fill_1
XFILLER_125_105 VGND VGND VPWR VPWR sky130_fd_sc_hd__decap_3
XFILLER_126_639 VGND VGND VPWR VPWR sky130_fd_sc_hd__decap_3
XFILLER_125_116 VGND VGND VPWR VPWR sky130_fd_sc_hd__decap_3
XFILLER_5_18 VGND VGND VPWR VPWR sky130_fd_sc_hd__decap_3
XTAP_TAPCELL_ROW_95_1561 VGND VPWR sky130_fd_sc_hd__tapvpwrvgnd_1
XFILLER_125_149 VGND VGND VPWR VPWR sky130_fd_sc_hd__decap_3
XFILLER_4_457 VGND VGND VPWR VPWR sky130_fd_sc_hd__decap_3
XFILLER_109_72 VGND VGND VPWR VPWR sky130_fd_sc_hd__decap_3
XFILLER_79_225 VGND VGND VPWR VPWR sky130_fd_sc_hd__fill_1
XFILLER_106_396 VGND VGND VPWR VPWR sky130_fd_sc_hd__fill_1
XFILLER_79_247 VGND VGND VPWR VPWR sky130_fd_sc_hd__decap_3
XFILLER_0_641 VGND VGND VPWR VPWR sky130_fd_sc_hd__decap_3
XFILLER_121_355 VGND VGND VPWR VPWR sky130_fd_sc_hd__decap_3
XFILLER_0_663 VGND VGND VPWR VPWR sky130_fd_sc_hd__decap_3
XFILLER_125_60 VGND VGND VPWR VPWR sky130_fd_sc_hd__decap_3
XFILLER_0_685 VGND VGND VPWR VPWR sky130_fd_sc_hd__decap_3
XFILLER_125_93 VGND VGND VPWR VPWR sky130_fd_sc_hd__decap_3
XFILLER_47_144 VGND VGND VPWR VPWR sky130_fd_sc_hd__decap_3
XFILLER_63_615 VGND VGND VPWR VPWR sky130_fd_sc_hd__fill_1
XFILLER_75_497 VGND VGND VPWR VPWR sky130_fd_sc_hd__decap_3
XTAP_TAPCELL_ROW_18_526 VGND VPWR sky130_fd_sc_hd__tapvpwrvgnd_1
XFILLER_90_445 VGND VGND VPWR VPWR sky130_fd_sc_hd__decap_3
XFILLER_62_147 VGND VGND VPWR VPWR sky130_fd_sc_hd__decap_3
XFILLER_90_467 VGND VGND VPWR VPWR sky130_fd_sc_hd__decap_3
XFILLER_90_489 VGND VGND VPWR VPWR sky130_fd_sc_hd__fill_1
XFILLER_71_670 VGND VGND VPWR VPWR sky130_fd_sc_hd__fill_2
XFILLER_43_361 VGND VGND VPWR VPWR sky130_fd_sc_hd__decap_3
XFILLER_43_383 VGND VGND VPWR VPWR sky130_fd_sc_hd__fill_1
XFILLER_31_545 VGND VGND VPWR VPWR sky130_fd_sc_hd__decap_3
XTAP_TAPCELL_ROW_104_1690 VGND VPWR sky130_fd_sc_hd__tapvpwrvgnd_1
XFILLER_86_6 VGND VGND VPWR VPWR sky130_fd_sc_hd__decap_3
XFILLER_31_589 VGND VGND VPWR VPWR sky130_fd_sc_hd__decap_3
XFILLER_8_752 VGND VGND VPWR VPWR sky130_fd_sc_hd__decap_3
XFILLER_8_763 VGND VGND VPWR VPWR sky130_fd_sc_hd__decap_3
Xwire160 _5123_/Y VGND VGND VPWR VPWR wire160/X sky130_fd_sc_hd__buf_1
XFILLER_7_251 VGND VGND VPWR VPWR sky130_fd_sc_hd__decap_3
XFILLER_117_639 VGND VGND VPWR VPWR sky130_fd_sc_hd__decap_3
XFILLER_7_284 VGND VGND VPWR VPWR sky130_fd_sc_hd__decap_3
XTAP_TAPCELL_ROW_55_1022 VGND VPWR sky130_fd_sc_hd__tapvpwrvgnd_1
XFILLER_98_512 VGND VGND VPWR VPWR sky130_fd_sc_hd__decap_3
X_6120_ _6120_/A _6120_/B VGND VGND VPWR VPWR _6440_/B sky130_fd_sc_hd__xnor2_2
XFILLER_124_171 VGND VGND VPWR VPWR sky130_fd_sc_hd__decap_3
XFILLER_3_490 VGND VGND VPWR VPWR sky130_fd_sc_hd__decap_3
X_6051_ _6158_/A _6051_/B VGND VGND VPWR VPWR _6151_/A sky130_fd_sc_hd__xnor2_2
XFILLER_105_19 VGND VGND VPWR VPWR sky130_fd_sc_hd__fill_2
XFILLER_100_528 VGND VGND VPWR VPWR sky130_fd_sc_hd__decap_3
X_5002_ _5002_/A VGND VGND VPWR VPWR _5002_/X sky130_fd_sc_hd__buf_2
XFILLER_39_623 VGND VGND VPWR VPWR sky130_fd_sc_hd__decap_3
XFILLER_38_122 VGND VGND VPWR VPWR sky130_fd_sc_hd__decap_3
XFILLER_66_442 VGND VGND VPWR VPWR sky130_fd_sc_hd__fill_1
XFILLER_39_656 VGND VGND VPWR VPWR sky130_fd_sc_hd__decap_3
XFILLER_54_615 VGND VGND VPWR VPWR sky130_fd_sc_hd__decap_3
XFILLER_39_689 VGND VGND VPWR VPWR sky130_fd_sc_hd__fill_1
XFILLER_66_475 VGND VGND VPWR VPWR sky130_fd_sc_hd__fill_1
XFILLER_38_166 VGND VGND VPWR VPWR sky130_fd_sc_hd__decap_3
XFILLER_66_486 VGND VGND VPWR VPWR sky130_fd_sc_hd__decap_3
XFILLER_54_648 VGND VGND VPWR VPWR sky130_fd_sc_hd__decap_3
XFILLER_121_18 VGND VGND VPWR VPWR sky130_fd_sc_hd__decap_3
X_6953_ _6953_/A _6953_/B VGND VGND VPWR VPWR _7012_/B sky130_fd_sc_hd__nand2_4
XFILLER_53_136 VGND VGND VPWR VPWR sky130_fd_sc_hd__fill_2
XFILLER_19_391 VGND VGND VPWR VPWR sky130_fd_sc_hd__fill_1
X_5904_ _5904_/A _5904_/B VGND VGND VPWR VPWR _5905_/A sky130_fd_sc_hd__xor2_2
XFILLER_53_169 VGND VGND VPWR VPWR sky130_fd_sc_hd__decap_3
XTAP_TAPCELL_ROW_120_1908 VGND VPWR sky130_fd_sc_hd__tapvpwrvgnd_1
XFILLER_81_489 VGND VGND VPWR VPWR sky130_fd_sc_hd__decap_3
XFILLER_34_350 VGND VGND VPWR VPWR sky130_fd_sc_hd__decap_3
X_6884_ _6884_/A VGND VGND VPWR VPWR _6884_/Y sky130_fd_sc_hd__inv_2
XFILLER_62_670 VGND VGND VPWR VPWR sky130_fd_sc_hd__decap_3
XTAP_TAPCELL_ROW_66_1173 VGND VPWR sky130_fd_sc_hd__tapvpwrvgnd_1
X_8623_ _8642_/A _8676_/B VGND VGND VPWR VPWR _8623_/Y sky130_fd_sc_hd__nor2_2
XFILLER_34_383 VGND VGND VPWR VPWR sky130_fd_sc_hd__decap_3
X_5835_ _7311_/A _7805_/A _5699_/A _5699_/B VGND VGND VPWR VPWR _5835_/X sky130_fd_sc_hd__o22a_2
XTAP_TAPCELL_ROW_45_890 VGND VPWR sky130_fd_sc_hd__tapvpwrvgnd_1
XFILLER_14_27 VGND VGND VPWR VPWR sky130_fd_sc_hd__fill_1
XFILLER_22_556 VGND VGND VPWR VPWR sky130_fd_sc_hd__decap_3
XFILLER_10_707 VGND VGND VPWR VPWR sky130_fd_sc_hd__decap_3
X_8554_ _8627_/A _8554_/B VGND VGND VPWR VPWR _8555_/B sky130_fd_sc_hd__and2_2
X_5766_ _5766_/A _5766_/B VGND VGND VPWR VPWR _5768_/C sky130_fd_sc_hd__or2_2
XFILLER_22_589 VGND VGND VPWR VPWR sky130_fd_sc_hd__decap_3
X_7505_ _7394_/A _7393_/A _7564_/C VGND VGND VPWR VPWR _7507_/A sky130_fd_sc_hd__o21bai_2
X_4717_ _4750_/A1 _4717_/A1 _4735_/S VGND VGND VPWR VPWR _4718_/A sky130_fd_sc_hd__mux2_2
X_8485_ _8514_/A _8482_/X _8484_/X VGND VGND VPWR VPWR _8486_/B sky130_fd_sc_hd__o21ai_2
X_5697_ _5019_/X _5272_/X _5201_/A VGND VGND VPWR VPWR _5699_/A sky130_fd_sc_hd__a21o_2
X_7436_ _7436_/A _7436_/B _7436_/C _7436_/D VGND VGND VPWR VPWR _7624_/B sky130_fd_sc_hd__or4_4
X_4648_ _9074_/Q _4648_/A1 _4650_/S VGND VGND VPWR VPWR _4648_/X sky130_fd_sc_hd__mux2_2
XFILLER_107_138 VGND VGND VPWR VPWR sky130_fd_sc_hd__decap_3
XFILLER_107_149 VGND VGND VPWR VPWR sky130_fd_sc_hd__fill_1
XFILLER_123_609 VGND VGND VPWR VPWR sky130_fd_sc_hd__decap_3
X_7367_ _8345_/A _7123_/B _9213_/Q VGND VGND VPWR VPWR _7367_/X sky130_fd_sc_hd__mux2_2
X_4579_ _9041_/Q hold841/X _4587_/S VGND VGND VPWR VPWR _4579_/X sky130_fd_sc_hd__mux2_2
XFILLER_89_501 VGND VGND VPWR VPWR sky130_fd_sc_hd__decap_3
Xhold752 _8791_/X VGND VGND VPWR VPWR _8792_/A sky130_fd_sc_hd__dlygate4sd3_1
Xhold763 input16/X VGND VGND VPWR VPWR hold763/X sky130_fd_sc_hd__dlygate4sd3_1
X_9106_ _9341_/CLK _9106_/D load_slew378/X VGND VGND VPWR VPWR _9106_/Q sky130_fd_sc_hd__dfrtp_2
X_6318_ _7093_/A _8405_/A _6212_/B VGND VGND VPWR VPWR _6318_/Y sky130_fd_sc_hd__a21oi_2
Xhold774 _7549_/A VGND VGND VPWR VPWR hold774/X sky130_fd_sc_hd__dlygate4sd3_1
Xhold785 _4884_/X VGND VGND VPWR VPWR _9182_/D sky130_fd_sc_hd__dlygate4sd3_1
XFILLER_1_438 VGND VGND VPWR VPWR sky130_fd_sc_hd__decap_3
X_7298_ _7298_/A _8137_/B VGND VGND VPWR VPWR _7299_/B sky130_fd_sc_hd__xnor2_2
Xhold796 _4879_/X VGND VGND VPWR VPWR _9180_/D sky130_fd_sc_hd__dlygate4sd3_1
XFILLER_103_333 VGND VGND VPWR VPWR sky130_fd_sc_hd__decap_3
XFILLER_103_355 VGND VGND VPWR VPWR sky130_fd_sc_hd__decap_3
X_9037_ _9133_/CLK _9037_/D load_slew394/X VGND VGND VPWR VPWR _9037_/Q sky130_fd_sc_hd__dfrtp_2
XFILLER_77_718 VGND VGND VPWR VPWR sky130_fd_sc_hd__decap_3
XFILLER_130_141 VGND VGND VPWR VPWR sky130_fd_sc_hd__decap_3
X_6249_ _6249_/A VGND VGND VPWR VPWR _8232_/A sky130_fd_sc_hd__buf_2
XFILLER_89_589 VGND VGND VPWR VPWR sky130_fd_sc_hd__decap_3
XFILLER_77_729 VGND VGND VPWR VPWR sky130_fd_sc_hd__decap_3
XFILLER_39_57 VGND VGND VPWR VPWR sky130_fd_sc_hd__decap_3
XTAP_TAPCELL_ROW_90_1491 VGND VPWR sky130_fd_sc_hd__tapvpwrvgnd_1
XFILLER_103_399 VGND VGND VPWR VPWR sky130_fd_sc_hd__fill_1
XFILLER_29_133 VGND VGND VPWR VPWR sky130_fd_sc_hd__decap_3
XFILLER_57_464 VGND VGND VPWR VPWR sky130_fd_sc_hd__decap_3
XFILLER_55_12 VGND VGND VPWR VPWR sky130_fd_sc_hd__decap_3
XFILLER_45_615 VGND VGND VPWR VPWR sky130_fd_sc_hd__fill_1
XFILLER_45_626 VGND VGND VPWR VPWR sky130_fd_sc_hd__decap_3
XFILLER_29_177 VGND VGND VPWR VPWR sky130_fd_sc_hd__decap_3
XFILLER_57_497 VGND VGND VPWR VPWR sky130_fd_sc_hd__decap_3
XFILLER_45_637 VGND VGND VPWR VPWR sky130_fd_sc_hd__decap_3
XFILLER_55_45 VGND VGND VPWR VPWR sky130_fd_sc_hd__decap_3
XFILLER_55_67 VGND VGND VPWR VPWR sky130_fd_sc_hd__decap_3
XFILLER_44_147 VGND VGND VPWR VPWR sky130_fd_sc_hd__decap_3
XFILLER_72_467 VGND VGND VPWR VPWR sky130_fd_sc_hd__decap_3
XFILLER_60_607 VGND VGND VPWR VPWR sky130_fd_sc_hd__decap_3
XFILLER_111_51 VGND VGND VPWR VPWR sky130_fd_sc_hd__decap_3
XFILLER_71_11 VGND VGND VPWR VPWR sky130_fd_sc_hd__fill_2
XFILLER_13_523 VGND VGND VPWR VPWR sky130_fd_sc_hd__decap_3
XFILLER_111_84 VGND VGND VPWR VPWR sky130_fd_sc_hd__decap_3
XFILLER_9_505 VGND VGND VPWR VPWR sky130_fd_sc_hd__decap_3
XFILLER_71_55 VGND VGND VPWR VPWR sky130_fd_sc_hd__fill_1
XTAP_TAPCELL_ROW_23_595 VGND VPWR sky130_fd_sc_hd__tapvpwrvgnd_1
XFILLER_5_700 VGND VGND VPWR VPWR sky130_fd_sc_hd__decap_3
XFILLER_5_744 VGND VGND VPWR VPWR sky130_fd_sc_hd__decap_3
XFILLER_4_265 VGND VGND VPWR VPWR sky130_fd_sc_hd__decap_3
XFILLER_20_70 VGND VGND VPWR VPWR sky130_fd_sc_hd__fill_1
XFILLER_107_694 VGND VGND VPWR VPWR sky130_fd_sc_hd__decap_3
XFILLER_122_642 VGND VGND VPWR VPWR sky130_fd_sc_hd__fill_2
XFILLER_95_515 VGND VGND VPWR VPWR sky130_fd_sc_hd__decap_3
XFILLER_122_675 VGND VGND VPWR VPWR sky130_fd_sc_hd__decap_3
XFILLER_121_152 VGND VGND VPWR VPWR sky130_fd_sc_hd__decap_3
XFILLER_67_228 VGND VGND VPWR VPWR sky130_fd_sc_hd__decap_3
XFILLER_96_85 VGND VGND VPWR VPWR sky130_fd_sc_hd__fill_2
XFILLER_96_96 VGND VGND VPWR VPWR sky130_fd_sc_hd__fill_2
XFILLER_95_559 VGND VGND VPWR VPWR sky130_fd_sc_hd__fill_1
XFILLER_121_196 VGND VGND VPWR VPWR sky130_fd_sc_hd__decap_3
XFILLER_76_751 VGND VGND VPWR VPWR sky130_fd_sc_hd__decap_3
XFILLER_48_453 VGND VGND VPWR VPWR sky130_fd_sc_hd__decap_3
XFILLER_48_486 VGND VGND VPWR VPWR sky130_fd_sc_hd__decap_3
XFILLER_35_103 VGND VGND VPWR VPWR sky130_fd_sc_hd__fill_2
XFILLER_35_125 VGND VGND VPWR VPWR sky130_fd_sc_hd__fill_1
XPHY_EDGE_ROW_11_Left_142 VGND VGND VPWR VPWR sky130_fd_sc_hd__decap_3
XFILLER_90_242 VGND VGND VPWR VPWR sky130_fd_sc_hd__decap_3
XFILLER_63_467 VGND VGND VPWR VPWR sky130_fd_sc_hd__fill_1
XFILLER_51_629 VGND VGND VPWR VPWR sky130_fd_sc_hd__decap_3
XFILLER_90_286 VGND VGND VPWR VPWR sky130_fd_sc_hd__decap_3
XFILLER_50_128 VGND VGND VPWR VPWR sky130_fd_sc_hd__decap_3
X_5620_ _4934_/A _5878_/C _5618_/X _5619_/X _5991_/B1 VGND VGND VPWR VPWR _5626_/A
+ sky130_fd_sc_hd__a32o_2
XFILLER_84_3 VGND VGND VPWR VPWR sky130_fd_sc_hd__decap_3
X_5551_ _5549_/Y _5550_/X _4970_/X VGND VGND VPWR VPWR _5552_/B sky130_fd_sc_hd__a21o_2
XFILLER_8_560 VGND VGND VPWR VPWR sky130_fd_sc_hd__fill_2
XFILLER_129_263 VGND VGND VPWR VPWR sky130_fd_sc_hd__decap_3
XFILLER_117_403 VGND VGND VPWR VPWR sky130_fd_sc_hd__decap_3
X_8270_ _9220_/Q _8216_/B _8266_/Y _8271_/B wire66/X VGND VGND VPWR VPWR _8270_/X
+ sky130_fd_sc_hd__a221o_2
X_5482_ _5482_/A _5482_/B VGND VGND VPWR VPWR _5489_/A sky130_fd_sc_hd__xnor2_2
XPHY_EDGE_ROW_20_Left_151 VGND VGND VPWR VPWR sky130_fd_sc_hd__decap_3
XFILLER_6_50 VGND VGND VPWR VPWR sky130_fd_sc_hd__decap_3
X_7221_ _7181_/A _5231_/Y _6805_/A _6873_/Y _5220_/X VGND VGND VPWR VPWR _7221_/X
+ sky130_fd_sc_hd__a221o_2
XFILLER_117_469 VGND VGND VPWR VPWR sky130_fd_sc_hd__decap_3
X_7152_ _6900_/X _7148_/A _7149_/X _6894_/A _7151_/X VGND VGND VPWR VPWR _7510_/A
+ sky130_fd_sc_hd__o221a_4
XFILLER_116_18 VGND VGND VPWR VPWR sky130_fd_sc_hd__decap_3
XFILLER_113_620 VGND VGND VPWR VPWR sky130_fd_sc_hd__decap_3
XFILLER_116_29 VGND VGND VPWR VPWR sky130_fd_sc_hd__decap_3
X_6103_ _6100_/X _6102_/X _6103_/S VGND VGND VPWR VPWR _6103_/X sky130_fd_sc_hd__mux2_2
XFILLER_59_718 VGND VGND VPWR VPWR sky130_fd_sc_hd__decap_3
X_7083_ _7083_/A VGND VGND VPWR VPWR _7416_/B sky130_fd_sc_hd__clkbuf_1
XFILLER_59_729 VGND VGND VPWR VPWR sky130_fd_sc_hd__decap_3
XFILLER_112_152 VGND VGND VPWR VPWR sky130_fd_sc_hd__decap_3
XFILLER_98_397 VGND VGND VPWR VPWR sky130_fd_sc_hd__decap_3
X_6034_ _7329_/C VGND VGND VPWR VPWR _8405_/A sky130_fd_sc_hd__clkbuf_2
XFILLER_58_239 VGND VGND VPWR VPWR sky130_fd_sc_hd__fill_2
XFILLER_100_347 VGND VGND VPWR VPWR sky130_fd_sc_hd__decap_3
XFILLER_67_773 VGND VGND VPWR VPWR sky130_fd_sc_hd__decap_3
XTAP_TAPCELL_ROW_68_1202 VGND VPWR sky130_fd_sc_hd__tapvpwrvgnd_1
XFILLER_27_615 VGND VGND VPWR VPWR sky130_fd_sc_hd__fill_1
XFILLER_82_710 VGND VGND VPWR VPWR sky130_fd_sc_hd__decap_3
XFILLER_54_412 VGND VGND VPWR VPWR sky130_fd_sc_hd__decap_3
XFILLER_39_486 VGND VGND VPWR VPWR sky130_fd_sc_hd__decap_3
XFILLER_94_592 VGND VGND VPWR VPWR sky130_fd_sc_hd__decap_3
X_7985_ _8111_/A _7985_/B VGND VGND VPWR VPWR _7989_/A sky130_fd_sc_hd__xnor2_2
XFILLER_82_754 VGND VGND VPWR VPWR sky130_fd_sc_hd__fill_2
XFILLER_54_445 VGND VGND VPWR VPWR sky130_fd_sc_hd__fill_1
XFILLER_54_467 VGND VGND VPWR VPWR sky130_fd_sc_hd__decap_3
XFILLER_42_607 VGND VGND VPWR VPWR sky130_fd_sc_hd__fill_2
XFILLER_14_309 VGND VGND VPWR VPWR sky130_fd_sc_hd__decap_3
X_6936_ _7480_/C _6936_/B VGND VGND VPWR VPWR _6936_/Y sky130_fd_sc_hd__nor2_2
XFILLER_81_264 VGND VGND VPWR VPWR sky130_fd_sc_hd__decap_3
XFILLER_41_106 VGND VGND VPWR VPWR sky130_fd_sc_hd__decap_3
XFILLER_35_670 VGND VGND VPWR VPWR sky130_fd_sc_hd__fill_2
XFILLER_81_297 VGND VGND VPWR VPWR sky130_fd_sc_hd__decap_3
XFILLER_41_128 VGND VGND VPWR VPWR sky130_fd_sc_hd__decap_3
X_6867_ _6865_/Y _6832_/B _6866_/X VGND VGND VPWR VPWR _7159_/A sky130_fd_sc_hd__o21ai_2
X_8606_ _8579_/Y _8576_/A _8576_/B VGND VGND VPWR VPWR _8607_/A sky130_fd_sc_hd__a21bo_2
XTAP_TAPCELL_ROW_40_819 VGND VPWR sky130_fd_sc_hd__tapvpwrvgnd_1
X_5818_ _5820_/B _5973_/B _5973_/A VGND VGND VPWR VPWR _5819_/C sky130_fd_sc_hd__o21a_2
X_6798_ _7877_/A _6797_/Y _6798_/S VGND VGND VPWR VPWR _6798_/X sky130_fd_sc_hd__mux2_2
X_8537_ _8549_/A _8554_/B VGND VGND VPWR VPWR _8538_/B sky130_fd_sc_hd__or2_2
X_5749_ _7955_/A _5749_/B VGND VGND VPWR VPWR _5749_/X sky130_fd_sc_hd__or2_2
XTAP_TAPCELL_ROW_20_554 VGND VPWR sky130_fd_sc_hd__tapvpwrvgnd_1
XTAP_TAPCELL_ROW_79_1342 VGND VPWR sky130_fd_sc_hd__tapvpwrvgnd_1
XFILLER_108_436 VGND VGND VPWR VPWR sky130_fd_sc_hd__decap_3
X_8468_ _8397_/A _8421_/X _8337_/Y VGND VGND VPWR VPWR _8482_/B sky130_fd_sc_hd__o21a_2
XTAP_TAPCELL_ROW_79_1353 VGND VPWR sky130_fd_sc_hd__tapvpwrvgnd_1
XFILLER_108_469 VGND VGND VPWR VPWR sky130_fd_sc_hd__decap_3
X_7419_ _7419_/A _7419_/B VGND VGND VPWR VPWR _7590_/C sky130_fd_sc_hd__xnor2_2
X_8399_ _8399_/A _8399_/B VGND VGND VPWR VPWR _8399_/Y sky130_fd_sc_hd__xnor2_2
XTAP_TAPCELL_ROW_92_1520 VGND VPWR sky130_fd_sc_hd__tapvpwrvgnd_1
XFILLER_123_428 VGND VGND VPWR VPWR sky130_fd_sc_hd__decap_3
XFILLER_2_725 VGND VGND VPWR VPWR sky130_fd_sc_hd__decap_3
XFILLER_104_620 VGND VGND VPWR VPWR sky130_fd_sc_hd__decap_3
XFILLER_2_769 VGND VGND VPWR VPWR sky130_fd_sc_hd__decap_3
XFILLER_103_152 VGND VGND VPWR VPWR sky130_fd_sc_hd__fill_1
XFILLER_92_518 VGND VGND VPWR VPWR sky130_fd_sc_hd__decap_3
XFILLER_64_209 VGND VGND VPWR VPWR sky130_fd_sc_hd__fill_2
XFILLER_58_773 VGND VGND VPWR VPWR sky130_fd_sc_hd__decap_3
XFILLER_66_88 VGND VGND VPWR VPWR sky130_fd_sc_hd__decap_3
XFILLER_18_626 VGND VGND VPWR VPWR sky130_fd_sc_hd__decap_3
XFILLER_45_423 VGND VGND VPWR VPWR sky130_fd_sc_hd__decap_3
XFILLER_72_231 VGND VGND VPWR VPWR sky130_fd_sc_hd__fill_1
XFILLER_122_50 VGND VGND VPWR VPWR sky130_fd_sc_hd__decap_3
XTAP_TAPCELL_ROW_28_654 VGND VPWR sky130_fd_sc_hd__tapvpwrvgnd_1
XFILLER_45_467 VGND VGND VPWR VPWR sky130_fd_sc_hd__decap_3
XTAP_TAPCELL_ROW_28_665 VGND VPWR sky130_fd_sc_hd__tapvpwrvgnd_1
XFILLER_122_83 VGND VGND VPWR VPWR sky130_fd_sc_hd__fill_1
XFILLER_122_94 VGND VGND VPWR VPWR sky130_fd_sc_hd__decap_3
XFILLER_13_331 VGND VGND VPWR VPWR sky130_fd_sc_hd__decap_3
XFILLER_41_673 VGND VGND VPWR VPWR sky130_fd_sc_hd__decap_3
XFILLER_15_81 VGND VGND VPWR VPWR sky130_fd_sc_hd__decap_3
XFILLER_13_375 VGND VGND VPWR VPWR sky130_fd_sc_hd__decap_3
XFILLER_9_335 VGND VGND VPWR VPWR sky130_fd_sc_hd__fill_1
XFILLER_40_172 VGND VGND VPWR VPWR sky130_fd_sc_hd__decap_3
XFILLER_127_712 VGND VGND VPWR VPWR sky130_fd_sc_hd__decap_3
XFILLER_126_200 VGND VGND VPWR VPWR sky130_fd_sc_hd__decap_3
XFILLER_127_756 VGND VGND VPWR VPWR sky130_fd_sc_hd__decap_3
XFILLER_126_233 VGND VGND VPWR VPWR sky130_fd_sc_hd__decap_3
XTAP_TAPCELL_ROW_130_2034 VGND VPWR sky130_fd_sc_hd__tapvpwrvgnd_1
XFILLER_5_574 VGND VGND VPWR VPWR sky130_fd_sc_hd__decap_3
XFILLER_126_277 VGND VGND VPWR VPWR sky130_fd_sc_hd__decap_3
XTAP_TAPCELL_ROW_130_2045 VGND VPWR sky130_fd_sc_hd__tapvpwrvgnd_1
XTAP_TAPCELL_ROW_130_2056 VGND VPWR sky130_fd_sc_hd__tapvpwrvgnd_1
XFILLER_99_139 VGND VGND VPWR VPWR sky130_fd_sc_hd__fill_1
XFILLER_114_439 VGND VGND VPWR VPWR sky130_fd_sc_hd__fill_1
XFILLER_49_6 VGND VGND VPWR VPWR sky130_fd_sc_hd__fill_2
XFILLER_68_504 VGND VGND VPWR VPWR sky130_fd_sc_hd__decap_3
XFILLER_110_601 VGND VGND VPWR VPWR sky130_fd_sc_hd__decap_3
XFILLER_95_312 VGND VGND VPWR VPWR sky130_fd_sc_hd__decap_3
XFILLER_122_483 VGND VGND VPWR VPWR sky130_fd_sc_hd__decap_3
XTAP_TAPCELL_ROW_8_390 VGND VPWR sky130_fd_sc_hd__tapvpwrvgnd_1
XFILLER_110_645 VGND VGND VPWR VPWR sky130_fd_sc_hd__decap_3
XFILLER_68_559 VGND VGND VPWR VPWR sky130_fd_sc_hd__decap_3
XFILLER_95_356 VGND VGND VPWR VPWR sky130_fd_sc_hd__decap_3
XFILLER_0_290 VGND VGND VPWR VPWR sky130_fd_sc_hd__decap_3
XFILLER_49_751 VGND VGND VPWR VPWR sky130_fd_sc_hd__decap_3
XFILLER_110_678 VGND VGND VPWR VPWR sky130_fd_sc_hd__decap_3
XFILLER_49_773 VGND VGND VPWR VPWR sky130_fd_sc_hd__decap_3
XFILLER_63_231 VGND VGND VPWR VPWR sky130_fd_sc_hd__fill_1
XFILLER_64_776 VGND VGND VPWR VPWR sky130_fd_sc_hd__fill_1
XFILLER_91_573 VGND VGND VPWR VPWR sky130_fd_sc_hd__decap_3
X_7770_ _7770_/A _7770_/B VGND VGND VPWR VPWR _7772_/A sky130_fd_sc_hd__xnor2_2
X_4982_ _6206_/A _4978_/Y _4981_/Y _5283_/A VGND VGND VPWR VPWR _7050_/A sky130_fd_sc_hd__a211o_2
XFILLER_51_437 VGND VGND VPWR VPWR sky130_fd_sc_hd__decap_3
X_6721_ _5566_/A _7071_/B _5629_/A _6963_/B VGND VGND VPWR VPWR _6723_/B sky130_fd_sc_hd__a211o_2
XTAP_TAPCELL_ROW_63_1132 VGND VPWR sky130_fd_sc_hd__tapvpwrvgnd_1
XFILLER_16_180 VGND VGND VPWR VPWR sky130_fd_sc_hd__decap_3
X_6652_ _6652_/A _6652_/B VGND VGND VPWR VPWR _6652_/Y sky130_fd_sc_hd__xnor2_2
XFILLER_31_150 VGND VGND VPWR VPWR sky130_fd_sc_hd__fill_2
XFILLER_32_684 VGND VGND VPWR VPWR sky130_fd_sc_hd__decap_3
XFILLER_31_161 VGND VGND VPWR VPWR sky130_fd_sc_hd__decap_3
X_5603_ _5603_/A _5603_/B VGND VGND VPWR VPWR _5705_/B sky130_fd_sc_hd__xnor2_2
X_6583_ _6583_/A _6583_/B VGND VGND VPWR VPWR _6676_/A sky130_fd_sc_hd__nand2_2
XFILLER_118_701 VGND VGND VPWR VPWR sky130_fd_sc_hd__decap_3
X_8322_ _8322_/A _8322_/B VGND VGND VPWR VPWR _8322_/X sky130_fd_sc_hd__or2_2
XFILLER_118_734 VGND VGND VPWR VPWR sky130_fd_sc_hd__decap_3
X_5534_ _5528_/A _5528_/C _5533_/X VGND VGND VPWR VPWR _5561_/A sky130_fd_sc_hd__o21a_2
XFILLER_11_39 VGND VGND VPWR VPWR sky130_fd_sc_hd__decap_3
XFILLER_117_244 VGND VGND VPWR VPWR sky130_fd_sc_hd__decap_3
XTAP_TAPCELL_ROW_115_1829 VGND VPWR sky130_fd_sc_hd__tapvpwrvgnd_1
XFILLER_105_406 VGND VGND VPWR VPWR sky130_fd_sc_hd__decap_3
X_8253_ _8253_/A _8253_/B VGND VGND VPWR VPWR _8254_/B sky130_fd_sc_hd__xnor2_2
X_5465_ _9293_/Q _5457_/X _5460_/X _6756_/C _5464_/X VGND VGND VPWR VPWR _5830_/B
+ sky130_fd_sc_hd__a221oi_4
XFILLER_127_39 VGND VGND VPWR VPWR sky130_fd_sc_hd__decap_3
XFILLER_105_439 VGND VGND VPWR VPWR sky130_fd_sc_hd__decap_3
X_7204_ _6882_/A _6881_/B _7202_/X _7203_/Y VGND VGND VPWR VPWR _7204_/X sky130_fd_sc_hd__a22o_2
X_8184_ _8184_/A _8184_/B VGND VGND VPWR VPWR _8184_/X sky130_fd_sc_hd__or2_4
X_5396_ _5396_/A _5493_/C VGND VGND VPWR VPWR _5402_/A sky130_fd_sc_hd__xor2_2
X_7135_ _7273_/B _7273_/A VGND VGND VPWR VPWR _7285_/C sky130_fd_sc_hd__or2_4
Xfanout314 input18/X VGND VGND VPWR VPWR wire316/A sky130_fd_sc_hd__clkdlybuf4s25_1
XFILLER_99_673 VGND VGND VPWR VPWR sky130_fd_sc_hd__decap_3
Xfanout325 _7227_/B1 VGND VGND VPWR VPWR _5926_/B sky130_fd_sc_hd__dlymetal6s4s_1
XTAP_TAPCELL_ROW_74_1283 VGND VPWR sky130_fd_sc_hd__tapvpwrvgnd_1
XFILLER_113_461 VGND VGND VPWR VPWR sky130_fd_sc_hd__decap_3
XFILLER_59_526 VGND VGND VPWR VPWR sky130_fd_sc_hd__decap_3
XFILLER_101_623 VGND VGND VPWR VPWR sky130_fd_sc_hd__decap_3
Xfanout336 _6426_/A VGND VGND VPWR VPWR _7534_/A sky130_fd_sc_hd__dlymetal6s4s_1
XFILLER_86_312 VGND VGND VPWR VPWR sky130_fd_sc_hd__fill_2
XFILLER_86_323 VGND VGND VPWR VPWR sky130_fd_sc_hd__decap_3
XFILLER_59_537 VGND VGND VPWR VPWR sky130_fd_sc_hd__decap_3
Xfanout358 input11/X VGND VGND VPWR VPWR _5950_/B sky130_fd_sc_hd__clkdlybuf4s25_1
XFILLER_98_194 VGND VGND VPWR VPWR sky130_fd_sc_hd__fill_2
X_7066_ _7417_/A _7071_/D VGND VGND VPWR VPWR _7326_/A sky130_fd_sc_hd__nand2_2
Xfanout369 fanout391/A VGND VGND VPWR VPWR fanout369/X sky130_fd_sc_hd__clkdlybuf4s25_1
XFILLER_86_356 VGND VGND VPWR VPWR sky130_fd_sc_hd__decap_3
XFILLER_100_144 VGND VGND VPWR VPWR sky130_fd_sc_hd__fill_1
X_6017_ _6939_/A _6963_/D VGND VGND VPWR VPWR _6017_/Y sky130_fd_sc_hd__nor2_2
XFILLER_67_570 VGND VGND VPWR VPWR sky130_fd_sc_hd__decap_3
XFILLER_27_412 VGND VGND VPWR VPWR sky130_fd_sc_hd__decap_3
XFILLER_67_592 VGND VGND VPWR VPWR sky130_fd_sc_hd__decap_3
XFILLER_55_732 VGND VGND VPWR VPWR sky130_fd_sc_hd__decap_3
XFILLER_36_47 VGND VGND VPWR VPWR sky130_fd_sc_hd__decap_3
XFILLER_54_253 VGND VGND VPWR VPWR sky130_fd_sc_hd__fill_1
XFILLER_42_404 VGND VGND VPWR VPWR sky130_fd_sc_hd__decap_3
XFILLER_15_629 VGND VGND VPWR VPWR sky130_fd_sc_hd__fill_2
X_7968_ _8406_/A VGND VGND VPWR VPWR _8216_/A sky130_fd_sc_hd__clkbuf_1
XFILLER_82_584 VGND VGND VPWR VPWR sky130_fd_sc_hd__decap_3
XFILLER_54_275 VGND VGND VPWR VPWR sky130_fd_sc_hd__fill_2
XTAP_TAPCELL_ROW_25_613 VGND VPWR sky130_fd_sc_hd__tapvpwrvgnd_1
XTAP_TAPCELL_ROW_25_624 VGND VPWR sky130_fd_sc_hd__tapvpwrvgnd_1
XFILLER_70_746 VGND VGND VPWR VPWR sky130_fd_sc_hd__decap_3
XFILLER_54_297 VGND VGND VPWR VPWR sky130_fd_sc_hd__decap_3
XFILLER_42_437 VGND VGND VPWR VPWR sky130_fd_sc_hd__decap_3
XFILLER_70_757 VGND VGND VPWR VPWR sky130_fd_sc_hd__decap_3
XFILLER_14_139 VGND VGND VPWR VPWR sky130_fd_sc_hd__fill_1
X_6919_ _7274_/B _6919_/B VGND VGND VPWR VPWR _7277_/B sky130_fd_sc_hd__xor2_2
X_7899_ _7899_/A _7899_/B VGND VGND VPWR VPWR _7899_/Y sky130_fd_sc_hd__nor2_2
XFILLER_52_24 VGND VGND VPWR VPWR sky130_fd_sc_hd__decap_3
XTAP_TAPCELL_ROW_53_999 VGND VPWR sky130_fd_sc_hd__tapvpwrvgnd_1
XFILLER_23_673 VGND VGND VPWR VPWR sky130_fd_sc_hd__fill_1
XFILLER_50_470 VGND VGND VPWR VPWR sky130_fd_sc_hd__decap_3
XFILLER_52_79 VGND VGND VPWR VPWR sky130_fd_sc_hd__decap_3
XFILLER_109_723 VGND VGND VPWR VPWR sky130_fd_sc_hd__decap_3
XFILLER_10_378 VGND VGND VPWR VPWR sky130_fd_sc_hd__fill_2
XFILLER_10_389 VGND VGND VPWR VPWR sky130_fd_sc_hd__decap_3
XFILLER_109_767 VGND VGND VPWR VPWR sky130_fd_sc_hd__fill_2
XFILLER_124_704 VGND VGND VPWR VPWR sky130_fd_sc_hd__decap_3
XFILLER_2_500 VGND VGND VPWR VPWR sky130_fd_sc_hd__decap_3
XFILLER_124_737 VGND VGND VPWR VPWR sky130_fd_sc_hd__decap_3
XFILLER_123_214 VGND VGND VPWR VPWR sky130_fd_sc_hd__decap_3
XFILLER_2_533 VGND VGND VPWR VPWR sky130_fd_sc_hd__decap_3
XFILLER_111_409 VGND VGND VPWR VPWR sky130_fd_sc_hd__fill_2
XFILLER_117_72 VGND VGND VPWR VPWR sky130_fd_sc_hd__decap_3
XFILLER_77_32 VGND VGND VPWR VPWR sky130_fd_sc_hd__decap_3
XFILLER_37_209 VGND VGND VPWR VPWR sky130_fd_sc_hd__decap_3
XFILLER_92_304 VGND VGND VPWR VPWR sky130_fd_sc_hd__decap_3
XFILLER_65_529 VGND VGND VPWR VPWR sky130_fd_sc_hd__decap_3
XFILLER_58_570 VGND VGND VPWR VPWR sky130_fd_sc_hd__decap_3
XFILLER_18_412 VGND VGND VPWR VPWR sky130_fd_sc_hd__fill_1
XFILLER_58_592 VGND VGND VPWR VPWR sky130_fd_sc_hd__decap_3
XFILLER_18_434 VGND VGND VPWR VPWR sky130_fd_sc_hd__decap_3
Xhold1090 _4744_/X VGND VGND VPWR VPWR _4745_/A sky130_fd_sc_hd__dlygate4sd3_1
XFILLER_93_53 VGND VGND VPWR VPWR sky130_fd_sc_hd__decap_3
XFILLER_45_242 VGND VGND VPWR VPWR sky130_fd_sc_hd__decap_3
XFILLER_73_584 VGND VGND VPWR VPWR sky130_fd_sc_hd__decap_3
XFILLER_61_735 VGND VGND VPWR VPWR sky130_fd_sc_hd__decap_3
XFILLER_45_297 VGND VGND VPWR VPWR sky130_fd_sc_hd__fill_1
XFILLER_33_437 VGND VGND VPWR VPWR sky130_fd_sc_hd__decap_3
XFILLER_60_256 VGND VGND VPWR VPWR sky130_fd_sc_hd__decap_3
XFILLER_14_662 VGND VGND VPWR VPWR sky130_fd_sc_hd__decap_3
XFILLER_14_695 VGND VGND VPWR VPWR sky130_fd_sc_hd__decap_3
XFILLER_13_172 VGND VGND VPWR VPWR sky130_fd_sc_hd__fill_2
XFILLER_13_183 VGND VGND VPWR VPWR sky130_fd_sc_hd__decap_3
XFILLER_9_198 VGND VGND VPWR VPWR sky130_fd_sc_hd__decap_3
XFILLER_127_575 VGND VGND VPWR VPWR sky130_fd_sc_hd__decap_3
XFILLER_127_586 VGND VGND VPWR VPWR sky130_fd_sc_hd__decap_3
X_5250_ _9200_/Q _7764_/A VGND VGND VPWR VPWR _5251_/B sky130_fd_sc_hd__nand2_2
XFILLER_47_3 VGND VGND VPWR VPWR sky130_fd_sc_hd__decap_3
XFILLER_130_707 VGND VGND VPWR VPWR sky130_fd_sc_hd__decap_3
XFILLER_130_729 VGND VGND VPWR VPWR sky130_fd_sc_hd__decap_3
X_5181_ _9306_/Q _9102_/Q _5384_/A VGND VGND VPWR VPWR _5181_/X sky130_fd_sc_hd__mux2_2
XFILLER_68_312 VGND VGND VPWR VPWR sky130_fd_sc_hd__decap_3
XFILLER_3_51 VGND VGND VPWR VPWR sky130_fd_sc_hd__decap_3
XFILLER_96_654 VGND VGND VPWR VPWR sky130_fd_sc_hd__decap_3
XFILLER_110_442 VGND VGND VPWR VPWR sky130_fd_sc_hd__decap_3
XTAP_TAPCELL_ROW_3_319 VGND VPWR sky130_fd_sc_hd__tapvpwrvgnd_1
XFILLER_3_84 VGND VGND VPWR VPWR sky130_fd_sc_hd__decap_3
XFILLER_110_464 VGND VGND VPWR VPWR sky130_fd_sc_hd__decap_3
X_8940_ _9312_/Q hold896/X _8946_/S VGND VGND VPWR VPWR _8940_/X sky130_fd_sc_hd__mux2_2
XFILLER_83_326 VGND VGND VPWR VPWR sky130_fd_sc_hd__decap_3
XFILLER_83_337 VGND VGND VPWR VPWR sky130_fd_sc_hd__fill_1
XFILLER_49_581 VGND VGND VPWR VPWR sky130_fd_sc_hd__decap_3
X_8871_ _9279_/Q hold854/X _8883_/S VGND VGND VPWR VPWR _8871_/X sky130_fd_sc_hd__mux2_2
XFILLER_36_253 VGND VGND VPWR VPWR sky130_fd_sc_hd__fill_2
X_7822_ _7924_/A _8099_/C _7821_/X VGND VGND VPWR VPWR _7823_/B sky130_fd_sc_hd__a21oi_2
XFILLER_64_573 VGND VGND VPWR VPWR sky130_fd_sc_hd__decap_3
XFILLER_52_724 VGND VGND VPWR VPWR sky130_fd_sc_hd__decap_3
XFILLER_64_595 VGND VGND VPWR VPWR sky130_fd_sc_hd__decap_3
XFILLER_52_757 VGND VGND VPWR VPWR sky130_fd_sc_hd__fill_2
X_7753_ _7634_/Y _7647_/B _7752_/X VGND VGND VPWR VPWR _7847_/A sky130_fd_sc_hd__o21a_2
X_4965_ _5855_/A VGND VGND VPWR VPWR _6304_/A sky130_fd_sc_hd__clkbuf_2
X_6704_ _6705_/B _6705_/C _6705_/A _6705_/D VGND VGND VPWR VPWR _6704_/X sky130_fd_sc_hd__a31o_4
X_7684_ _7684_/A _7684_/B VGND VGND VPWR VPWR _7711_/B sky130_fd_sc_hd__xnor2_2
X_4896_ _4876_/X _4895_/Y _4878_/X hold793/X VGND VGND VPWR VPWR _4896_/X sky130_fd_sc_hd__a2bb2o_2
XTAP_TAPCELL_ROW_50_958 VGND VPWR sky130_fd_sc_hd__tapvpwrvgnd_1
X_6635_ _6661_/A _6661_/B VGND VGND VPWR VPWR _6636_/B sky130_fd_sc_hd__xnor2_2
XFILLER_22_27 VGND VGND VPWR VPWR sky130_fd_sc_hd__fill_1
XFILLER_20_654 VGND VGND VPWR VPWR sky130_fd_sc_hd__decap_3
XFILLER_22_49 VGND VGND VPWR VPWR sky130_fd_sc_hd__decap_3
XFILLER_20_698 VGND VGND VPWR VPWR sky130_fd_sc_hd__fill_2
X_6566_ _6564_/X _6566_/B VGND VGND VPWR VPWR _6567_/B sky130_fd_sc_hd__and2b_2
XTAP_TAPCELL_ROW_30_682 VGND VPWR sky130_fd_sc_hd__tapvpwrvgnd_1
XTAP_TAPCELL_ROW_76_1301 VGND VPWR sky130_fd_sc_hd__tapvpwrvgnd_1
XTAP_TAPCELL_ROW_30_693 VGND VPWR sky130_fd_sc_hd__tapvpwrvgnd_1
XFILLER_118_9 VGND VGND VPWR VPWR sky130_fd_sc_hd__decap_3
X_8305_ _8276_/B _8303_/X _8304_/X VGND VGND VPWR VPWR _8385_/A sky130_fd_sc_hd__a21oi_2
XTAP_TAPCELL_ROW_76_1312 VGND VPWR sky130_fd_sc_hd__tapvpwrvgnd_1
XFILLER_106_715 VGND VGND VPWR VPWR sky130_fd_sc_hd__decap_3
X_5517_ _5790_/A VGND VGND VPWR VPWR _5930_/C sky130_fd_sc_hd__inv_2
X_9285_ _9346_/CLK _9285_/D wire406/X VGND VGND VPWR VPWR _9285_/Q sky130_fd_sc_hd__dfrtp_2
XFILLER_118_575 VGND VGND VPWR VPWR sky130_fd_sc_hd__decap_3
X_6497_ _6442_/B _6497_/B VGND VGND VPWR VPWR _6497_/X sky130_fd_sc_hd__and2b_2
XFILLER_105_225 VGND VGND VPWR VPWR sky130_fd_sc_hd__decap_3
X_8236_ _7065_/B _6253_/B _7604_/A VGND VGND VPWR VPWR _8237_/C sky130_fd_sc_hd__a21o_2
X_5448_ _7065_/A VGND VGND VPWR VPWR _7951_/A sky130_fd_sc_hd__clkbuf_2
XFILLER_0_9 VGND VGND VPWR VPWR sky130_fd_sc_hd__decap_3
XFILLER_121_729 VGND VGND VPWR VPWR sky130_fd_sc_hd__decap_3
X_8167_ _8239_/A _8167_/B _8167_/C VGND VGND VPWR VPWR _8168_/B sky130_fd_sc_hd__or3_2
X_5379_ _5463_/C _5879_/C _5379_/C VGND VGND VPWR VPWR _5386_/B sky130_fd_sc_hd__and3_2
XFILLER_99_470 VGND VGND VPWR VPWR sky130_fd_sc_hd__decap_3
XFILLER_87_632 VGND VGND VPWR VPWR sky130_fd_sc_hd__decap_3
X_7118_ _7112_/A _6946_/B _7117_/X _9212_/Q VGND VGND VPWR VPWR _7118_/Y sky130_fd_sc_hd__o211ai_2
X_8098_ _9218_/Q _8345_/A _7916_/Y _8104_/C _8097_/Y VGND VGND VPWR VPWR _8098_/X
+ sky130_fd_sc_hd__a32o_2
XFILLER_101_453 VGND VGND VPWR VPWR sky130_fd_sc_hd__decap_3
XFILLER_47_35 VGND VGND VPWR VPWR sky130_fd_sc_hd__fill_2
XFILLER_101_475 VGND VGND VPWR VPWR sky130_fd_sc_hd__decap_3
X_7049_ _6997_/A _6997_/B _7048_/X VGND VGND VPWR VPWR _7303_/A sky130_fd_sc_hd__o21a_2
XPHY_EDGE_ROW_29_Right_29 VGND VGND VPWR VPWR sky130_fd_sc_hd__decap_3
XFILLER_47_57 VGND VGND VPWR VPWR sky130_fd_sc_hd__decap_3
XFILLER_86_186 VGND VGND VPWR VPWR sky130_fd_sc_hd__decap_3
XFILLER_86_197 VGND VGND VPWR VPWR sky130_fd_sc_hd__fill_2
XFILLER_74_348 VGND VGND VPWR VPWR sky130_fd_sc_hd__decap_3
XFILLER_55_540 VGND VGND VPWR VPWR sky130_fd_sc_hd__decap_3
XTAP_TAPCELL_ROW_87_1452 VGND VPWR sky130_fd_sc_hd__tapvpwrvgnd_1
XFILLER_55_573 VGND VGND VPWR VPWR sky130_fd_sc_hd__decap_3
XFILLER_103_63 VGND VGND VPWR VPWR sky130_fd_sc_hd__decap_3
XFILLER_70_510 VGND VGND VPWR VPWR sky130_fd_sc_hd__fill_1
XTAP_TAPCELL_ROW_38_793 VGND VPWR sky130_fd_sc_hd__tapvpwrvgnd_1
XFILLER_27_297 VGND VGND VPWR VPWR sky130_fd_sc_hd__decap_3
XFILLER_63_78 VGND VGND VPWR VPWR sky130_fd_sc_hd__decap_3
XFILLER_30_418 VGND VGND VPWR VPWR sky130_fd_sc_hd__fill_2
XFILLER_8_18 VGND VGND VPWR VPWR sky130_fd_sc_hd__decap_3
XFILLER_23_481 VGND VGND VPWR VPWR sky130_fd_sc_hd__decap_3
XFILLER_8_29 VGND VGND VPWR VPWR sky130_fd_sc_hd__decap_3
XFILLER_10_120 VGND VGND VPWR VPWR sky130_fd_sc_hd__decap_3
XFILLER_128_306 VGND VGND VPWR VPWR sky130_fd_sc_hd__fill_2
XPHY_EDGE_ROW_38_Right_38 VGND VGND VPWR VPWR sky130_fd_sc_hd__decap_3
XFILLER_128_317 VGND VGND VPWR VPWR sky130_fd_sc_hd__decap_3
XFILLER_11_676 VGND VGND VPWR VPWR sky130_fd_sc_hd__fill_1
XFILLER_11_687 VGND VGND VPWR VPWR sky130_fd_sc_hd__decap_3
XFILLER_109_542 VGND VGND VPWR VPWR sky130_fd_sc_hd__decap_3
XFILLER_10_197 VGND VGND VPWR VPWR sky130_fd_sc_hd__fill_1
XFILLER_12_82 VGND VGND VPWR VPWR sky130_fd_sc_hd__fill_2
XFILLER_124_523 VGND VGND VPWR VPWR sky130_fd_sc_hd__fill_2
XFILLER_128_71 VGND VGND VPWR VPWR sky130_fd_sc_hd__decap_3
XFILLER_2_330 VGND VGND VPWR VPWR sky130_fd_sc_hd__decap_3
XFILLER_97_407 VGND VGND VPWR VPWR sky130_fd_sc_hd__fill_1
XFILLER_97_429 VGND VGND VPWR VPWR sky130_fd_sc_hd__fill_1
XFILLER_111_206 VGND VGND VPWR VPWR sky130_fd_sc_hd__decap_3
XFILLER_2_374 VGND VGND VPWR VPWR sky130_fd_sc_hd__fill_1
XFILLER_120_740 VGND VGND VPWR VPWR sky130_fd_sc_hd__decap_3
XPHY_EDGE_ROW_47_Right_47 VGND VGND VPWR VPWR sky130_fd_sc_hd__decap_3
XFILLER_78_665 VGND VGND VPWR VPWR sky130_fd_sc_hd__decap_3
XFILLER_38_529 VGND VGND VPWR VPWR sky130_fd_sc_hd__decap_3
XFILLER_92_101 VGND VGND VPWR VPWR sky130_fd_sc_hd__fill_1
XFILLER_19_710 VGND VGND VPWR VPWR sky130_fd_sc_hd__decap_3
XFILLER_93_646 VGND VGND VPWR VPWR sky130_fd_sc_hd__decap_3
XFILLER_65_337 VGND VGND VPWR VPWR sky130_fd_sc_hd__decap_3
XFILLER_19_732 VGND VGND VPWR VPWR sky130_fd_sc_hd__decap_3
XFILLER_18_231 VGND VGND VPWR VPWR sky130_fd_sc_hd__decap_3
XFILLER_93_679 VGND VGND VPWR VPWR sky130_fd_sc_hd__decap_3
XFILLER_19_765 VGND VGND VPWR VPWR sky130_fd_sc_hd__decap_3
XFILLER_80_307 VGND VGND VPWR VPWR sky130_fd_sc_hd__fill_1
XFILLER_80_318 VGND VGND VPWR VPWR sky130_fd_sc_hd__fill_1
XFILLER_18_253 VGND VGND VPWR VPWR sky130_fd_sc_hd__fill_2
XFILLER_46_573 VGND VGND VPWR VPWR sky130_fd_sc_hd__decap_3
XFILLER_34_713 VGND VGND VPWR VPWR sky130_fd_sc_hd__fill_2
XFILLER_73_381 VGND VGND VPWR VPWR sky130_fd_sc_hd__decap_3
XFILLER_34_746 VGND VGND VPWR VPWR sky130_fd_sc_hd__fill_2
XFILLER_61_532 VGND VGND VPWR VPWR sky130_fd_sc_hd__decap_3
XFILLER_34_757 VGND VGND VPWR VPWR sky130_fd_sc_hd__decap_3
XFILLER_33_256 VGND VGND VPWR VPWR sky130_fd_sc_hd__decap_3
X_4750_ hold880/X _4750_/A1 _4756_/S VGND VGND VPWR VPWR _4751_/A sky130_fd_sc_hd__mux2_2
XFILLER_21_429 VGND VGND VPWR VPWR sky130_fd_sc_hd__decap_3
XPHY_EDGE_ROW_56_Right_56 VGND VGND VPWR VPWR sky130_fd_sc_hd__decap_3
XTAP_TAPCELL_ROW_16_498 VGND VPWR sky130_fd_sc_hd__tapvpwrvgnd_1
X_4681_ _4681_/A0 _9073_/Q _4693_/S VGND VGND VPWR VPWR _4681_/X sky130_fd_sc_hd__mux2_2
X_6420_ _6420_/A _6420_/B VGND VGND VPWR VPWR _6421_/B sky130_fd_sc_hd__xnor2_2
X_6351_ _6351_/A _6351_/B VGND VGND VPWR VPWR _6361_/B sky130_fd_sc_hd__xnor2_2
XFILLER_127_361 VGND VGND VPWR VPWR sky130_fd_sc_hd__decap_3
X_5302_ _5369_/A _5369_/B VGND VGND VPWR VPWR _5303_/B sky130_fd_sc_hd__xnor2_2
XFILLER_115_534 VGND VGND VPWR VPWR sky130_fd_sc_hd__decap_3
X_9070_ _9293_/CLK _9070_/D fanout383/X VGND VGND VPWR VPWR _9070_/Q sky130_fd_sc_hd__dfrtp_2
X_6282_ _7050_/A _7043_/B VGND VGND VPWR VPWR _6286_/A sky130_fd_sc_hd__nand2_4
XTAP_TAPCELL_ROW_58_1064 VGND VPWR sky130_fd_sc_hd__tapvpwrvgnd_1
XFILLER_5_190 VGND VGND VPWR VPWR sky130_fd_sc_hd__decap_3
X_8021_ _5926_/B _5656_/B _8018_/Y _8020_/Y _5930_/C VGND VGND VPWR VPWR _8021_/X
+ sky130_fd_sc_hd__o32a_2
XFILLER_103_729 VGND VGND VPWR VPWR sky130_fd_sc_hd__decap_3
X_5233_ _5230_/Y _5232_/X _6077_/A VGND VGND VPWR VPWR _5234_/B sky130_fd_sc_hd__mux2_2
XFILLER_115_589 VGND VGND VPWR VPWR sky130_fd_sc_hd__decap_3
XPHY_EDGE_ROW_65_Right_65 VGND VGND VPWR VPWR sky130_fd_sc_hd__decap_3
XTAP_TAPCELL_ROW_71_1242 VGND VPWR sky130_fd_sc_hd__tapvpwrvgnd_1
XFILLER_69_632 VGND VGND VPWR VPWR sky130_fd_sc_hd__decap_3
XFILLER_130_548 VGND VGND VPWR VPWR sky130_fd_sc_hd__decap_3
XFILLER_124_18 VGND VGND VPWR VPWR sky130_fd_sc_hd__decap_3
X_5164_ wire110/X hold769/X _5163_/X VGND VGND VPWR VPWR _9199_/D sky130_fd_sc_hd__o21ai_2
XFILLER_124_29 VGND VGND VPWR VPWR sky130_fd_sc_hd__decap_3
XFILLER_68_164 VGND VGND VPWR VPWR sky130_fd_sc_hd__fill_2
XFILLER_84_624 VGND VGND VPWR VPWR sky130_fd_sc_hd__fill_1
XFILLER_29_529 VGND VGND VPWR VPWR sky130_fd_sc_hd__fill_2
X_5095_ _6094_/B _6083_/B VGND VGND VPWR VPWR _5095_/X sky130_fd_sc_hd__or2_2
XPHY_EDGE_ROW_3_Left_134 VGND VGND VPWR VPWR sky130_fd_sc_hd__decap_3
X_8923_ _8957_/A1 _8923_/A1 _8925_/S VGND VGND VPWR VPWR _8924_/A sky130_fd_sc_hd__mux2_2
XFILLER_56_359 VGND VGND VPWR VPWR sky130_fd_sc_hd__decap_3
XFILLER_17_27 VGND VGND VPWR VPWR sky130_fd_sc_hd__decap_3
XFILLER_37_573 VGND VGND VPWR VPWR sky130_fd_sc_hd__fill_2
XFILLER_25_713 VGND VGND VPWR VPWR sky130_fd_sc_hd__decap_3
X_8854_ _8888_/A1 _8854_/A1 _8862_/S VGND VGND VPWR VPWR _8855_/A sky130_fd_sc_hd__mux2_2
XTAP_TAPCELL_ROW_123_1939 VGND VPWR sky130_fd_sc_hd__tapvpwrvgnd_1
XFILLER_92_690 VGND VGND VPWR VPWR sky130_fd_sc_hd__decap_3
XFILLER_64_381 VGND VGND VPWR VPWR sky130_fd_sc_hd__fill_2
XFILLER_52_521 VGND VGND VPWR VPWR sky130_fd_sc_hd__decap_3
XFILLER_37_595 VGND VGND VPWR VPWR sky130_fd_sc_hd__fill_1
XFILLER_64_392 VGND VGND VPWR VPWR sky130_fd_sc_hd__decap_3
X_7805_ _7805_/A _8066_/B VGND VGND VPWR VPWR _7806_/B sky130_fd_sc_hd__nor2_2
XFILLER_25_768 VGND VGND VPWR VPWR sky130_fd_sc_hd__decap_3
X_8785_ _9238_/Q hold757/X _8799_/S VGND VGND VPWR VPWR _8785_/X sky130_fd_sc_hd__mux2_2
XTAP_TAPCELL_ROW_35_752 VGND VPWR sky130_fd_sc_hd__tapvpwrvgnd_1
X_5997_ _9281_/Q _5065_/X _4992_/X _9329_/Q _5996_/X VGND VGND VPWR VPWR _5998_/C
+ sky130_fd_sc_hd__a221o_2
XPHY_EDGE_ROW_74_Right_74 VGND VGND VPWR VPWR sky130_fd_sc_hd__decap_3
XFILLER_24_256 VGND VGND VPWR VPWR sky130_fd_sc_hd__decap_3
XFILLER_40_716 VGND VGND VPWR VPWR sky130_fd_sc_hd__decap_3
X_7736_ _7736_/A _7736_/B VGND VGND VPWR VPWR _7738_/A sky130_fd_sc_hd__xnor2_2
X_4948_ _5588_/A _6206_/A VGND VGND VPWR VPWR _5718_/B sky130_fd_sc_hd__nor2_2
XTAP_TAPCELL_ROW_82_1382 VGND VPWR sky130_fd_sc_hd__tapvpwrvgnd_1
XTAP_TAPCELL_ROW_82_1393 VGND VPWR sky130_fd_sc_hd__tapvpwrvgnd_1
X_7667_ _7667_/A _7667_/B VGND VGND VPWR VPWR _7667_/Y sky130_fd_sc_hd__xnor2_2
X_4879_ _4872_/Y _4876_/X _4878_/X hold795/X VGND VGND VPWR VPWR _4879_/X sky130_fd_sc_hd__a2bb2o_2
X_6618_ _8161_/B VGND VGND VPWR VPWR _8066_/B sky130_fd_sc_hd__buf_6
XFILLER_20_484 VGND VGND VPWR VPWR sky130_fd_sc_hd__decap_3
X_7598_ _6250_/A _6250_/B _8066_/A VGND VGND VPWR VPWR _7784_/C sky130_fd_sc_hd__a21oi_2
XFILLER_118_350 VGND VGND VPWR VPWR sky130_fd_sc_hd__decap_3
XFILLER_116_6 VGND VGND VPWR VPWR sky130_fd_sc_hd__decap_3
X_6549_ _6550_/B _7945_/A _7430_/B _6992_/A VGND VGND VPWR VPWR _6549_/X sky130_fd_sc_hd__o22a_2
X_9337_ clkload4/A _9337_/D wire372/X VGND VGND VPWR VPWR _9337_/Q sky130_fd_sc_hd__dfrtp_2
XFILLER_3_105 VGND VGND VPWR VPWR sky130_fd_sc_hd__decap_3
XFILLER_4_639 VGND VGND VPWR VPWR sky130_fd_sc_hd__decap_3
XFILLER_118_383 VGND VGND VPWR VPWR sky130_fd_sc_hd__decap_3
XFILLER_106_545 VGND VGND VPWR VPWR sky130_fd_sc_hd__decap_3
X_9268_ _9346_/CLK _9268_/D load_slew397/X VGND VGND VPWR VPWR _9268_/Q sky130_fd_sc_hd__dfrtp_2
XPHY_EDGE_ROW_83_Right_83 VGND VGND VPWR VPWR sky130_fd_sc_hd__decap_3
XFILLER_106_578 VGND VGND VPWR VPWR sky130_fd_sc_hd__decap_3
X_8219_ _8219_/A _8219_/B VGND VGND VPWR VPWR _8219_/X sky130_fd_sc_hd__xor2_2
X_9199_ clkload8/A _9199_/D fanout407/A VGND VGND VPWR VPWR _9199_/Q sky130_fd_sc_hd__dfrtp_2
XFILLER_59_164 VGND VGND VPWR VPWR sky130_fd_sc_hd__decap_3
XPHY_EDGE_ROW_58_Left_189 VGND VGND VPWR VPWR sky130_fd_sc_hd__decap_3
XFILLER_74_101 VGND VGND VPWR VPWR sky130_fd_sc_hd__fill_2
XFILLER_114_62 VGND VGND VPWR VPWR sky130_fd_sc_hd__decap_3
XFILLER_74_156 VGND VGND VPWR VPWR sky130_fd_sc_hd__decap_3
XFILLER_74_44 VGND VGND VPWR VPWR sky130_fd_sc_hd__decap_3
XFILLER_90_627 VGND VGND VPWR VPWR sky130_fd_sc_hd__decap_3
XFILLER_62_318 VGND VGND VPWR VPWR sky130_fd_sc_hd__decap_3
XFILLER_28_573 VGND VGND VPWR VPWR sky130_fd_sc_hd__fill_1
XFILLER_16_713 VGND VGND VPWR VPWR sky130_fd_sc_hd__decap_3
XFILLER_55_370 VGND VGND VPWR VPWR sky130_fd_sc_hd__decap_3
XFILLER_28_595 VGND VGND VPWR VPWR sky130_fd_sc_hd__decap_3
XPHY_EDGE_ROW_92_Right_92 VGND VGND VPWR VPWR sky130_fd_sc_hd__decap_3
XFILLER_43_532 VGND VGND VPWR VPWR sky130_fd_sc_hd__decap_3
XFILLER_16_746 VGND VGND VPWR VPWR sky130_fd_sc_hd__decap_3
XFILLER_16_757 VGND VGND VPWR VPWR sky130_fd_sc_hd__decap_3
XFILLER_130_50 VGND VGND VPWR VPWR sky130_fd_sc_hd__decap_3
XFILLER_15_267 VGND VGND VPWR VPWR sky130_fd_sc_hd__fill_2
XFILLER_130_72 VGND VGND VPWR VPWR sky130_fd_sc_hd__decap_3
XFILLER_31_738 VGND VGND VPWR VPWR sky130_fd_sc_hd__decap_3
XFILLER_130_94 VGND VGND VPWR VPWR sky130_fd_sc_hd__decap_3
XFILLER_90_65 VGND VGND VPWR VPWR sky130_fd_sc_hd__decap_3
XFILLER_30_248 VGND VGND VPWR VPWR sky130_fd_sc_hd__decap_3
XFILLER_129_615 VGND VGND VPWR VPWR sky130_fd_sc_hd__fill_1
XPHY_EDGE_ROW_67_Left_198 VGND VGND VPWR VPWR sky130_fd_sc_hd__decap_3
XTAP_TAPCELL_ROW_13_457 VGND VPWR sky130_fd_sc_hd__tapvpwrvgnd_1
XFILLER_129_626 VGND VGND VPWR VPWR sky130_fd_sc_hd__decap_3
XFILLER_128_103 VGND VGND VPWR VPWR sky130_fd_sc_hd__decap_3
XFILLER_7_411 VGND VGND VPWR VPWR sky130_fd_sc_hd__decap_3
XFILLER_129_659 VGND VGND VPWR VPWR sky130_fd_sc_hd__decap_3
XFILLER_128_136 VGND VGND VPWR VPWR sky130_fd_sc_hd__decap_3
XFILLER_128_147 VGND VGND VPWR VPWR sky130_fd_sc_hd__decap_3
XFILLER_116_309 VGND VGND VPWR VPWR sky130_fd_sc_hd__decap_3
Xmax_cap108 _6957_/B VGND VGND VPWR VPWR _5893_/B sky130_fd_sc_hd__buf_4
XFILLER_124_331 VGND VGND VPWR VPWR sky130_fd_sc_hd__fill_1
XFILLER_98_716 VGND VGND VPWR VPWR sky130_fd_sc_hd__decap_3
XFILLER_3_650 VGND VGND VPWR VPWR sky130_fd_sc_hd__decap_3
Xload_slew303 input3/X VGND VGND VPWR VPWR _7174_/B sky130_fd_sc_hd__buf_4
XFILLER_3_694 VGND VGND VPWR VPWR sky130_fd_sc_hd__decap_3
XFILLER_31_6 VGND VGND VPWR VPWR sky130_fd_sc_hd__fill_1
XFILLER_112_548 VGND VGND VPWR VPWR sky130_fd_sc_hd__decap_3
XFILLER_66_624 VGND VGND VPWR VPWR sky130_fd_sc_hd__decap_3
XFILLER_120_570 VGND VGND VPWR VPWR sky130_fd_sc_hd__decap_3
XFILLER_120_592 VGND VGND VPWR VPWR sky130_fd_sc_hd__fill_2
XTAP_TAPCELL_ROW_109_1750 VGND VPWR sky130_fd_sc_hd__tapvpwrvgnd_1
XFILLER_93_476 VGND VGND VPWR VPWR sky130_fd_sc_hd__decap_3
XFILLER_65_167 VGND VGND VPWR VPWR sky130_fd_sc_hd__fill_1
XFILLER_0_41 VGND VGND VPWR VPWR sky130_fd_sc_hd__decap_3
X_5920_ _5667_/S _5087_/B _5669_/B VGND VGND VPWR VPWR _5920_/Y sky130_fd_sc_hd__a21oi_2
XFILLER_19_573 VGND VGND VPWR VPWR sky130_fd_sc_hd__decap_3
XFILLER_81_649 VGND VGND VPWR VPWR sky130_fd_sc_hd__decap_3
XFILLER_19_595 VGND VGND VPWR VPWR sky130_fd_sc_hd__decap_3
XFILLER_0_74 VGND VGND VPWR VPWR sky130_fd_sc_hd__fill_2
X_5851_ _5851_/A _5851_/B VGND VGND VPWR VPWR _6159_/B sky130_fd_sc_hd__xnor2_2
XFILLER_61_340 VGND VGND VPWR VPWR sky130_fd_sc_hd__decap_3
XFILLER_34_554 VGND VGND VPWR VPWR sky130_fd_sc_hd__fill_1
XFILLER_22_716 VGND VGND VPWR VPWR sky130_fd_sc_hd__decap_3
X_4802_ _4802_/A VGND VGND VPWR VPWR _9146_/D sky130_fd_sc_hd__buf_1
XPHY_EDGE_ROW_100_Right_100 VGND VGND VPWR VPWR sky130_fd_sc_hd__decap_3
XFILLER_61_373 VGND VGND VPWR VPWR sky130_fd_sc_hd__decap_3
XFILLER_21_204 VGND VGND VPWR VPWR sky130_fd_sc_hd__fill_2
X_8570_ _9226_/Q _8570_/B VGND VGND VPWR VPWR _8571_/B sky130_fd_sc_hd__xnor2_2
XTAP_TAPCELL_ROW_32_711 VGND VPWR sky130_fd_sc_hd__tapvpwrvgnd_1
XFILLER_21_215 VGND VGND VPWR VPWR sky130_fd_sc_hd__decap_3
X_5782_ _5782_/A1 _5672_/B _5670_/Y VGND VGND VPWR VPWR _5809_/A sky130_fd_sc_hd__a21o_2
XFILLER_22_749 VGND VGND VPWR VPWR sky130_fd_sc_hd__decap_3
X_7521_ _7522_/A _7522_/B VGND VGND VPWR VPWR _7521_/Y sky130_fd_sc_hd__nand2_2
XFILLER_21_248 VGND VGND VPWR VPWR sky130_fd_sc_hd__decap_3
X_4733_ hold998/X _4733_/A1 _4735_/S VGND VGND VPWR VPWR _4734_/A sky130_fd_sc_hd__mux2_2
XFILLER_9_83 VGND VGND VPWR VPWR sky130_fd_sc_hd__fill_1
XFILLER_30_760 VGND VGND VPWR VPWR sky130_fd_sc_hd__decap_3
Xrebuffer508 _4516_/X VGND VGND VPWR VPWR _5995_/A2 sky130_fd_sc_hd__buf_4
XFILLER_9_94 VGND VGND VPWR VPWR sky130_fd_sc_hd__decap_3
Xrebuffer519 _7647_/A VGND VGND VPWR VPWR _7752_/B1 sky130_fd_sc_hd__buf_2
XFILLER_119_125 VGND VGND VPWR VPWR sky130_fd_sc_hd__decap_3
X_7452_ _7576_/A _7576_/B _8137_/B VGND VGND VPWR VPWR _7454_/B sky130_fd_sc_hd__a21o_2
XFILLER_119_18 VGND VGND VPWR VPWR sky130_fd_sc_hd__decap_3
X_4664_ hold890/X hold939/X _4672_/S VGND VGND VPWR VPWR _4665_/A sky130_fd_sc_hd__mux2_2
XFILLER_119_147 VGND VGND VPWR VPWR sky130_fd_sc_hd__decap_3
X_6403_ _4970_/X _6398_/Y _6402_/X VGND VGND VPWR VPWR _6423_/A sky130_fd_sc_hd__a21o_2
XFILLER_119_169 VGND VGND VPWR VPWR sky130_fd_sc_hd__decap_3
X_7383_ _7382_/Y _7380_/X _7496_/A VGND VGND VPWR VPWR _7383_/X sky130_fd_sc_hd__mux2_2
X_4595_ _4595_/A VGND VGND VPWR VPWR _9048_/D sky130_fd_sc_hd__buf_1
Xhold901 _8862_/X VGND VGND VPWR VPWR _8863_/A sky130_fd_sc_hd__dlygate4sd3_1
XFILLER_128_681 VGND VGND VPWR VPWR sky130_fd_sc_hd__decap_3
Xhold912 _9320_/Q VGND VGND VPWR VPWR hold912/X sky130_fd_sc_hd__dlygate4sd3_1
Xhold923 _8919_/X VGND VGND VPWR VPWR _8920_/A sky130_fd_sc_hd__dlygate4sd3_1
X_9122_ _9341_/CLK _9122_/D fanout379/X VGND VGND VPWR VPWR _9122_/Q sky130_fd_sc_hd__dfrtp_2
XFILLER_115_320 VGND VGND VPWR VPWR sky130_fd_sc_hd__decap_3
X_6334_ _9095_/Q _5115_/X _5126_/X _9143_/Q VGND VGND VPWR VPWR _6345_/B sky130_fd_sc_hd__a22o_2
Xhold934 _9092_/Q VGND VGND VPWR VPWR hold934/X sky130_fd_sc_hd__dlygate4sd3_1
Xhold945 _4838_/X VGND VGND VPWR VPWR _4839_/A sky130_fd_sc_hd__dlygate4sd3_1
Xhold956 _9061_/Q VGND VGND VPWR VPWR hold956/X sky130_fd_sc_hd__dlygate4sd3_1
XFILLER_1_609 VGND VGND VPWR VPWR sky130_fd_sc_hd__decap_3
Xhold967 _9017_/Q VGND VGND VPWR VPWR hold967/X sky130_fd_sc_hd__dlygate4sd3_1
XFILLER_89_727 VGND VGND VPWR VPWR sky130_fd_sc_hd__fill_1
Xhold978 _4625_/X VGND VGND VPWR VPWR _4626_/A sky130_fd_sc_hd__dlygate4sd3_1
X_9053_ _9133_/CLK _9053_/D load_slew394/X VGND VGND VPWR VPWR _9053_/Q sky130_fd_sc_hd__dfrtp_2
XFILLER_89_738 VGND VGND VPWR VPWR sky130_fd_sc_hd__decap_3
X_6265_ _6265_/A _6265_/B VGND VGND VPWR VPWR _6266_/B sky130_fd_sc_hd__xnor2_2
Xhold989 _9046_/Q VGND VGND VPWR VPWR hold989/X sky130_fd_sc_hd__dlygate4sd3_1
XFILLER_0_119 VGND VGND VPWR VPWR sky130_fd_sc_hd__decap_3
XFILLER_130_312 VGND VGND VPWR VPWR sky130_fd_sc_hd__decap_3
XFILLER_88_237 VGND VGND VPWR VPWR sky130_fd_sc_hd__fill_2
X_8004_ _8006_/B _8006_/C VGND VGND VPWR VPWR _8004_/X sky130_fd_sc_hd__or2_2
XFILLER_103_559 VGND VGND VPWR VPWR sky130_fd_sc_hd__fill_1
X_5216_ _5236_/B _5216_/B VGND VGND VPWR VPWR _5216_/Y sky130_fd_sc_hd__xnor2_2
XFILLER_88_259 VGND VGND VPWR VPWR sky130_fd_sc_hd__fill_2
XFILLER_69_440 VGND VGND VPWR VPWR sky130_fd_sc_hd__decap_3
X_6196_ _6311_/A _6196_/B VGND VGND VPWR VPWR _6197_/B sky130_fd_sc_hd__nor2_2
X_5147_ _5147_/A _5147_/B VGND VGND VPWR VPWR _5148_/B sky130_fd_sc_hd__xnor2_2
XFILLER_28_26 VGND VGND VPWR VPWR sky130_fd_sc_hd__fill_2
XFILLER_29_326 VGND VGND VPWR VPWR sky130_fd_sc_hd__decap_3
XFILLER_84_421 VGND VGND VPWR VPWR sky130_fd_sc_hd__decap_3
XFILLER_29_337 VGND VGND VPWR VPWR sky130_fd_sc_hd__decap_3
XFILLER_28_59 VGND VGND VPWR VPWR sky130_fd_sc_hd__decap_3
XFILLER_29_359 VGND VGND VPWR VPWR sky130_fd_sc_hd__decap_3
X_5078_ _6942_/A _5078_/B _5078_/C VGND VGND VPWR VPWR _5079_/B sky130_fd_sc_hd__and3_2
XFILLER_56_156 VGND VGND VPWR VPWR sky130_fd_sc_hd__decap_3
XFILLER_56_178 VGND VGND VPWR VPWR sky130_fd_sc_hd__fill_1
X_8906_ _8969_/A VGND VGND VPWR VPWR _8925_/S sky130_fd_sc_hd__clkbuf_2
XTAP_TAPCELL_ROW_84_1411 VGND VPWR sky130_fd_sc_hd__tapvpwrvgnd_1
XFILLER_71_126 VGND VGND VPWR VPWR sky130_fd_sc_hd__decap_3
XTAP_TAPCELL_ROW_84_1422 VGND VPWR sky130_fd_sc_hd__tapvpwrvgnd_1
X_8837_ hold854/X _8837_/A1 _8837_/S VGND VGND VPWR VPWR _8838_/A sky130_fd_sc_hd__mux2_2
XFILLER_80_660 VGND VGND VPWR VPWR sky130_fd_sc_hd__decap_3
XFILLER_13_727 VGND VGND VPWR VPWR sky130_fd_sc_hd__fill_1
XFILLER_13_738 VGND VGND VPWR VPWR sky130_fd_sc_hd__decap_3
XFILLER_80_693 VGND VGND VPWR VPWR sky130_fd_sc_hd__decap_3
X_8768_ _8768_/A _8768_/B VGND VGND VPWR VPWR _8768_/Y sky130_fd_sc_hd__nand2_2
XFILLER_9_709 VGND VGND VPWR VPWR sky130_fd_sc_hd__decap_3
XFILLER_12_226 VGND VGND VPWR VPWR sky130_fd_sc_hd__decap_3
XFILLER_40_557 VGND VGND VPWR VPWR sky130_fd_sc_hd__fill_1
XFILLER_100_53 VGND VGND VPWR VPWR sky130_fd_sc_hd__decap_3
XFILLER_12_259 VGND VGND VPWR VPWR sky130_fd_sc_hd__decap_3
X_7719_ _8011_/C _7719_/B VGND VGND VPWR VPWR _7720_/B sky130_fd_sc_hd__xnor2_2
XFILLER_8_219 VGND VGND VPWR VPWR sky130_fd_sc_hd__decap_3
XFILLER_60_24 VGND VGND VPWR VPWR sky130_fd_sc_hd__decap_3
X_8699_ _9228_/Q _8699_/B VGND VGND VPWR VPWR _8699_/X sky130_fd_sc_hd__or2_2
XFILLER_21_771 VGND VGND VPWR VPWR sky130_fd_sc_hd__decap_3
XTAP_TAPCELL_ROW_10_416 VGND VPWR sky130_fd_sc_hd__tapvpwrvgnd_1
XFILLER_60_79 VGND VGND VPWR VPWR sky130_fd_sc_hd__decap_3
XFILLER_126_618 VGND VGND VPWR VPWR sky130_fd_sc_hd__decap_3
XFILLER_114_3 VGND VGND VPWR VPWR sky130_fd_sc_hd__decap_3
XFILLER_125_128 VGND VGND VPWR VPWR sky130_fd_sc_hd__decap_3
XFILLER_109_51 VGND VGND VPWR VPWR sky130_fd_sc_hd__decap_3
XFILLER_106_331 VGND VGND VPWR VPWR sky130_fd_sc_hd__decap_3
XTAP_TAPCELL_ROW_95_1562 VGND VPWR sky130_fd_sc_hd__tapvpwrvgnd_1
XFILLER_106_353 VGND VGND VPWR VPWR sky130_fd_sc_hd__decap_3
XFILLER_69_55 VGND VGND VPWR VPWR sky130_fd_sc_hd__fill_1
XFILLER_69_66 VGND VGND VPWR VPWR sky130_fd_sc_hd__fill_2
XFILLER_69_77 VGND VGND VPWR VPWR sky130_fd_sc_hd__fill_1
XFILLER_0_620 VGND VGND VPWR VPWR sky130_fd_sc_hd__decap_3
XFILLER_95_719 VGND VGND VPWR VPWR sky130_fd_sc_hd__decap_3
XFILLER_121_367 VGND VGND VPWR VPWR sky130_fd_sc_hd__decap_3
XFILLER_125_72 VGND VGND VPWR VPWR sky130_fd_sc_hd__decap_3
XFILLER_0_697 VGND VGND VPWR VPWR sky130_fd_sc_hd__decap_3
XFILLER_102_581 VGND VGND VPWR VPWR sky130_fd_sc_hd__decap_3
XFILLER_87_281 VGND VGND VPWR VPWR sky130_fd_sc_hd__fill_1
XFILLER_102_592 VGND VGND VPWR VPWR sky130_fd_sc_hd__decap_3
XFILLER_35_329 VGND VGND VPWR VPWR sky130_fd_sc_hd__fill_2
XTAP_TAPCELL_ROW_18_527 VGND VPWR sky130_fd_sc_hd__tapvpwrvgnd_1
XFILLER_90_424 VGND VGND VPWR VPWR sky130_fd_sc_hd__fill_1
XFILLER_16_521 VGND VGND VPWR VPWR sky130_fd_sc_hd__decap_3
XFILLER_16_576 VGND VGND VPWR VPWR sky130_fd_sc_hd__decap_3
XPHY_EDGE_ROW_75_Left_206 VGND VGND VPWR VPWR sky130_fd_sc_hd__decap_3
XFILLER_43_373 VGND VGND VPWR VPWR sky130_fd_sc_hd__decap_3
XFILLER_16_598 VGND VGND VPWR VPWR sky130_fd_sc_hd__decap_3
XTAP_TAPCELL_ROW_104_1680 VGND VPWR sky130_fd_sc_hd__tapvpwrvgnd_1
XTAP_TAPCELL_ROW_104_1691 VGND VPWR sky130_fd_sc_hd__tapvpwrvgnd_1
XFILLER_31_557 VGND VGND VPWR VPWR sky130_fd_sc_hd__decap_3
XFILLER_31_568 VGND VGND VPWR VPWR sky130_fd_sc_hd__decap_3
XFILLER_12_760 VGND VGND VPWR VPWR sky130_fd_sc_hd__decap_3
XFILLER_8_731 VGND VGND VPWR VPWR sky130_fd_sc_hd__decap_3
XFILLER_11_270 VGND VGND VPWR VPWR sky130_fd_sc_hd__decap_3
XFILLER_11_281 VGND VGND VPWR VPWR sky130_fd_sc_hd__decap_3
XFILLER_117_607 VGND VGND VPWR VPWR sky130_fd_sc_hd__decap_3
XFILLER_8_775 VGND VGND VPWR VPWR sky130_fd_sc_hd__fill_2
XFILLER_7_263 VGND VGND VPWR VPWR sky130_fd_sc_hd__fill_1
XFILLER_116_106 VGND VGND VPWR VPWR sky130_fd_sc_hd__decap_3
Xwire172 _5056_/X VGND VGND VPWR VPWR wire172/X sky130_fd_sc_hd__buf_4
XFILLER_109_180 VGND VGND VPWR VPWR sky130_fd_sc_hd__fill_2
XFILLER_7_296 VGND VGND VPWR VPWR sky130_fd_sc_hd__decap_3
XFILLER_98_502 VGND VGND VPWR VPWR sky130_fd_sc_hd__fill_2
XTAP_TAPCELL_ROW_55_1023 VGND VPWR sky130_fd_sc_hd__tapvpwrvgnd_1
XPHY_EDGE_ROW_84_Left_215 VGND VGND VPWR VPWR sky130_fd_sc_hd__decap_3
XFILLER_125_673 VGND VGND VPWR VPWR sky130_fd_sc_hd__fill_2
XFILLER_124_150 VGND VGND VPWR VPWR sky130_fd_sc_hd__decap_3
XFILLER_98_524 VGND VGND VPWR VPWR sky130_fd_sc_hd__decap_3
XFILLER_125_695 VGND VGND VPWR VPWR sky130_fd_sc_hd__decap_3
XFILLER_124_183 VGND VGND VPWR VPWR sky130_fd_sc_hd__decap_3
X_6050_ _6050_/A _6050_/B VGND VGND VPWR VPWR _6051_/B sky130_fd_sc_hd__xnor2_2
XFILLER_98_568 VGND VGND VPWR VPWR sky130_fd_sc_hd__decap_3
X_5001_ _5457_/B _5875_/C VGND VGND VPWR VPWR _5002_/A sky130_fd_sc_hd__and2_2
XFILLER_112_378 VGND VGND VPWR VPWR sky130_fd_sc_hd__fill_2
XFILLER_78_281 VGND VGND VPWR VPWR sky130_fd_sc_hd__fill_2
XFILLER_66_421 VGND VGND VPWR VPWR sky130_fd_sc_hd__decap_3
XFILLER_39_635 VGND VGND VPWR VPWR sky130_fd_sc_hd__fill_2
XFILLER_94_741 VGND VGND VPWR VPWR sky130_fd_sc_hd__decap_3
XFILLER_38_134 VGND VGND VPWR VPWR sky130_fd_sc_hd__decap_3
XFILLER_54_627 VGND VGND VPWR VPWR sky130_fd_sc_hd__decap_3
XFILLER_26_318 VGND VGND VPWR VPWR sky130_fd_sc_hd__decap_3
XFILLER_53_104 VGND VGND VPWR VPWR sky130_fd_sc_hd__decap_3
X_6952_ _5077_/B _7014_/B _6952_/S VGND VGND VPWR VPWR _6952_/X sky130_fd_sc_hd__mux2_2
XFILLER_93_284 VGND VGND VPWR VPWR sky130_fd_sc_hd__fill_2
XFILLER_93_295 VGND VGND VPWR VPWR sky130_fd_sc_hd__fill_1
XFILLER_81_435 VGND VGND VPWR VPWR sky130_fd_sc_hd__decap_3
XFILLER_53_148 VGND VGND VPWR VPWR sky130_fd_sc_hd__fill_1
XPHY_EDGE_ROW_93_Left_224 VGND VGND VPWR VPWR sky130_fd_sc_hd__decap_3
X_5903_ _5903_/A _5902_/Y VGND VGND VPWR VPWR _5904_/A sky130_fd_sc_hd__nor2b_2
XFILLER_81_468 VGND VGND VPWR VPWR sky130_fd_sc_hd__decap_3
X_6883_ _6861_/B _7256_/A _7212_/A VGND VGND VPWR VPWR _6889_/A sky130_fd_sc_hd__mux2_2
XTAP_TAPCELL_ROW_66_1174 VGND VPWR sky130_fd_sc_hd__tapvpwrvgnd_1
XFILLER_34_362 VGND VGND VPWR VPWR sky130_fd_sc_hd__fill_2
XFILLER_62_682 VGND VGND VPWR VPWR sky130_fd_sc_hd__decap_3
X_5834_ _5834_/A _5834_/B VGND VGND VPWR VPWR _5843_/A sky130_fd_sc_hd__xnor2_2
X_8622_ _8676_/C _8622_/B VGND VGND VPWR VPWR _8644_/B sky130_fd_sc_hd__xor2_2
XTAP_TAPCELL_ROW_45_891 VGND VPWR sky130_fd_sc_hd__tapvpwrvgnd_1
XFILLER_34_395 VGND VGND VPWR VPWR sky130_fd_sc_hd__decap_3
XFILLER_22_568 VGND VGND VPWR VPWR sky130_fd_sc_hd__decap_3
X_5765_ _5765_/A _5766_/B VGND VGND VPWR VPWR _5765_/X sky130_fd_sc_hd__and2_2
X_8553_ _8627_/A _8554_/B VGND VGND VPWR VPWR _8572_/A sky130_fd_sc_hd__nor2_2
XFILLER_10_719 VGND VGND VPWR VPWR sky130_fd_sc_hd__decap_3
X_4716_ _4842_/A VGND VGND VPWR VPWR _4735_/S sky130_fd_sc_hd__clkbuf_2
X_7504_ _7565_/B _7565_/A VGND VGND VPWR VPWR _7564_/A sky130_fd_sc_hd__nor2_4
X_8484_ _8514_/A _8482_/B _8328_/Y _8421_/B VGND VGND VPWR VPWR _8484_/X sky130_fd_sc_hd__a211o_2
X_5696_ _7099_/C _7573_/B VGND VGND VPWR VPWR _5700_/A sky130_fd_sc_hd__nand2_2
X_7435_ _7434_/B _7434_/C _7434_/A VGND VGND VPWR VPWR _7436_/D sky130_fd_sc_hd__a21oi_2
X_4647_ _4647_/A VGND VGND VPWR VPWR _9073_/D sky130_fd_sc_hd__buf_1
XFILLER_107_128 VGND VGND VPWR VPWR sky130_fd_sc_hd__fill_2
X_7366_ _9213_/Q _9212_/Q VGND VGND VPWR VPWR _7366_/X sky130_fd_sc_hd__or2b_2
XFILLER_100_9 VGND VGND VPWR VPWR sky130_fd_sc_hd__decap_3
X_4578_ _4578_/A VGND VGND VPWR VPWR _9040_/D sky130_fd_sc_hd__buf_1
Xhold753 input9/X VGND VGND VPWR VPWR hold753/X sky130_fd_sc_hd__dlygate4sd3_1
XFILLER_122_109 VGND VGND VPWR VPWR sky130_fd_sc_hd__decap_3
X_6317_ _6198_/A _6197_/B _6316_/X VGND VGND VPWR VPWR _6563_/A sky130_fd_sc_hd__o21a_2
Xhold764 _8802_/X VGND VGND VPWR VPWR _8803_/A sky130_fd_sc_hd__dlygate4sd3_1
X_9105_ _9168_/CLK _9105_/D fanout377/X VGND VGND VPWR VPWR _9105_/Q sky130_fd_sc_hd__dfrtp_2
XFILLER_1_417 VGND VGND VPWR VPWR sky130_fd_sc_hd__decap_3
X_7297_ _6206_/A _5709_/B _8406_/A _8780_/A VGND VGND VPWR VPWR _8137_/B sky130_fd_sc_hd__o211a_2
Xhold775 _8816_/X VGND VGND VPWR VPWR _8817_/A sky130_fd_sc_hd__dlygate4sd3_1
Xhold786 sample_valid VGND VGND VPWR VPWR input18/A sky130_fd_sc_hd__dlygate4sd3_1
XFILLER_89_546 VGND VGND VPWR VPWR sky130_fd_sc_hd__fill_2
Xhold797 _9186_/Q VGND VGND VPWR VPWR hold797/X sky130_fd_sc_hd__dlygate4sd3_1
X_9036_ _9133_/CLK _9036_/D wire372/A VGND VGND VPWR VPWR _9036_/Q sky130_fd_sc_hd__dfrtp_2
X_6248_ _6248_/A _6248_/B VGND VGND VPWR VPWR _6378_/A sky130_fd_sc_hd__xnor2_4
XFILLER_130_131 VGND VGND VPWR VPWR sky130_fd_sc_hd__decap_3
XFILLER_39_47 VGND VGND VPWR VPWR sky130_fd_sc_hd__decap_3
XFILLER_103_367 VGND VGND VPWR VPWR sky130_fd_sc_hd__fill_2
XFILLER_130_153 VGND VGND VPWR VPWR sky130_fd_sc_hd__decap_3
XFILLER_39_69 VGND VGND VPWR VPWR sky130_fd_sc_hd__decap_3
XTAP_TAPCELL_ROW_90_1492 VGND VPWR sky130_fd_sc_hd__tapvpwrvgnd_1
XFILLER_29_101 VGND VGND VPWR VPWR sky130_fd_sc_hd__decap_3
XFILLER_130_175 VGND VGND VPWR VPWR sky130_fd_sc_hd__decap_3
X_6179_ _5999_/B _5999_/A _6687_/B1 VGND VGND VPWR VPWR _6180_/B sky130_fd_sc_hd__a21o_4
XFILLER_69_281 VGND VGND VPWR VPWR sky130_fd_sc_hd__fill_2
XFILLER_130_197 VGND VGND VPWR VPWR sky130_fd_sc_hd__decap_3
XFILLER_85_741 VGND VGND VPWR VPWR sky130_fd_sc_hd__decap_3
XFILLER_57_443 VGND VGND VPWR VPWR sky130_fd_sc_hd__decap_3
XFILLER_84_240 VGND VGND VPWR VPWR sky130_fd_sc_hd__fill_1
XFILLER_29_145 VGND VGND VPWR VPWR sky130_fd_sc_hd__decap_3
XFILLER_17_307 VGND VGND VPWR VPWR sky130_fd_sc_hd__decap_3
XFILLER_57_476 VGND VGND VPWR VPWR sky130_fd_sc_hd__decap_3
XFILLER_29_189 VGND VGND VPWR VPWR sky130_fd_sc_hd__fill_1
XFILLER_17_329 VGND VGND VPWR VPWR sky130_fd_sc_hd__decap_3
XFILLER_55_57 VGND VGND VPWR VPWR sky130_fd_sc_hd__decap_3
XFILLER_60_619 VGND VGND VPWR VPWR sky130_fd_sc_hd__decap_3
XFILLER_25_340 VGND VGND VPWR VPWR sky130_fd_sc_hd__decap_3
XFILLER_53_660 VGND VGND VPWR VPWR sky130_fd_sc_hd__decap_3
XFILLER_111_30 VGND VGND VPWR VPWR sky130_fd_sc_hd__decap_3
XFILLER_25_362 VGND VGND VPWR VPWR sky130_fd_sc_hd__decap_3
XFILLER_13_502 VGND VGND VPWR VPWR sky130_fd_sc_hd__fill_2
XFILLER_111_63 VGND VGND VPWR VPWR sky130_fd_sc_hd__decap_3
XFILLER_13_535 VGND VGND VPWR VPWR sky130_fd_sc_hd__decap_3
XFILLER_71_45 VGND VGND VPWR VPWR sky130_fd_sc_hd__decap_3
XFILLER_13_557 VGND VGND VPWR VPWR sky130_fd_sc_hd__decap_3
XFILLER_111_96 VGND VGND VPWR VPWR sky130_fd_sc_hd__decap_3
XFILLER_9_517 VGND VGND VPWR VPWR sky130_fd_sc_hd__decap_3
XFILLER_40_354 VGND VGND VPWR VPWR sky130_fd_sc_hd__fill_2
XFILLER_40_365 VGND VGND VPWR VPWR sky130_fd_sc_hd__decap_3
XTAP_TAPCELL_ROW_23_596 VGND VPWR sky130_fd_sc_hd__tapvpwrvgnd_1
XFILLER_126_415 VGND VGND VPWR VPWR sky130_fd_sc_hd__decap_3
XFILLER_5_712 VGND VGND VPWR VPWR sky130_fd_sc_hd__decap_3
XFILLER_4_200 VGND VGND VPWR VPWR sky130_fd_sc_hd__decap_3
XFILLER_126_437 VGND VGND VPWR VPWR sky130_fd_sc_hd__decap_3
XFILLER_4_211 VGND VGND VPWR VPWR sky130_fd_sc_hd__decap_3
XFILLER_126_459 VGND VGND VPWR VPWR sky130_fd_sc_hd__decap_3
XFILLER_5_756 VGND VGND VPWR VPWR sky130_fd_sc_hd__decap_3
XFILLER_107_673 VGND VGND VPWR VPWR sky130_fd_sc_hd__decap_3
XFILLER_113_109 VGND VGND VPWR VPWR sky130_fd_sc_hd__decap_3
XFILLER_106_150 VGND VGND VPWR VPWR sky130_fd_sc_hd__decap_3
XFILLER_4_277 VGND VGND VPWR VPWR sky130_fd_sc_hd__fill_1
XFILLER_122_610 VGND VGND VPWR VPWR sky130_fd_sc_hd__decap_3
XFILLER_106_183 VGND VGND VPWR VPWR sky130_fd_sc_hd__decap_3
XFILLER_121_131 VGND VGND VPWR VPWR sky130_fd_sc_hd__decap_3
XFILLER_95_505 VGND VGND VPWR VPWR sky130_fd_sc_hd__decap_3
XFILLER_68_719 VGND VGND VPWR VPWR sky130_fd_sc_hd__decap_3
XFILLER_122_687 VGND VGND VPWR VPWR sky130_fd_sc_hd__decap_3
XFILLER_0_461 VGND VGND VPWR VPWR sky130_fd_sc_hd__fill_2
XFILLER_121_164 VGND VGND VPWR VPWR sky130_fd_sc_hd__decap_3
XFILLER_95_538 VGND VGND VPWR VPWR sky130_fd_sc_hd__decap_3
XFILLER_121_175 VGND VGND VPWR VPWR sky130_fd_sc_hd__decap_3
XFILLER_0_483 VGND VGND VPWR VPWR sky130_fd_sc_hd__decap_3
XFILLER_76_730 VGND VGND VPWR VPWR sky130_fd_sc_hd__decap_3
XFILLER_48_421 VGND VGND VPWR VPWR sky130_fd_sc_hd__decap_3
XFILLER_0_494 VGND VGND VPWR VPWR sky130_fd_sc_hd__decap_3
XFILLER_48_432 VGND VGND VPWR VPWR sky130_fd_sc_hd__fill_1
XFILLER_76_763 VGND VGND VPWR VPWR sky130_fd_sc_hd__decap_3
XFILLER_29_80 VGND VGND VPWR VPWR sky130_fd_sc_hd__fill_1
XFILLER_75_251 VGND VGND VPWR VPWR sky130_fd_sc_hd__decap_3
XFILLER_63_402 VGND VGND VPWR VPWR sky130_fd_sc_hd__decap_3
XFILLER_91_722 VGND VGND VPWR VPWR sky130_fd_sc_hd__decap_3
XFILLER_63_424 VGND VGND VPWR VPWR sky130_fd_sc_hd__decap_3
XFILLER_36_638 VGND VGND VPWR VPWR sky130_fd_sc_hd__decap_3
XFILLER_29_690 VGND VGND VPWR VPWR sky130_fd_sc_hd__decap_3
XFILLER_51_608 VGND VGND VPWR VPWR sky130_fd_sc_hd__decap_3
XFILLER_35_159 VGND VGND VPWR VPWR sky130_fd_sc_hd__decap_3
XFILLER_63_479 VGND VGND VPWR VPWR sky130_fd_sc_hd__decap_3
XFILLER_44_660 VGND VGND VPWR VPWR sky130_fd_sc_hd__decap_3
XFILLER_50_118 VGND VGND VPWR VPWR sky130_fd_sc_hd__fill_1
XFILLER_16_384 VGND VGND VPWR VPWR sky130_fd_sc_hd__decap_3
XFILLER_71_490 VGND VGND VPWR VPWR sky130_fd_sc_hd__decap_3
XFILLER_31_332 VGND VGND VPWR VPWR sky130_fd_sc_hd__decap_3
XFILLER_31_343 VGND VGND VPWR VPWR sky130_fd_sc_hd__decap_3
XTAP_TAPCELL_ROW_42_850 VGND VPWR sky130_fd_sc_hd__tapvpwrvgnd_1
XFILLER_129_220 VGND VGND VPWR VPWR sky130_fd_sc_hd__decap_3
X_5550_ _6807_/A _5550_/B VGND VGND VPWR VPWR _5550_/X sky130_fd_sc_hd__or2_2
XFILLER_129_231 VGND VGND VPWR VPWR sky130_fd_sc_hd__decap_3
XFILLER_77_3 VGND VGND VPWR VPWR sky130_fd_sc_hd__decap_3
XFILLER_129_275 VGND VGND VPWR VPWR sky130_fd_sc_hd__decap_3
X_5481_ _5481_/A _5481_/B VGND VGND VPWR VPWR _5482_/B sky130_fd_sc_hd__xnor2_2
X_7220_ _7220_/A VGND VGND VPWR VPWR _9213_/D sky130_fd_sc_hd__buf_1
XTAP_TAPCELL_ROW_117_1860 VGND VPWR sky130_fd_sc_hd__tapvpwrvgnd_1
X_7151_ _6900_/X _7148_/A _7148_/B _7150_/X VGND VGND VPWR VPWR _7151_/X sky130_fd_sc_hd__a22o_2
XFILLER_6_95 VGND VGND VPWR VPWR sky130_fd_sc_hd__decap_3
XFILLER_125_481 VGND VGND VPWR VPWR sky130_fd_sc_hd__decap_3
XFILLER_98_332 VGND VGND VPWR VPWR sky130_fd_sc_hd__decap_3
X_6102_ _6821_/S _6097_/X _7244_/B VGND VGND VPWR VPWR _6102_/X sky130_fd_sc_hd__o21a_2
XFILLER_113_643 VGND VGND VPWR VPWR sky130_fd_sc_hd__decap_3
X_7082_ _7094_/B _7081_/C _7081_/A VGND VGND VPWR VPWR _7090_/D sky130_fd_sc_hd__a21o_2
XFILLER_113_676 VGND VGND VPWR VPWR sky130_fd_sc_hd__decap_3
XFILLER_100_304 VGND VGND VPWR VPWR sky130_fd_sc_hd__decap_3
XFILLER_86_527 VGND VGND VPWR VPWR sky130_fd_sc_hd__decap_3
X_6033_ _6033_/A _6033_/B VGND VGND VPWR VPWR _7329_/C sky130_fd_sc_hd__nand2_2
XFILLER_86_549 VGND VGND VPWR VPWR sky130_fd_sc_hd__decap_3
XFILLER_39_421 VGND VGND VPWR VPWR sky130_fd_sc_hd__fill_1
XFILLER_39_432 VGND VGND VPWR VPWR sky130_fd_sc_hd__decap_3
XTAP_TAPCELL_ROW_68_1203 VGND VPWR sky130_fd_sc_hd__tapvpwrvgnd_1
XFILLER_94_571 VGND VGND VPWR VPWR sky130_fd_sc_hd__fill_1
XFILLER_66_262 VGND VGND VPWR VPWR sky130_fd_sc_hd__decap_3
XFILLER_66_284 VGND VGND VPWR VPWR sky130_fd_sc_hd__fill_1
XFILLER_54_424 VGND VGND VPWR VPWR sky130_fd_sc_hd__fill_1
XFILLER_27_649 VGND VGND VPWR VPWR sky130_fd_sc_hd__decap_3
X_7984_ _8111_/B _7984_/B VGND VGND VPWR VPWR _7985_/B sky130_fd_sc_hd__xor2_2
X_6935_ _6934_/B _6944_/B _6764_/A VGND VGND VPWR VPWR _6936_/B sky130_fd_sc_hd__o21a_2
XFILLER_42_619 VGND VGND VPWR VPWR sky130_fd_sc_hd__fill_1
XFILLER_25_27 VGND VGND VPWR VPWR sky130_fd_sc_hd__decap_3
XFILLER_25_49 VGND VGND VPWR VPWR sky130_fd_sc_hd__decap_3
XFILLER_35_693 VGND VGND VPWR VPWR sky130_fd_sc_hd__fill_2
XFILLER_22_321 VGND VGND VPWR VPWR sky130_fd_sc_hd__decap_3
X_6866_ _6865_/Y _6832_/B _6833_/A VGND VGND VPWR VPWR _6866_/X sky130_fd_sc_hd__a21o_2
X_8605_ _8605_/A _8632_/A VGND VGND VPWR VPWR _8607_/B sky130_fd_sc_hd__xnor2_2
X_5817_ _5820_/B _5973_/B VGND VGND VPWR VPWR _5822_/C sky130_fd_sc_hd__and2_2
XFILLER_22_365 VGND VGND VPWR VPWR sky130_fd_sc_hd__decap_3
X_6797_ _7877_/A _6797_/B VGND VGND VPWR VPWR _6797_/Y sky130_fd_sc_hd__nand2_2
XFILLER_50_685 VGND VGND VPWR VPWR sky130_fd_sc_hd__fill_1
XFILLER_41_15 VGND VGND VPWR VPWR sky130_fd_sc_hd__decap_3
XFILLER_22_387 VGND VGND VPWR VPWR sky130_fd_sc_hd__decap_3
X_5748_ _7955_/A _5749_/B VGND VGND VPWR VPWR _5748_/Y sky130_fd_sc_hd__nand2_2
X_8536_ _8549_/A _8554_/B VGND VGND VPWR VPWR _8538_/A sky130_fd_sc_hd__nand2_2
XFILLER_41_48 VGND VGND VPWR VPWR sky130_fd_sc_hd__decap_3
XTAP_TAPCELL_ROW_20_555 VGND VPWR sky130_fd_sc_hd__tapvpwrvgnd_1
XTAP_TAPCELL_ROW_79_1343 VGND VPWR sky130_fd_sc_hd__tapvpwrvgnd_1
X_5679_ _5949_/B _5675_/X _5678_/X VGND VGND VPWR VPWR _5679_/X sky130_fd_sc_hd__a21o_2
X_8467_ _8467_/A _8467_/B VGND VGND VPWR VPWR _8467_/Y sky130_fd_sc_hd__xnor2_2
XTAP_TAPCELL_ROW_79_1354 VGND VPWR sky130_fd_sc_hd__tapvpwrvgnd_1
X_7418_ _7418_/A _7418_/B VGND VGND VPWR VPWR _7419_/B sky130_fd_sc_hd__xnor2_2
X_8398_ _8398_/A _8398_/B VGND VGND VPWR VPWR _8399_/B sky130_fd_sc_hd__or2_2
XFILLER_2_704 VGND VGND VPWR VPWR sky130_fd_sc_hd__decap_3
XTAP_TAPCELL_ROW_92_1521 VGND VPWR sky130_fd_sc_hd__tapvpwrvgnd_1
X_7349_ _7349_/A1 _7078_/Y _7089_/X _7090_/Y VGND VGND VPWR VPWR _7349_/X sky130_fd_sc_hd__o211a_2
XFILLER_2_737 VGND VGND VPWR VPWR sky130_fd_sc_hd__decap_3
XFILLER_9_6 VGND VGND VPWR VPWR sky130_fd_sc_hd__decap_3
XFILLER_89_332 VGND VGND VPWR VPWR sky130_fd_sc_hd__decap_3
XFILLER_1_225 VGND VGND VPWR VPWR sky130_fd_sc_hd__fill_1
XFILLER_103_131 VGND VGND VPWR VPWR sky130_fd_sc_hd__decap_3
XFILLER_1_247 VGND VGND VPWR VPWR sky130_fd_sc_hd__decap_3
XFILLER_103_175 VGND VGND VPWR VPWR sky130_fd_sc_hd__fill_2
XFILLER_106_63 VGND VGND VPWR VPWR sky130_fd_sc_hd__fill_2
X_9019_ _9335_/CLK _9019_/D load_slew399/X VGND VGND VPWR VPWR _9019_/Q sky130_fd_sc_hd__dfrtp_2
XFILLER_77_549 VGND VGND VPWR VPWR sky130_fd_sc_hd__decap_3
Xhold1250 hold1250/A VGND VGND VPWR VPWR hold1250/X sky130_fd_sc_hd__dlygate4sd3_1
XFILLER_73_711 VGND VGND VPWR VPWR sky130_fd_sc_hd__decap_3
XFILLER_18_638 VGND VGND VPWR VPWR sky130_fd_sc_hd__decap_3
XFILLER_73_744 VGND VGND VPWR VPWR sky130_fd_sc_hd__decap_3
XFILLER_17_126 VGND VGND VPWR VPWR sky130_fd_sc_hd__decap_3
XFILLER_73_766 VGND VGND VPWR VPWR sky130_fd_sc_hd__fill_2
XFILLER_122_62 VGND VGND VPWR VPWR sky130_fd_sc_hd__decap_3
XTAP_TAPCELL_ROW_28_655 VGND VPWR sky130_fd_sc_hd__tapvpwrvgnd_1
XTAP_TAPCELL_ROW_28_666 VGND VPWR sky130_fd_sc_hd__tapvpwrvgnd_1
XFILLER_26_660 VGND VGND VPWR VPWR sky130_fd_sc_hd__decap_3
XFILLER_32_107 VGND VGND VPWR VPWR sky130_fd_sc_hd__decap_3
XTAP_TAPCELL_ROW_0_280 VGND VPWR sky130_fd_sc_hd__tapvpwrvgnd_1
XFILLER_82_55 VGND VGND VPWR VPWR sky130_fd_sc_hd__fill_1
XFILLER_32_129 VGND VGND VPWR VPWR sky130_fd_sc_hd__decap_3
XFILLER_60_449 VGND VGND VPWR VPWR sky130_fd_sc_hd__decap_3
XFILLER_82_77 VGND VGND VPWR VPWR sky130_fd_sc_hd__decap_3
XFILLER_82_88 VGND VGND VPWR VPWR sky130_fd_sc_hd__fill_2
XFILLER_15_60 VGND VGND VPWR VPWR sky130_fd_sc_hd__decap_3
XTAP_TAPCELL_ROW_101_1650 VGND VPWR sky130_fd_sc_hd__tapvpwrvgnd_1
XFILLER_15_93 VGND VGND VPWR VPWR sky130_fd_sc_hd__decap_3
XFILLER_13_387 VGND VGND VPWR VPWR sky130_fd_sc_hd__decap_3
XFILLER_40_184 VGND VGND VPWR VPWR sky130_fd_sc_hd__decap_3
XFILLER_127_724 VGND VGND VPWR VPWR sky130_fd_sc_hd__decap_3
XFILLER_127_735 VGND VGND VPWR VPWR sky130_fd_sc_hd__decap_3
XFILLER_126_212 VGND VGND VPWR VPWR sky130_fd_sc_hd__decap_3
XFILLER_127_768 VGND VGND VPWR VPWR sky130_fd_sc_hd__decap_3
Xrebuffer680 _6440_/A VGND VGND VPWR VPWR _6124_/A sky130_fd_sc_hd__buf_2
XFILLER_5_542 VGND VGND VPWR VPWR sky130_fd_sc_hd__fill_1
XFILLER_99_107 VGND VGND VPWR VPWR sky130_fd_sc_hd__decap_3
XFILLER_114_407 VGND VGND VPWR VPWR sky130_fd_sc_hd__decap_3
XTAP_TAPCELL_ROW_130_2035 VGND VPWR sky130_fd_sc_hd__tapvpwrvgnd_1
XFILLER_126_289 VGND VGND VPWR VPWR sky130_fd_sc_hd__decap_3
XTAP_TAPCELL_ROW_130_2046 VGND VPWR sky130_fd_sc_hd__tapvpwrvgnd_1
XFILLER_122_451 VGND VGND VPWR VPWR sky130_fd_sc_hd__fill_2
XFILLER_68_516 VGND VGND VPWR VPWR sky130_fd_sc_hd__decap_3
XTAP_TAPCELL_ROW_8_391 VGND VPWR sky130_fd_sc_hd__tapvpwrvgnd_1
XTAP_TAPCELL_ROW_112_1790 VGND VPWR sky130_fd_sc_hd__tapvpwrvgnd_1
XFILLER_110_657 VGND VGND VPWR VPWR sky130_fd_sc_hd__fill_1
XFILLER_83_508 VGND VGND VPWR VPWR sky130_fd_sc_hd__decap_3
XFILLER_76_571 VGND VGND VPWR VPWR sky130_fd_sc_hd__decap_3
XFILLER_48_262 VGND VGND VPWR VPWR sky130_fd_sc_hd__fill_2
XFILLER_36_402 VGND VGND VPWR VPWR sky130_fd_sc_hd__fill_2
XTAP_TAPCELL_ROW_47_920 VGND VPWR sky130_fd_sc_hd__tapvpwrvgnd_1
XFILLER_64_755 VGND VGND VPWR VPWR sky130_fd_sc_hd__fill_1
XFILLER_24_608 VGND VGND VPWR VPWR sky130_fd_sc_hd__decap_3
X_4981_ _4979_/X _4980_/X _6206_/B VGND VGND VPWR VPWR _4981_/Y sky130_fd_sc_hd__a21oi_2
XFILLER_51_405 VGND VGND VPWR VPWR sky130_fd_sc_hd__decap_3
XFILLER_91_585 VGND VGND VPWR VPWR sky130_fd_sc_hd__decap_3
XFILLER_23_129 VGND VGND VPWR VPWR sky130_fd_sc_hd__decap_3
X_6720_ _6972_/A _7071_/D VGND VGND VPWR VPWR _6723_/A sky130_fd_sc_hd__nand2_2
XFILLER_51_449 VGND VGND VPWR VPWR sky130_fd_sc_hd__decap_3
XFILLER_32_630 VGND VGND VPWR VPWR sky130_fd_sc_hd__decap_3
XTAP_TAPCELL_ROW_63_1133 VGND VPWR sky130_fd_sc_hd__tapvpwrvgnd_1
XFILLER_16_192 VGND VGND VPWR VPWR sky130_fd_sc_hd__decap_3
X_6651_ _6651_/A _6651_/B VGND VGND VPWR VPWR _6652_/B sky130_fd_sc_hd__nand2_2
X_5602_ _5602_/A _5602_/B VGND VGND VPWR VPWR _5603_/B sky130_fd_sc_hd__xnor2_2
X_6582_ _6582_/A _6582_/B VGND VGND VPWR VPWR _6665_/A sky130_fd_sc_hd__xnor2_2
XFILLER_118_713 VGND VGND VPWR VPWR sky130_fd_sc_hd__decap_3
X_5533_ _5524_/A _5524_/B _5524_/C VGND VGND VPWR VPWR _5533_/X sky130_fd_sc_hd__a21o_2
X_8321_ _8321_/A VGND VGND VPWR VPWR _8321_/Y sky130_fd_sc_hd__inv_2
XFILLER_117_212 VGND VGND VPWR VPWR sky130_fd_sc_hd__fill_1
XFILLER_11_18 VGND VGND VPWR VPWR sky130_fd_sc_hd__decap_3
XFILLER_118_746 VGND VGND VPWR VPWR sky130_fd_sc_hd__decap_3
XFILLER_118_757 VGND VGND VPWR VPWR sky130_fd_sc_hd__decap_3
X_8252_ _8252_/A _8251_/X VGND VGND VPWR VPWR _8253_/B sky130_fd_sc_hd__or2b_2
X_5464_ _5464_/A1 _5878_/C _5461_/X _5462_/X _5463_/X VGND VGND VPWR VPWR _5464_/X
+ sky130_fd_sc_hd__a32o_2
XFILLER_127_18 VGND VGND VPWR VPWR sky130_fd_sc_hd__decap_3
XFILLER_117_267 VGND VGND VPWR VPWR sky130_fd_sc_hd__decap_3
XFILLER_105_418 VGND VGND VPWR VPWR sky130_fd_sc_hd__decap_3
X_7203_ _8013_/A _7203_/B VGND VGND VPWR VPWR _7203_/Y sky130_fd_sc_hd__nand2_2
XFILLER_117_289 VGND VGND VPWR VPWR sky130_fd_sc_hd__decap_3
X_8183_ _8184_/A _8184_/B VGND VGND VPWR VPWR _8185_/A sky130_fd_sc_hd__and2_2
X_5395_ _5395_/A _5395_/B VGND VGND VPWR VPWR _5493_/C sky130_fd_sc_hd__xnor2_2
X_7134_ _7134_/A1 _7133_/C _7133_/A VGND VGND VPWR VPWR _7273_/B sky130_fd_sc_hd__a21oi_2
XFILLER_113_440 VGND VGND VPWR VPWR sky130_fd_sc_hd__decap_3
Xfanout304 hold757/X VGND VGND VPWR VPWR _5934_/A sky130_fd_sc_hd__buf_6
XFILLER_99_663 VGND VGND VPWR VPWR sky130_fd_sc_hd__decap_3
XTAP_TAPCELL_ROW_74_1284 VGND VPWR sky130_fd_sc_hd__tapvpwrvgnd_1
XFILLER_98_151 VGND VGND VPWR VPWR sky130_fd_sc_hd__decap_3
XFILLER_59_505 VGND VGND VPWR VPWR sky130_fd_sc_hd__fill_2
XFILLER_98_162 VGND VGND VPWR VPWR sky130_fd_sc_hd__decap_3
Xfanout348 fanout350/X VGND VGND VPWR VPWR _6406_/B sky130_fd_sc_hd__buf_6
XFILLER_98_173 VGND VGND VPWR VPWR sky130_fd_sc_hd__decap_3
XFILLER_113_484 VGND VGND VPWR VPWR sky130_fd_sc_hd__decap_3
XFILLER_101_635 VGND VGND VPWR VPWR sky130_fd_sc_hd__fill_1
X_7065_ _7065_/A _7065_/B VGND VGND VPWR VPWR _7069_/A sky130_fd_sc_hd__nor2_2
XFILLER_59_549 VGND VGND VPWR VPWR sky130_fd_sc_hd__fill_1
XFILLER_100_112 VGND VGND VPWR VPWR sky130_fd_sc_hd__decap_3
XFILLER_86_335 VGND VGND VPWR VPWR sky130_fd_sc_hd__decap_3
X_6016_ _7114_/B _6249_/A VGND VGND VPWR VPWR _6016_/Y sky130_fd_sc_hd__nand2_2
XFILLER_86_368 VGND VGND VPWR VPWR sky130_fd_sc_hd__decap_3
XFILLER_101_679 VGND VGND VPWR VPWR sky130_fd_sc_hd__fill_1
XFILLER_39_251 VGND VGND VPWR VPWR sky130_fd_sc_hd__decap_3
XFILLER_27_424 VGND VGND VPWR VPWR sky130_fd_sc_hd__decap_3
XFILLER_39_295 VGND VGND VPWR VPWR sky130_fd_sc_hd__decap_3
XFILLER_82_552 VGND VGND VPWR VPWR sky130_fd_sc_hd__decap_3
XFILLER_36_59 VGND VGND VPWR VPWR sky130_fd_sc_hd__decap_3
XFILLER_70_714 VGND VGND VPWR VPWR sky130_fd_sc_hd__decap_3
X_7967_ _7790_/A _7789_/B _7966_/X VGND VGND VPWR VPWR _8080_/B sky130_fd_sc_hd__o21a_2
XFILLER_42_416 VGND VGND VPWR VPWR sky130_fd_sc_hd__fill_1
XTAP_TAPCELL_ROW_25_614 VGND VPWR sky130_fd_sc_hd__tapvpwrvgnd_1
XFILLER_14_118 VGND VGND VPWR VPWR sky130_fd_sc_hd__decap_3
XTAP_TAPCELL_ROW_25_625 VGND VPWR sky130_fd_sc_hd__tapvpwrvgnd_1
X_6918_ _6768_/A _6768_/B _6917_/X VGND VGND VPWR VPWR _6919_/B sky130_fd_sc_hd__a21oi_2
Xclkbuf_leaf_34_clk clkload1/A VGND VGND VPWR VPWR _9215_/CLK sky130_fd_sc_hd__clkbuf_8
X_7898_ _7898_/A0 _7897_/Y _8045_/S VGND VGND VPWR VPWR _7898_/X sky130_fd_sc_hd__mux2_2
XFILLER_23_652 VGND VGND VPWR VPWR sky130_fd_sc_hd__decap_3
X_6849_ _6849_/A _6849_/B VGND VGND VPWR VPWR _6850_/B sky130_fd_sc_hd__xnor2_2
XFILLER_10_346 VGND VGND VPWR VPWR sky130_fd_sc_hd__decap_3
XFILLER_108_212 VGND VGND VPWR VPWR sky130_fd_sc_hd__decap_3
X_8519_ _8486_/A _8513_/Y _8514_/Y _8518_/X VGND VGND VPWR VPWR _8539_/B sky130_fd_sc_hd__a31o_2
XFILLER_6_339 VGND VGND VPWR VPWR sky130_fd_sc_hd__decap_3
XFILLER_108_245 VGND VGND VPWR VPWR sky130_fd_sc_hd__fill_1
XFILLER_108_256 VGND VGND VPWR VPWR sky130_fd_sc_hd__decap_3
XFILLER_124_716 VGND VGND VPWR VPWR sky130_fd_sc_hd__decap_3
XFILLER_124_749 VGND VGND VPWR VPWR sky130_fd_sc_hd__decap_3
XFILLER_7_3 VGND VGND VPWR VPWR sky130_fd_sc_hd__decap_3
XFILLER_117_51 VGND VGND VPWR VPWR sky130_fd_sc_hd__decap_3
XFILLER_104_451 VGND VGND VPWR VPWR sky130_fd_sc_hd__decap_3
XFILLER_117_84 VGND VGND VPWR VPWR sky130_fd_sc_hd__decap_3
XFILLER_77_44 VGND VGND VPWR VPWR sky130_fd_sc_hd__decap_3
XFILLER_2_589 VGND VGND VPWR VPWR sky130_fd_sc_hd__decap_3
XFILLER_77_335 VGND VGND VPWR VPWR sky130_fd_sc_hd__fill_1
XTAP_TAPCELL_ROW_5_350 VGND VPWR sky130_fd_sc_hd__tapvpwrvgnd_1
XFILLER_65_508 VGND VGND VPWR VPWR sky130_fd_sc_hd__decap_3
XFILLER_93_10 VGND VGND VPWR VPWR sky130_fd_sc_hd__decap_3
XFILLER_58_582 VGND VGND VPWR VPWR sky130_fd_sc_hd__decap_3
Xhold1080 _9327_/Q VGND VGND VPWR VPWR _9005_/A1 sky130_fd_sc_hd__dlygate4sd3_1
XFILLER_73_530 VGND VGND VPWR VPWR sky130_fd_sc_hd__decap_3
XFILLER_46_755 VGND VGND VPWR VPWR sky130_fd_sc_hd__fill_1
XFILLER_18_446 VGND VGND VPWR VPWR sky130_fd_sc_hd__decap_3
Xhold1091 _9115_/Q VGND VGND VPWR VPWR _4769_/A1 sky130_fd_sc_hd__dlygate4sd3_1
XFILLER_46_766 VGND VGND VPWR VPWR sky130_fd_sc_hd__decap_3
XFILLER_61_703 VGND VGND VPWR VPWR sky130_fd_sc_hd__decap_3
XFILLER_45_254 VGND VGND VPWR VPWR sky130_fd_sc_hd__decap_3
XFILLER_33_416 VGND VGND VPWR VPWR sky130_fd_sc_hd__decap_3
XFILLER_45_287 VGND VGND VPWR VPWR sky130_fd_sc_hd__decap_3
XFILLER_61_747 VGND VGND VPWR VPWR sky130_fd_sc_hd__decap_3
Xclkbuf_leaf_25_clk clkbuf_leaf_9_clk/A VGND VGND VPWR VPWR _9346_/CLK sky130_fd_sc_hd__clkbuf_8
XFILLER_9_100 VGND VGND VPWR VPWR sky130_fd_sc_hd__decap_3
XFILLER_9_111 VGND VGND VPWR VPWR sky130_fd_sc_hd__fill_1
XFILLER_41_493 VGND VGND VPWR VPWR sky130_fd_sc_hd__fill_2
XFILLER_9_144 VGND VGND VPWR VPWR sky130_fd_sc_hd__decap_3
XFILLER_13_195 VGND VGND VPWR VPWR sky130_fd_sc_hd__decap_3
XFILLER_42_80 VGND VGND VPWR VPWR sky130_fd_sc_hd__decap_3
XFILLER_42_91 VGND VGND VPWR VPWR sky130_fd_sc_hd__fill_1
XFILLER_127_521 VGND VGND VPWR VPWR sky130_fd_sc_hd__decap_3
XFILLER_61_6 VGND VGND VPWR VPWR sky130_fd_sc_hd__decap_3
XFILLER_115_716 VGND VGND VPWR VPWR sky130_fd_sc_hd__decap_3
XFILLER_127_598 VGND VGND VPWR VPWR sky130_fd_sc_hd__decap_3
XFILLER_130_719 VGND VGND VPWR VPWR sky130_fd_sc_hd__decap_3
X_5180_ _9258_/Q _9322_/Q _5180_/S VGND VGND VPWR VPWR _5180_/X sky130_fd_sc_hd__mux2_2
XFILLER_123_771 VGND VGND VPWR VPWR sky130_fd_sc_hd__decap_3
XFILLER_3_30 VGND VGND VPWR VPWR sky130_fd_sc_hd__decap_3
XFILLER_110_410 VGND VGND VPWR VPWR sky130_fd_sc_hd__decap_3
XFILLER_110_421 VGND VGND VPWR VPWR sky130_fd_sc_hd__decap_3
XFILLER_3_63 VGND VGND VPWR VPWR sky130_fd_sc_hd__decap_3
XFILLER_122_292 VGND VGND VPWR VPWR sky130_fd_sc_hd__decap_3
XFILLER_3_96 VGND VGND VPWR VPWR sky130_fd_sc_hd__decap_3
XFILLER_96_699 VGND VGND VPWR VPWR sky130_fd_sc_hd__fill_1
XFILLER_37_700 VGND VGND VPWR VPWR sky130_fd_sc_hd__decap_3
XFILLER_49_593 VGND VGND VPWR VPWR sky130_fd_sc_hd__decap_3
XFILLER_36_210 VGND VGND VPWR VPWR sky130_fd_sc_hd__decap_3
X_8870_ _8870_/A VGND VGND VPWR VPWR _9278_/D sky130_fd_sc_hd__buf_1
XFILLER_64_530 VGND VGND VPWR VPWR sky130_fd_sc_hd__fill_2
X_7821_ _9215_/Q _7924_/B _8099_/C _7924_/A VGND VGND VPWR VPWR _7821_/X sky130_fd_sc_hd__o22a_2
XFILLER_91_360 VGND VGND VPWR VPWR sky130_fd_sc_hd__decap_3
XFILLER_91_371 VGND VGND VPWR VPWR sky130_fd_sc_hd__decap_3
XFILLER_51_202 VGND VGND VPWR VPWR sky130_fd_sc_hd__decap_3
XFILLER_36_276 VGND VGND VPWR VPWR sky130_fd_sc_hd__decap_3
XTAP_TAPCELL_ROW_125_1970 VGND VPWR sky130_fd_sc_hd__tapvpwrvgnd_1
XFILLER_52_747 VGND VGND VPWR VPWR sky130_fd_sc_hd__decap_3
XFILLER_24_438 VGND VGND VPWR VPWR sky130_fd_sc_hd__decap_3
XFILLER_91_393 VGND VGND VPWR VPWR sky130_fd_sc_hd__decap_3
X_4964_ _6953_/A VGND VGND VPWR VPWR _7096_/A sky130_fd_sc_hd__buf_4
X_7752_ _7634_/Y _7647_/B _7752_/B1 VGND VGND VPWR VPWR _7752_/X sky130_fd_sc_hd__a21o_2
Xclkbuf_leaf_16_clk clkbuf_leaf_9_clk/A VGND VGND VPWR VPWR _9331_/CLK sky130_fd_sc_hd__clkbuf_8
XFILLER_51_257 VGND VGND VPWR VPWR sky130_fd_sc_hd__fill_2
X_6703_ _6703_/A _8405_/B VGND VGND VPWR VPWR _7421_/C sky130_fd_sc_hd__nor2_2
X_4895_ _9219_/Q _4899_/B VGND VGND VPWR VPWR _4895_/Y sky130_fd_sc_hd__nor2_2
X_7683_ _7683_/A _8037_/A VGND VGND VPWR VPWR _7684_/B sky130_fd_sc_hd__xor2_2
XTAP_TAPCELL_ROW_50_959 VGND VPWR sky130_fd_sc_hd__tapvpwrvgnd_1
X_6634_ _5048_/B _6632_/Y _6633_/Y _6351_/B VGND VGND VPWR VPWR _6661_/B sky130_fd_sc_hd__o22a_2
XFILLER_20_666 VGND VGND VPWR VPWR sky130_fd_sc_hd__decap_3
XFILLER_118_510 VGND VGND VPWR VPWR sky130_fd_sc_hd__decap_3
X_6565_ _6668_/A _6668_/B _6669_/B VGND VGND VPWR VPWR _6566_/B sky130_fd_sc_hd__a21o_2
XTAP_TAPCELL_ROW_30_683 VGND VPWR sky130_fd_sc_hd__tapvpwrvgnd_1
XTAP_TAPCELL_ROW_76_1302 VGND VPWR sky130_fd_sc_hd__tapvpwrvgnd_1
X_8304_ _8304_/A_N _8304_/B VGND VGND VPWR VPWR _8304_/X sky130_fd_sc_hd__and2b_2
X_5516_ _5550_/B _5516_/B VGND VGND VPWR VPWR _5521_/A sky130_fd_sc_hd__xor2_2
XTAP_TAPCELL_ROW_76_1313 VGND VPWR sky130_fd_sc_hd__tapvpwrvgnd_1
X_6496_ _6497_/B _6442_/B VGND VGND VPWR VPWR _6496_/X sky130_fd_sc_hd__or2b_2
X_9284_ _9348_/CLK _9284_/D fanout403/X VGND VGND VPWR VPWR _9284_/Q sky130_fd_sc_hd__dfrtp_2
XFILLER_106_727 VGND VGND VPWR VPWR sky130_fd_sc_hd__decap_3
XFILLER_118_587 VGND VGND VPWR VPWR sky130_fd_sc_hd__fill_1
X_5447_ _5443_/X _5446_/X _8175_/A VGND VGND VPWR VPWR _6963_/B sky130_fd_sc_hd__a21oi_4
X_8235_ _8226_/X _8234_/X _8222_/A VGND VGND VPWR VPWR _8253_/A sky130_fd_sc_hd__a21o_2
X_5378_ _9024_/Q _9152_/Q _5384_/A VGND VGND VPWR VPWR _5379_/C sky130_fd_sc_hd__mux2_2
X_8166_ _8165_/B _8165_/C _8315_/A VGND VGND VPWR VPWR _8167_/C sky130_fd_sc_hd__a21oi_2
X_7117_ _7117_/A _7117_/B _9211_/Q VGND VGND VPWR VPWR _7117_/X sky130_fd_sc_hd__or3b_2
X_8097_ _9217_/Q _9218_/Q VGND VGND VPWR VPWR _8097_/Y sky130_fd_sc_hd__nor2_2
XFILLER_59_335 VGND VGND VPWR VPWR sky130_fd_sc_hd__fill_1
XFILLER_113_281 VGND VGND VPWR VPWR sky130_fd_sc_hd__decap_3
XFILLER_59_346 VGND VGND VPWR VPWR sky130_fd_sc_hd__fill_1
XFILLER_59_357 VGND VGND VPWR VPWR sky130_fd_sc_hd__decap_3
XFILLER_47_508 VGND VGND VPWR VPWR sky130_fd_sc_hd__decap_3
X_7048_ _6997_/A _6997_/B _5201_/A _6939_/B VGND VGND VPWR VPWR _7048_/X sky130_fd_sc_hd__a211o_2
XFILLER_86_165 VGND VGND VPWR VPWR sky130_fd_sc_hd__decap_3
XFILLER_47_47 VGND VGND VPWR VPWR sky130_fd_sc_hd__decap_3
XFILLER_28_711 VGND VGND VPWR VPWR sky130_fd_sc_hd__decap_3
XPHY_EDGE_ROW_114_Right_114 VGND VGND VPWR VPWR sky130_fd_sc_hd__decap_3
XFILLER_101_498 VGND VGND VPWR VPWR sky130_fd_sc_hd__decap_3
XFILLER_28_766 VGND VGND VPWR VPWR sky130_fd_sc_hd__decap_3
XTAP_TAPCELL_ROW_87_1453 VGND VPWR sky130_fd_sc_hd__tapvpwrvgnd_1
XFILLER_55_552 VGND VGND VPWR VPWR sky130_fd_sc_hd__decap_3
XFILLER_43_703 VGND VGND VPWR VPWR sky130_fd_sc_hd__fill_2
XFILLER_82_360 VGND VGND VPWR VPWR sky130_fd_sc_hd__decap_3
XFILLER_15_405 VGND VGND VPWR VPWR sky130_fd_sc_hd__decap_3
XFILLER_43_725 VGND VGND VPWR VPWR sky130_fd_sc_hd__decap_3
XFILLER_27_276 VGND VGND VPWR VPWR sky130_fd_sc_hd__decap_3
XFILLER_103_75 VGND VGND VPWR VPWR sky130_fd_sc_hd__fill_2
X_8999_ _9340_/Q _8999_/A1 _9009_/S VGND VGND VPWR VPWR _8999_/X sky130_fd_sc_hd__mux2_2
XFILLER_15_427 VGND VGND VPWR VPWR sky130_fd_sc_hd__decap_3
XFILLER_70_522 VGND VGND VPWR VPWR sky130_fd_sc_hd__decap_3
XFILLER_42_213 VGND VGND VPWR VPWR sky130_fd_sc_hd__fill_1
XFILLER_103_97 VGND VGND VPWR VPWR sky130_fd_sc_hd__decap_3
XTAP_TAPCELL_ROW_38_794 VGND VPWR sky130_fd_sc_hd__tapvpwrvgnd_1
XFILLER_70_533 VGND VGND VPWR VPWR sky130_fd_sc_hd__fill_1
XFILLER_70_544 VGND VGND VPWR VPWR sky130_fd_sc_hd__decap_3
XFILLER_43_758 VGND VGND VPWR VPWR sky130_fd_sc_hd__decap_3
XFILLER_15_449 VGND VGND VPWR VPWR sky130_fd_sc_hd__decap_3
XFILLER_63_57 VGND VGND VPWR VPWR sky130_fd_sc_hd__fill_1
XFILLER_70_566 VGND VGND VPWR VPWR sky130_fd_sc_hd__decap_3
XFILLER_11_611 VGND VGND VPWR VPWR sky130_fd_sc_hd__decap_3
XFILLER_10_132 VGND VGND VPWR VPWR sky130_fd_sc_hd__fill_1
XFILLER_7_626 VGND VGND VPWR VPWR sky130_fd_sc_hd__decap_3
XFILLER_6_103 VGND VGND VPWR VPWR sky130_fd_sc_hd__decap_3
XFILLER_7_637 VGND VGND VPWR VPWR sky130_fd_sc_hd__decap_3
XFILLER_11_699 VGND VGND VPWR VPWR sky130_fd_sc_hd__decap_3
XFILLER_7_659 VGND VGND VPWR VPWR sky130_fd_sc_hd__decap_3
XFILLER_109_554 VGND VGND VPWR VPWR sky130_fd_sc_hd__decap_3
XFILLER_6_147 VGND VGND VPWR VPWR sky130_fd_sc_hd__fill_1
XFILLER_128_50 VGND VGND VPWR VPWR sky130_fd_sc_hd__decap_3
XFILLER_128_83 VGND VGND VPWR VPWR sky130_fd_sc_hd__fill_1
XFILLER_128_94 VGND VGND VPWR VPWR sky130_fd_sc_hd__decap_3
XFILLER_124_579 VGND VGND VPWR VPWR sky130_fd_sc_hd__decap_3
XFILLER_112_719 VGND VGND VPWR VPWR sky130_fd_sc_hd__fill_2
XFILLER_78_611 VGND VGND VPWR VPWR sky130_fd_sc_hd__decap_3
XFILLER_78_633 VGND VGND VPWR VPWR sky130_fd_sc_hd__decap_3
XFILLER_104_292 VGND VGND VPWR VPWR sky130_fd_sc_hd__decap_3
XFILLER_120_752 VGND VGND VPWR VPWR sky130_fd_sc_hd__decap_3
XFILLER_38_508 VGND VGND VPWR VPWR sky130_fd_sc_hd__decap_3
XFILLER_120_763 VGND VGND VPWR VPWR sky130_fd_sc_hd__decap_3
XFILLER_78_677 VGND VGND VPWR VPWR sky130_fd_sc_hd__decap_3
XFILLER_77_165 VGND VGND VPWR VPWR sky130_fd_sc_hd__decap_3
XFILLER_78_699 VGND VGND VPWR VPWR sky130_fd_sc_hd__fill_1
XFILLER_19_722 VGND VGND VPWR VPWR sky130_fd_sc_hd__decap_3
XFILLER_93_658 VGND VGND VPWR VPWR sky130_fd_sc_hd__decap_3
XFILLER_65_349 VGND VGND VPWR VPWR sky130_fd_sc_hd__decap_3
XFILLER_19_744 VGND VGND VPWR VPWR sky130_fd_sc_hd__decap_3
XFILLER_18_221 VGND VGND VPWR VPWR sky130_fd_sc_hd__fill_1
XFILLER_46_552 VGND VGND VPWR VPWR sky130_fd_sc_hd__decap_3
XFILLER_61_511 VGND VGND VPWR VPWR sky130_fd_sc_hd__decap_3
XFILLER_46_585 VGND VGND VPWR VPWR sky130_fd_sc_hd__decap_3
XFILLER_34_769 VGND VGND VPWR VPWR sky130_fd_sc_hd__decap_3
XFILLER_61_555 VGND VGND VPWR VPWR sky130_fd_sc_hd__decap_3
XTAP_TAPCELL_ROW_16_499 VGND VPWR sky130_fd_sc_hd__tapvpwrvgnd_1
XFILLER_53_90 VGND VGND VPWR VPWR sky130_fd_sc_hd__decap_3
X_4680_ _4680_/A VGND VGND VPWR VPWR _9088_/D sky130_fd_sc_hd__buf_1
XFILLER_119_318 VGND VGND VPWR VPWR sky130_fd_sc_hd__fill_2
XFILLER_119_329 VGND VGND VPWR VPWR sky130_fd_sc_hd__fill_1
X_6350_ _6350_/A _9209_/Q VGND VGND VPWR VPWR _6351_/A sky130_fd_sc_hd__xnor2_4
XFILLER_127_340 VGND VGND VPWR VPWR sky130_fd_sc_hd__decap_3
XFILLER_127_373 VGND VGND VPWR VPWR sky130_fd_sc_hd__decap_3
XFILLER_115_513 VGND VGND VPWR VPWR sky130_fd_sc_hd__decap_3
X_5301_ _7313_/A _7313_/B _5041_/B VGND VGND VPWR VPWR _5369_/B sky130_fd_sc_hd__a21oi_2
XFILLER_6_681 VGND VGND VPWR VPWR sky130_fd_sc_hd__decap_3
X_6281_ _6279_/X _6172_/A _6280_/X VGND VGND VPWR VPWR _6281_/Y sky130_fd_sc_hd__a21oi_4
XTAP_TAPCELL_ROW_58_1065 VGND VPWR sky130_fd_sc_hd__tapvpwrvgnd_1
XFILLER_115_546 VGND VGND VPWR VPWR sky130_fd_sc_hd__decap_3
XFILLER_103_719 VGND VGND VPWR VPWR sky130_fd_sc_hd__decap_3
X_5232_ _7676_/C _5219_/Y _5231_/Y _6094_/B VGND VGND VPWR VPWR _5232_/X sky130_fd_sc_hd__o22a_2
X_8020_ _8020_/A _8020_/B VGND VGND VPWR VPWR _8020_/Y sky130_fd_sc_hd__nor2_2
Xclkbuf_leaf_5_clk clkload0/A VGND VGND VPWR VPWR clkload6/A sky130_fd_sc_hd__clkbuf_8
XFILLER_130_505 VGND VGND VPWR VPWR sky130_fd_sc_hd__decap_3
X_5163_ _7561_/A _5163_/B VGND VGND VPWR VPWR _5163_/X sky130_fd_sc_hd__or2_2
XTAP_TAPCELL_ROW_71_1243 VGND VPWR sky130_fd_sc_hd__tapvpwrvgnd_1
XFILLER_69_644 VGND VGND VPWR VPWR sky130_fd_sc_hd__decap_3
XFILLER_96_452 VGND VGND VPWR VPWR sky130_fd_sc_hd__decap_3
XFILLER_96_463 VGND VGND VPWR VPWR sky130_fd_sc_hd__decap_3
XFILLER_29_508 VGND VGND VPWR VPWR sky130_fd_sc_hd__decap_3
XFILLER_69_688 VGND VGND VPWR VPWR sky130_fd_sc_hd__decap_3
XFILLER_56_305 VGND VGND VPWR VPWR sky130_fd_sc_hd__decap_3
X_5094_ _6270_/S VGND VGND VPWR VPWR _5094_/X sky130_fd_sc_hd__buf_2
XFILLER_83_113 VGND VGND VPWR VPWR sky130_fd_sc_hd__decap_3
XFILLER_83_124 VGND VGND VPWR VPWR sky130_fd_sc_hd__decap_3
XFILLER_110_284 VGND VGND VPWR VPWR sky130_fd_sc_hd__fill_2
X_8922_ _8922_/A VGND VGND VPWR VPWR _9303_/D sky130_fd_sc_hd__buf_1
XFILLER_84_669 VGND VGND VPWR VPWR sky130_fd_sc_hd__decap_3
XFILLER_83_146 VGND VGND VPWR VPWR sky130_fd_sc_hd__fill_2
XFILLER_37_541 VGND VGND VPWR VPWR sky130_fd_sc_hd__fill_1
X_8853_ _8853_/A VGND VGND VPWR VPWR _9270_/D sky130_fd_sc_hd__buf_1
XFILLER_64_360 VGND VGND VPWR VPWR sky130_fd_sc_hd__decap_3
XFILLER_25_725 VGND VGND VPWR VPWR sky130_fd_sc_hd__decap_3
XFILLER_25_747 VGND VGND VPWR VPWR sky130_fd_sc_hd__decap_3
X_7804_ _8080_/A _8406_/A VGND VGND VPWR VPWR _8341_/A sky130_fd_sc_hd__nand2_2
XFILLER_52_533 VGND VGND VPWR VPWR sky130_fd_sc_hd__decap_3
X_8784_ _8784_/A VGND VGND VPWR VPWR _9237_/D sky130_fd_sc_hd__buf_1
X_5996_ _9313_/Q _6758_/B _6758_/C VGND VGND VPWR VPWR _5996_/X sky130_fd_sc_hd__and3_2
XTAP_TAPCELL_ROW_35_753 VGND VPWR sky130_fd_sc_hd__tapvpwrvgnd_1
XFILLER_24_268 VGND VGND VPWR VPWR sky130_fd_sc_hd__decap_3
X_7735_ _7735_/A _7735_/B VGND VGND VPWR VPWR _7736_/B sky130_fd_sc_hd__xnor2_2
X_4947_ _5716_/A _9034_/Q _5006_/B VGND VGND VPWR VPWR _4947_/X sky130_fd_sc_hd__and3_2
XTAP_TAPCELL_ROW_82_1383 VGND VPWR sky130_fd_sc_hd__tapvpwrvgnd_1
XTAP_TAPCELL_ROW_82_1394 VGND VPWR sky130_fd_sc_hd__tapvpwrvgnd_1
XFILLER_20_430 VGND VGND VPWR VPWR sky130_fd_sc_hd__decap_3
X_7666_ _8035_/S _7666_/B VGND VGND VPWR VPWR _7667_/B sky130_fd_sc_hd__xor2_2
XFILLER_130_9 VGND VGND VPWR VPWR sky130_fd_sc_hd__decap_3
X_4878_ _4878_/A VGND VGND VPWR VPWR _4878_/X sky130_fd_sc_hd__buf_1
XFILLER_20_463 VGND VGND VPWR VPWR sky130_fd_sc_hd__decap_3
X_6617_ _6617_/A VGND VGND VPWR VPWR _8161_/B sky130_fd_sc_hd__buf_6
X_7597_ _6626_/A _6626_/B _7951_/A VGND VGND VPWR VPWR _7599_/A sky130_fd_sc_hd__a21oi_2
XPHY_EDGE_ROW_104_Left_235 VGND VGND VPWR VPWR sky130_fd_sc_hd__decap_3
X_9336_ clkload6/A _9336_/D load_slew376/X VGND VGND VPWR VPWR _9336_/Q sky130_fd_sc_hd__dfrtp_2
X_6548_ _6548_/A _6548_/B VGND VGND VPWR VPWR _6692_/B sky130_fd_sc_hd__xnor2_2
XFILLER_109_6 VGND VGND VPWR VPWR sky130_fd_sc_hd__decap_3
XFILLER_3_128 VGND VGND VPWR VPWR sky130_fd_sc_hd__decap_3
X_9267_ _9331_/CLK _9267_/D load_slew386/X VGND VGND VPWR VPWR _9267_/Q sky130_fd_sc_hd__dfrtp_2
XFILLER_106_557 VGND VGND VPWR VPWR sky130_fd_sc_hd__fill_2
X_6479_ _5034_/Y _6477_/X _6478_/X _6420_/A VGND VGND VPWR VPWR _6493_/B sky130_fd_sc_hd__a2bb2o_2
X_8218_ _8218_/A _8218_/B VGND VGND VPWR VPWR _8219_/B sky130_fd_sc_hd__xnor2_2
X_9198_ clkload7/A _9198_/D fanout407/A VGND VGND VPWR VPWR _9198_/Q sky130_fd_sc_hd__dfrtp_2
X_8149_ _8149_/A _8231_/A VGND VGND VPWR VPWR _8149_/Y sky130_fd_sc_hd__nor2_2
XFILLER_58_46 VGND VGND VPWR VPWR sky130_fd_sc_hd__decap_3
XFILLER_87_441 VGND VGND VPWR VPWR sky130_fd_sc_hd__decap_3
XFILLER_59_132 VGND VGND VPWR VPWR sky130_fd_sc_hd__decap_3
XFILLER_75_603 VGND VGND VPWR VPWR sky130_fd_sc_hd__fill_2
XFILLER_87_463 VGND VGND VPWR VPWR sky130_fd_sc_hd__decap_3
XPHY_EDGE_ROW_113_Left_244 VGND VGND VPWR VPWR sky130_fd_sc_hd__decap_3
XFILLER_59_187 VGND VGND VPWR VPWR sky130_fd_sc_hd__fill_1
XFILLER_114_41 VGND VGND VPWR VPWR sky130_fd_sc_hd__decap_3
XFILLER_101_284 VGND VGND VPWR VPWR sky130_fd_sc_hd__decap_3
XFILLER_101_295 VGND VGND VPWR VPWR sky130_fd_sc_hd__decap_3
XFILLER_114_74 VGND VGND VPWR VPWR sky130_fd_sc_hd__decap_3
XFILLER_114_85 VGND VGND VPWR VPWR sky130_fd_sc_hd__decap_3
XFILLER_90_639 VGND VGND VPWR VPWR sky130_fd_sc_hd__decap_3
XFILLER_43_511 VGND VGND VPWR VPWR sky130_fd_sc_hd__fill_2
XFILLER_16_725 VGND VGND VPWR VPWR sky130_fd_sc_hd__decap_3
XFILLER_74_78 VGND VGND VPWR VPWR sky130_fd_sc_hd__decap_3
XFILLER_55_382 VGND VGND VPWR VPWR sky130_fd_sc_hd__fill_2
XFILLER_55_393 VGND VGND VPWR VPWR sky130_fd_sc_hd__decap_3
XFILLER_15_235 VGND VGND VPWR VPWR sky130_fd_sc_hd__decap_3
XFILLER_43_555 VGND VGND VPWR VPWR sky130_fd_sc_hd__decap_3
XFILLER_16_769 VGND VGND VPWR VPWR sky130_fd_sc_hd__decap_3
XFILLER_70_352 VGND VGND VPWR VPWR sky130_fd_sc_hd__decap_3
XFILLER_43_588 VGND VGND VPWR VPWR sky130_fd_sc_hd__decap_3
XFILLER_30_205 VGND VGND VPWR VPWR sky130_fd_sc_hd__decap_3
XFILLER_15_279 VGND VGND VPWR VPWR sky130_fd_sc_hd__fill_1
XFILLER_90_77 VGND VGND VPWR VPWR sky130_fd_sc_hd__decap_3
XTAP_TAPCELL_ROW_13_458 VGND VPWR sky130_fd_sc_hd__tapvpwrvgnd_1
XFILLER_90_88 VGND VGND VPWR VPWR sky130_fd_sc_hd__decap_3
XPHY_EDGE_ROW_122_Left_253 VGND VGND VPWR VPWR sky130_fd_sc_hd__decap_3
XFILLER_11_452 VGND VGND VPWR VPWR sky130_fd_sc_hd__decap_3
XFILLER_129_638 VGND VGND VPWR VPWR sky130_fd_sc_hd__decap_3
XFILLER_128_115 VGND VGND VPWR VPWR sky130_fd_sc_hd__decap_3
XFILLER_7_423 VGND VGND VPWR VPWR sky130_fd_sc_hd__decap_3
XFILLER_23_82 VGND VGND VPWR VPWR sky130_fd_sc_hd__decap_3
Xwire354 _5674_/A VGND VGND VPWR VPWR _6416_/A sky130_fd_sc_hd__clkbuf_4
XFILLER_7_456 VGND VGND VPWR VPWR sky130_fd_sc_hd__decap_3
XFILLER_128_159 VGND VGND VPWR VPWR sky130_fd_sc_hd__decap_3
Xmax_cap109 _7416_/A VGND VGND VPWR VPWR _5897_/D sky130_fd_sc_hd__clkbuf_2
XFILLER_109_384 VGND VGND VPWR VPWR sky130_fd_sc_hd__decap_3
XFILLER_3_662 VGND VGND VPWR VPWR sky130_fd_sc_hd__decap_3
XFILLER_98_739 VGND VGND VPWR VPWR sky130_fd_sc_hd__decap_3
XFILLER_3_673 VGND VGND VPWR VPWR sky130_fd_sc_hd__decap_3
XFILLER_112_516 VGND VGND VPWR VPWR sky130_fd_sc_hd__decap_3
Xload_slew315 _7560_/S VGND VGND VPWR VPWR _8461_/A1 sky130_fd_sc_hd__clkbuf_4
Xload_slew337 _7534_/A VGND VGND VPWR VPWR _7668_/A sky130_fd_sc_hd__clkbuf_4
Xload_slew359 _5950_/B VGND VGND VPWR VPWR _6076_/A sky130_fd_sc_hd__buf_4
XFILLER_24_6 VGND VGND VPWR VPWR sky130_fd_sc_hd__decap_3
XFILLER_78_463 VGND VGND VPWR VPWR sky130_fd_sc_hd__decap_3
XFILLER_66_603 VGND VGND VPWR VPWR sky130_fd_sc_hd__decap_3
XFILLER_38_305 VGND VGND VPWR VPWR sky130_fd_sc_hd__decap_3
XFILLER_78_485 VGND VGND VPWR VPWR sky130_fd_sc_hd__decap_3
XFILLER_38_316 VGND VGND VPWR VPWR sky130_fd_sc_hd__decap_3
XFILLER_66_636 VGND VGND VPWR VPWR sky130_fd_sc_hd__decap_3
XFILLER_93_422 VGND VGND VPWR VPWR sky130_fd_sc_hd__decap_3
XFILLER_65_113 VGND VGND VPWR VPWR sky130_fd_sc_hd__decap_3
XFILLER_38_349 VGND VGND VPWR VPWR sky130_fd_sc_hd__decap_3
XFILLER_93_455 VGND VGND VPWR VPWR sky130_fd_sc_hd__decap_3
XFILLER_81_606 VGND VGND VPWR VPWR sky130_fd_sc_hd__decap_3
XTAP_TAPCELL_ROW_109_1751 VGND VPWR sky130_fd_sc_hd__tapvpwrvgnd_1
XFILLER_19_552 VGND VGND VPWR VPWR sky130_fd_sc_hd__decap_3
XFILLER_93_488 VGND VGND VPWR VPWR sky130_fd_sc_hd__decap_3
XFILLER_0_53 VGND VGND VPWR VPWR sky130_fd_sc_hd__decap_3
XFILLER_74_680 VGND VGND VPWR VPWR sky130_fd_sc_hd__decap_3
XFILLER_46_371 VGND VGND VPWR VPWR sky130_fd_sc_hd__decap_3
XFILLER_80_127 VGND VGND VPWR VPWR sky130_fd_sc_hd__decap_3
XFILLER_34_533 VGND VGND VPWR VPWR sky130_fd_sc_hd__decap_3
X_5850_ _5850_/A _7071_/D VGND VGND VPWR VPWR _5851_/B sky130_fd_sc_hd__nand2_2
XFILLER_61_330 VGND VGND VPWR VPWR sky130_fd_sc_hd__decap_3
XFILLER_61_352 VGND VGND VPWR VPWR sky130_fd_sc_hd__decap_3
X_4801_ hold819/X _4801_/A1 _4819_/S VGND VGND VPWR VPWR _4802_/A sky130_fd_sc_hd__mux2_2
XFILLER_22_728 VGND VGND VPWR VPWR sky130_fd_sc_hd__decap_3
XTAP_TAPCELL_ROW_32_712 VGND VPWR sky130_fd_sc_hd__tapvpwrvgnd_1
X_5781_ _5682_/A _5779_/Y _5780_/Y VGND VGND VPWR VPWR _5811_/A sky130_fd_sc_hd__a21oi_2
XFILLER_61_385 VGND VGND VPWR VPWR sky130_fd_sc_hd__decap_3
XFILLER_61_396 VGND VGND VPWR VPWR sky130_fd_sc_hd__fill_1
X_7520_ _7520_/A _7520_/B VGND VGND VPWR VPWR _7520_/Y sky130_fd_sc_hd__xnor2_2
XFILLER_9_51 VGND VGND VPWR VPWR sky130_fd_sc_hd__decap_3
X_4732_ _4732_/A VGND VGND VPWR VPWR _9113_/D sky130_fd_sc_hd__buf_1
XFILLER_14_290 VGND VGND VPWR VPWR sky130_fd_sc_hd__decap_3
Xrebuffer509 _4516_/X VGND VGND VPWR VPWR _5063_/A2 sky130_fd_sc_hd__buf_2
XFILLER_30_772 VGND VGND VPWR VPWR sky130_fd_sc_hd__decap_3
X_4663_ _4663_/A VGND VGND VPWR VPWR _9080_/D sky130_fd_sc_hd__buf_1
X_7451_ _7450_/A _7450_/B _7569_/A _8161_/B VGND VGND VPWR VPWR _7576_/B sky130_fd_sc_hd__a211o_2
XFILLER_119_137 VGND VGND VPWR VPWR sky130_fd_sc_hd__fill_2
XFILLER_119_159 VGND VGND VPWR VPWR sky130_fd_sc_hd__decap_3
X_6402_ _5950_/B _5095_/X _5538_/X _6401_/X _5221_/A VGND VGND VPWR VPWR _6402_/X
+ sky130_fd_sc_hd__o311a_2
XFILLER_128_660 VGND VGND VPWR VPWR sky130_fd_sc_hd__decap_3
X_4594_ _9048_/Q hold972/X _4608_/S VGND VGND VPWR VPWR _4594_/X sky130_fd_sc_hd__mux2_2
X_7382_ _7496_/B _7382_/B VGND VGND VPWR VPWR _7382_/Y sky130_fd_sc_hd__nor2_2
Xhold902 _9141_/Q VGND VGND VPWR VPWR hold902/X sky130_fd_sc_hd__dlygate4sd3_1
Xhold913 _8991_/X VGND VGND VPWR VPWR _8992_/A sky130_fd_sc_hd__dlygate4sd3_1
X_9121_ _9168_/CLK _9121_/D load_slew378/X VGND VGND VPWR VPWR _9121_/Q sky130_fd_sc_hd__dfrtp_2
XFILLER_128_693 VGND VGND VPWR VPWR sky130_fd_sc_hd__decap_3
X_6333_ _9047_/Q _4521_/X _6757_/C _5062_/X _9267_/Q VGND VGND VPWR VPWR _6345_/A
+ sky130_fd_sc_hd__a32o_2
Xhold924 _9108_/Q VGND VGND VPWR VPWR hold924/X sky130_fd_sc_hd__dlygate4sd3_1
XFILLER_127_181 VGND VGND VPWR VPWR sky130_fd_sc_hd__decap_3
Xhold935 _9072_/Q VGND VGND VPWR VPWR hold935/X sky130_fd_sc_hd__dlygate4sd3_1
Xhold946 _9066_/Q VGND VGND VPWR VPWR hold946/X sky130_fd_sc_hd__dlygate4sd3_1
XFILLER_89_706 VGND VGND VPWR VPWR sky130_fd_sc_hd__decap_3
XFILLER_115_343 VGND VGND VPWR VPWR sky130_fd_sc_hd__decap_3
Xhold957 _4656_/X VGND VGND VPWR VPWR _4657_/A sky130_fd_sc_hd__dlygate4sd3_1
Xhold968 _4562_/X VGND VGND VPWR VPWR _4563_/A sky130_fd_sc_hd__dlygate4sd3_1
X_6264_ _6519_/B _6519_/C VGND VGND VPWR VPWR _6265_/B sky130_fd_sc_hd__xor2_2
X_9052_ _9133_/CLK _9052_/D load_slew394/X VGND VGND VPWR VPWR _9052_/Q sky130_fd_sc_hd__dfrtp_2
Xhold979 _9113_/Q VGND VGND VPWR VPWR hold979/X sky130_fd_sc_hd__dlygate4sd3_1
XFILLER_103_538 VGND VGND VPWR VPWR sky130_fd_sc_hd__decap_3
X_5215_ _5162_/A _5162_/B _5212_/X _5214_/X VGND VGND VPWR VPWR _5216_/B sky130_fd_sc_hd__a211oi_2
X_8003_ _8006_/A _8002_/Y _8034_/A VGND VGND VPWR VPWR _8003_/X sky130_fd_sc_hd__o21a_2
XFILLER_130_324 VGND VGND VPWR VPWR sky130_fd_sc_hd__decap_3
X_6195_ _7313_/A _7313_/B _8066_/A VGND VGND VPWR VPWR _6197_/A sky130_fd_sc_hd__a21oi_2
XFILLER_130_346 VGND VGND VPWR VPWR sky130_fd_sc_hd__decap_3
XFILLER_69_452 VGND VGND VPWR VPWR sky130_fd_sc_hd__fill_2
XFILLER_130_368 VGND VGND VPWR VPWR sky130_fd_sc_hd__fill_2
X_5146_ _5146_/A _5146_/B VGND VGND VPWR VPWR _5147_/B sky130_fd_sc_hd__nor2_2
XFILLER_69_474 VGND VGND VPWR VPWR sky130_fd_sc_hd__decap_3
XFILLER_57_647 VGND VGND VPWR VPWR sky130_fd_sc_hd__decap_3
X_5077_ _7099_/B _5077_/B _9197_/Q VGND VGND VPWR VPWR _5078_/C sky130_fd_sc_hd__or3b_2
X_8905_ _8905_/A VGND VGND VPWR VPWR _9295_/D sky130_fd_sc_hd__buf_1
XFILLER_37_360 VGND VGND VPWR VPWR sky130_fd_sc_hd__decap_3
XTAP_TAPCELL_ROW_84_1412 VGND VPWR sky130_fd_sc_hd__tapvpwrvgnd_1
XFILLER_37_371 VGND VGND VPWR VPWR sky130_fd_sc_hd__decap_3
X_8836_ _8836_/A VGND VGND VPWR VPWR _9262_/D sky130_fd_sc_hd__buf_1
XFILLER_25_544 VGND VGND VPWR VPWR sky130_fd_sc_hd__decap_3
XFILLER_52_341 VGND VGND VPWR VPWR sky130_fd_sc_hd__decap_3
XFILLER_44_48 VGND VGND VPWR VPWR sky130_fd_sc_hd__decap_3
XFILLER_13_706 VGND VGND VPWR VPWR sky130_fd_sc_hd__decap_3
XFILLER_40_503 VGND VGND VPWR VPWR sky130_fd_sc_hd__decap_3
X_8767_ _8770_/B _8766_/X _8765_/B _8771_/B VGND VGND VPWR VPWR _8767_/X sky130_fd_sc_hd__a211o_2
X_5979_ _9206_/Q _7065_/B _5899_/B VGND VGND VPWR VPWR _5979_/Y sky130_fd_sc_hd__a21oi_2
XFILLER_40_536 VGND VGND VPWR VPWR sky130_fd_sc_hd__fill_2
XFILLER_100_32 VGND VGND VPWR VPWR sky130_fd_sc_hd__fill_1
XFILLER_12_238 VGND VGND VPWR VPWR sky130_fd_sc_hd__fill_1
X_7718_ _6798_/S _7212_/A _7717_/X VGND VGND VPWR VPWR _7719_/B sky130_fd_sc_hd__o21a_2
XFILLER_8_209 VGND VGND VPWR VPWR sky130_fd_sc_hd__fill_2
XFILLER_21_750 VGND VGND VPWR VPWR sky130_fd_sc_hd__decap_3
X_8698_ _9229_/Q _8656_/A _8695_/B _8697_/X VGND VGND VPWR VPWR _8699_/B sky130_fd_sc_hd__o31a_2
X_7649_ _7495_/B _7491_/X _7494_/B VGND VGND VPWR VPWR _7650_/B sky130_fd_sc_hd__o21a_2
XTAP_TAPCELL_ROW_10_417 VGND VPWR sky130_fd_sc_hd__tapvpwrvgnd_1
XFILLER_20_271 VGND VGND VPWR VPWR sky130_fd_sc_hd__decap_3
XFILLER_20_293 VGND VGND VPWR VPWR sky130_fd_sc_hd__decap_3
XFILLER_109_30 VGND VGND VPWR VPWR sky130_fd_sc_hd__decap_3
XFILLER_119_693 VGND VGND VPWR VPWR sky130_fd_sc_hd__decap_3
X_9319_ _9335_/CLK _9319_/D load_slew399/X VGND VGND VPWR VPWR _9319_/Q sky130_fd_sc_hd__dfrtp_2
XTAP_TAPCELL_ROW_95_1563 VGND VPWR sky130_fd_sc_hd__tapvpwrvgnd_1
XFILLER_69_12 VGND VGND VPWR VPWR sky130_fd_sc_hd__decap_3
XFILLER_107_3 VGND VGND VPWR VPWR sky130_fd_sc_hd__decap_3
XFILLER_106_365 VGND VGND VPWR VPWR sky130_fd_sc_hd__decap_3
XFILLER_0_610 VGND VGND VPWR VPWR sky130_fd_sc_hd__decap_3
XFILLER_121_313 VGND VGND VPWR VPWR sky130_fd_sc_hd__fill_2
XFILLER_79_238 VGND VGND VPWR VPWR sky130_fd_sc_hd__decap_3
XFILLER_121_335 VGND VGND VPWR VPWR sky130_fd_sc_hd__fill_1
XFILLER_0_632 VGND VGND VPWR VPWR sky130_fd_sc_hd__decap_3
XFILLER_121_346 VGND VGND VPWR VPWR sky130_fd_sc_hd__decap_3
XFILLER_88_750 VGND VGND VPWR VPWR sky130_fd_sc_hd__fill_1
XFILLER_0_654 VGND VGND VPWR VPWR sky130_fd_sc_hd__decap_3
XFILLER_125_51 VGND VGND VPWR VPWR sky130_fd_sc_hd__decap_3
XFILLER_0_676 VGND VGND VPWR VPWR sky130_fd_sc_hd__decap_3
XFILLER_88_772 VGND VGND VPWR VPWR sky130_fd_sc_hd__decap_3
XFILLER_75_400 VGND VGND VPWR VPWR sky130_fd_sc_hd__decap_3
XFILLER_125_84 VGND VGND VPWR VPWR sky130_fd_sc_hd__decap_3
XFILLER_75_422 VGND VGND VPWR VPWR sky130_fd_sc_hd__decap_3
XFILLER_48_636 VGND VGND VPWR VPWR sky130_fd_sc_hd__decap_3
XFILLER_48_658 VGND VGND VPWR VPWR sky130_fd_sc_hd__decap_3
XFILLER_75_444 VGND VGND VPWR VPWR sky130_fd_sc_hd__decap_3
XFILLER_47_135 VGND VGND VPWR VPWR sky130_fd_sc_hd__decap_3
XFILLER_63_617 VGND VGND VPWR VPWR sky130_fd_sc_hd__decap_3
XFILLER_75_488 VGND VGND VPWR VPWR sky130_fd_sc_hd__decap_3
XTAP_TAPCELL_ROW_18_528 VGND VPWR sky130_fd_sc_hd__tapvpwrvgnd_1
XFILLER_90_436 VGND VGND VPWR VPWR sky130_fd_sc_hd__decap_3
XFILLER_18_82 VGND VGND VPWR VPWR sky130_fd_sc_hd__fill_2
XFILLER_56_691 VGND VGND VPWR VPWR sky130_fd_sc_hd__decap_3
XFILLER_16_555 VGND VGND VPWR VPWR sky130_fd_sc_hd__fill_2
XFILLER_16_566 VGND VGND VPWR VPWR sky130_fd_sc_hd__fill_1
XFILLER_71_683 VGND VGND VPWR VPWR sky130_fd_sc_hd__decap_3
XTAP_TAPCELL_ROW_104_1681 VGND VPWR sky130_fd_sc_hd__tapvpwrvgnd_1
XTAP_TAPCELL_ROW_104_1692 VGND VPWR sky130_fd_sc_hd__tapvpwrvgnd_1
XFILLER_34_81 VGND VGND VPWR VPWR sky130_fd_sc_hd__decap_3
XFILLER_129_402 VGND VGND VPWR VPWR sky130_fd_sc_hd__fill_2
XFILLER_8_710 VGND VGND VPWR VPWR sky130_fd_sc_hd__decap_3
XFILLER_12_772 VGND VGND VPWR VPWR sky130_fd_sc_hd__decap_3
XFILLER_8_743 VGND VGND VPWR VPWR sky130_fd_sc_hd__decap_3
XFILLER_7_220 VGND VGND VPWR VPWR sky130_fd_sc_hd__decap_3
XFILLER_7_231 VGND VGND VPWR VPWR sky130_fd_sc_hd__fill_1
XFILLER_11_293 VGND VGND VPWR VPWR sky130_fd_sc_hd__decap_3
Xwire151 _5742_/Y VGND VGND VPWR VPWR wire151/X sky130_fd_sc_hd__buf_6
XFILLER_7_242 VGND VGND VPWR VPWR sky130_fd_sc_hd__decap_3
XFILLER_116_118 VGND VGND VPWR VPWR sky130_fd_sc_hd__decap_3
XTAP_TAPCELL_ROW_55_1024 VGND VPWR sky130_fd_sc_hd__tapvpwrvgnd_1
XFILLER_124_162 VGND VGND VPWR VPWR sky130_fd_sc_hd__decap_3
XFILLER_124_195 VGND VGND VPWR VPWR sky130_fd_sc_hd__fill_1
XFILLER_79_750 VGND VGND VPWR VPWR sky130_fd_sc_hd__decap_3
XFILLER_112_357 VGND VGND VPWR VPWR sky130_fd_sc_hd__fill_2
X_5000_ _9319_/Q _4992_/X _5742_/D _4997_/X _4994_/X VGND VGND VPWR VPWR _5103_/C
+ sky130_fd_sc_hd__a2111o_2
Xload_slew145 wire146/X VGND VGND VPWR VPWR _5999_/A sky130_fd_sc_hd__buf_8
XFILLER_100_519 VGND VGND VPWR VPWR sky130_fd_sc_hd__decap_3
XFILLER_66_400 VGND VGND VPWR VPWR sky130_fd_sc_hd__decap_3
XFILLER_22_3 VGND VGND VPWR VPWR sky130_fd_sc_hd__decap_3
XFILLER_66_411 VGND VGND VPWR VPWR sky130_fd_sc_hd__fill_1
XFILLER_38_102 VGND VGND VPWR VPWR sky130_fd_sc_hd__decap_3
XFILLER_66_433 VGND VGND VPWR VPWR sky130_fd_sc_hd__decap_3
XFILLER_39_669 VGND VGND VPWR VPWR sky130_fd_sc_hd__decap_3
XFILLER_54_606 VGND VGND VPWR VPWR sky130_fd_sc_hd__decap_3
XFILLER_66_466 VGND VGND VPWR VPWR sky130_fd_sc_hd__decap_3
XFILLER_38_157 VGND VGND VPWR VPWR sky130_fd_sc_hd__fill_2
XFILLER_93_263 VGND VGND VPWR VPWR sky130_fd_sc_hd__decap_3
XFILLER_66_477 VGND VGND VPWR VPWR sky130_fd_sc_hd__decap_3
X_6951_ _7117_/A VGND VGND VPWR VPWR _6951_/X sky130_fd_sc_hd__clkbuf_1
XFILLER_54_639 VGND VGND VPWR VPWR sky130_fd_sc_hd__decap_3
XFILLER_53_116 VGND VGND VPWR VPWR sky130_fd_sc_hd__decap_3
XFILLER_19_393 VGND VGND VPWR VPWR sky130_fd_sc_hd__decap_3
X_5902_ _6061_/C _6143_/B VGND VGND VPWR VPWR _5902_/Y sky130_fd_sc_hd__nand2_2
X_6882_ _6882_/A _6882_/B VGND VGND VPWR VPWR wire91/A sky130_fd_sc_hd__xor2_2
XFILLER_62_661 VGND VGND VPWR VPWR sky130_fd_sc_hd__decap_3
X_8621_ _9227_/Q _8617_/X _8620_/X VGND VGND VPWR VPWR _8622_/B sky130_fd_sc_hd__a21o_2
XTAP_TAPCELL_ROW_66_1175 VGND VPWR sky130_fd_sc_hd__tapvpwrvgnd_1
X_5833_ _5833_/A _5833_/B VGND VGND VPWR VPWR _5834_/B sky130_fd_sc_hd__nand2_2
XFILLER_34_374 VGND VGND VPWR VPWR sky130_fd_sc_hd__decap_3
XFILLER_22_525 VGND VGND VPWR VPWR sky130_fd_sc_hd__decap_3
XFILLER_14_18 VGND VGND VPWR VPWR sky130_fd_sc_hd__decap_3
XTAP_TAPCELL_ROW_45_892 VGND VPWR sky130_fd_sc_hd__tapvpwrvgnd_1
XFILLER_22_536 VGND VGND VPWR VPWR sky130_fd_sc_hd__decap_3
XFILLER_22_547 VGND VGND VPWR VPWR sky130_fd_sc_hd__decap_3
XFILLER_14_29 VGND VGND VPWR VPWR sky130_fd_sc_hd__fill_2
X_8552_ _8547_/A _8547_/B _8549_/Y VGND VGND VPWR VPWR _8552_/X sky130_fd_sc_hd__o21a_2
X_5764_ _5822_/B _5764_/B VGND VGND VPWR VPWR _5911_/A sky130_fd_sc_hd__xnor2_2
X_7503_ _7565_/A _7565_/B VGND VGND VPWR VPWR _7507_/B sky130_fd_sc_hd__and2_2
X_4715_ _4715_/A VGND VGND VPWR VPWR _9105_/D sky130_fd_sc_hd__buf_1
X_8483_ _8421_/B _8481_/Y _8482_/X _8480_/Y VGND VGND VPWR VPWR _8483_/X sky130_fd_sc_hd__o2bb2a_2
X_5695_ _5695_/A _5695_/B VGND VGND VPWR VPWR _5863_/A sky130_fd_sc_hd__xnor2_2
XFILLER_108_619 VGND VGND VPWR VPWR sky130_fd_sc_hd__decap_3
X_7434_ _7434_/A _7434_/B _7434_/C VGND VGND VPWR VPWR _7436_/B sky130_fd_sc_hd__and3_4
X_4646_ _9073_/Q _4646_/A1 _4650_/S VGND VGND VPWR VPWR _4646_/X sky130_fd_sc_hd__mux2_2
X_4577_ hold865/X _4577_/A1 _4587_/S VGND VGND VPWR VPWR _4578_/A sky130_fd_sc_hd__mux2_2
X_7365_ _7365_/A _7365_/B VGND VGND VPWR VPWR _7369_/A sky130_fd_sc_hd__xnor2_2
X_9104_ clkload9/A _9104_/D load_slew368/X VGND VGND VPWR VPWR _9104_/Q sky130_fd_sc_hd__dfrtp_2
XFILLER_116_663 VGND VGND VPWR VPWR sky130_fd_sc_hd__decap_3
X_6316_ _7404_/B _8309_/A _6197_/B _6197_/A VGND VGND VPWR VPWR _6316_/X sky130_fd_sc_hd__a31o_2
Xhold754 _8787_/X VGND VGND VPWR VPWR _8788_/A sky130_fd_sc_hd__dlygate4sd3_1
XFILLER_1_407 VGND VGND VPWR VPWR sky130_fd_sc_hd__fill_1
Xhold765 _6483_/S VGND VGND VPWR VPWR hold765/X sky130_fd_sc_hd__dlygate4sd3_1
XFILLER_89_525 VGND VGND VPWR VPWR sky130_fd_sc_hd__fill_1
X_7296_ _7296_/A1 _7294_/X _7295_/X VGND VGND VPWR VPWR _7298_/A sky130_fd_sc_hd__a21o_2
Xhold776 _9179_/Q VGND VGND VPWR VPWR _9178_/D sky130_fd_sc_hd__dlygate4sd3_1
XFILLER_1_429 VGND VGND VPWR VPWR sky130_fd_sc_hd__decap_3
XFILLER_116_696 VGND VGND VPWR VPWR sky130_fd_sc_hd__decap_3
Xhold787 _9194_/Q VGND VGND VPWR VPWR hold787/X sky130_fd_sc_hd__dlygate4sd3_1
Xhold798 _4892_/X VGND VGND VPWR VPWR _9186_/D sky130_fd_sc_hd__dlygate4sd3_1
X_9035_ _9333_/CLK _9035_/D load_slew399/X VGND VGND VPWR VPWR _9035_/Q sky130_fd_sc_hd__dfrtp_2
XFILLER_103_346 VGND VGND VPWR VPWR sky130_fd_sc_hd__decap_3
X_6247_ _9208_/Q _6247_/B VGND VGND VPWR VPWR _6248_/B sky130_fd_sc_hd__xnor2_4
XFILLER_77_709 VGND VGND VPWR VPWR sky130_fd_sc_hd__decap_3
XFILLER_76_219 VGND VGND VPWR VPWR sky130_fd_sc_hd__decap_3
XFILLER_130_165 VGND VGND VPWR VPWR sky130_fd_sc_hd__decap_3
XTAP_TAPCELL_ROW_90_1493 VGND VPWR sky130_fd_sc_hd__tapvpwrvgnd_1
XFILLER_69_260 VGND VGND VPWR VPWR sky130_fd_sc_hd__decap_3
X_6178_ wire122/X _6546_/A2 _6939_/A VGND VGND VPWR VPWR _6180_/A sky130_fd_sc_hd__a21o_2
XFILLER_130_187 VGND VGND VPWR VPWR sky130_fd_sc_hd__decap_3
XFILLER_29_113 VGND VGND VPWR VPWR sky130_fd_sc_hd__fill_1
XFILLER_29_124 VGND VGND VPWR VPWR sky130_fd_sc_hd__decap_3
X_5129_ _9241_/Q _5873_/B _5127_/X _5128_/X VGND VGND VPWR VPWR _5129_/Y sky130_fd_sc_hd__a211oi_2
XFILLER_85_753 VGND VGND VPWR VPWR sky130_fd_sc_hd__decap_3
XFILLER_57_455 VGND VGND VPWR VPWR sky130_fd_sc_hd__decap_3
XFILLER_85_775 VGND VGND VPWR VPWR sky130_fd_sc_hd__fill_2
XFILLER_45_606 VGND VGND VPWR VPWR sky130_fd_sc_hd__decap_3
XFILLER_29_157 VGND VGND VPWR VPWR sky130_fd_sc_hd__decap_3
XFILLER_55_25 VGND VGND VPWR VPWR sky130_fd_sc_hd__decap_3
XFILLER_45_617 VGND VGND VPWR VPWR sky130_fd_sc_hd__decap_3
XFILLER_57_488 VGND VGND VPWR VPWR sky130_fd_sc_hd__fill_2
XFILLER_84_285 VGND VGND VPWR VPWR sky130_fd_sc_hd__decap_3
XFILLER_72_458 VGND VGND VPWR VPWR sky130_fd_sc_hd__decap_3
XFILLER_111_42 VGND VGND VPWR VPWR sky130_fd_sc_hd__decap_3
X_8819_ _8819_/A VGND VGND VPWR VPWR _9254_/D sky130_fd_sc_hd__buf_1
XFILLER_53_683 VGND VGND VPWR VPWR sky130_fd_sc_hd__decap_3
XFILLER_52_160 VGND VGND VPWR VPWR sky130_fd_sc_hd__decap_3
XFILLER_25_374 VGND VGND VPWR VPWR sky130_fd_sc_hd__decap_3
XFILLER_13_514 VGND VGND VPWR VPWR sky130_fd_sc_hd__decap_3
XFILLER_25_385 VGND VGND VPWR VPWR sky130_fd_sc_hd__decap_3
XFILLER_71_24 VGND VGND VPWR VPWR sky130_fd_sc_hd__fill_1
XFILLER_80_491 VGND VGND VPWR VPWR sky130_fd_sc_hd__decap_3
XTAP_TAPCELL_ROW_23_586 VGND VPWR sky130_fd_sc_hd__tapvpwrvgnd_1
XTAP_TAPCELL_ROW_23_597 VGND VPWR sky130_fd_sc_hd__tapvpwrvgnd_1
XFILLER_5_724 VGND VGND VPWR VPWR sky130_fd_sc_hd__decap_3
XFILLER_5_735 VGND VGND VPWR VPWR sky130_fd_sc_hd__decap_3
XFILLER_119_490 VGND VGND VPWR VPWR sky130_fd_sc_hd__decap_3
XFILLER_5_768 VGND VGND VPWR VPWR sky130_fd_sc_hd__fill_1
XFILLER_107_663 VGND VGND VPWR VPWR sky130_fd_sc_hd__decap_3
XFILLER_4_256 VGND VGND VPWR VPWR sky130_fd_sc_hd__decap_3
XFILLER_20_50 VGND VGND VPWR VPWR sky130_fd_sc_hd__decap_3
XFILLER_106_173 VGND VGND VPWR VPWR sky130_fd_sc_hd__fill_1
XFILLER_106_195 VGND VGND VPWR VPWR sky130_fd_sc_hd__fill_1
XFILLER_96_32 VGND VGND VPWR VPWR sky130_fd_sc_hd__fill_2
XFILLER_122_666 VGND VGND VPWR VPWR sky130_fd_sc_hd__decap_3
XFILLER_121_143 VGND VGND VPWR VPWR sky130_fd_sc_hd__decap_3
XFILLER_48_400 VGND VGND VPWR VPWR sky130_fd_sc_hd__fill_1
XFILLER_122_699 VGND VGND VPWR VPWR sky130_fd_sc_hd__fill_1
XFILLER_121_187 VGND VGND VPWR VPWR sky130_fd_sc_hd__decap_3
XFILLER_76_742 VGND VGND VPWR VPWR sky130_fd_sc_hd__decap_3
XFILLER_76_775 VGND VGND VPWR VPWR sky130_fd_sc_hd__fill_2
XFILLER_48_477 VGND VGND VPWR VPWR sky130_fd_sc_hd__fill_2
XFILLER_36_617 VGND VGND VPWR VPWR sky130_fd_sc_hd__decap_3
XFILLER_48_499 VGND VGND VPWR VPWR sky130_fd_sc_hd__decap_3
XTAP_TAPCELL_ROW_106_1710 VGND VPWR sky130_fd_sc_hd__tapvpwrvgnd_1
XFILLER_63_436 VGND VGND VPWR VPWR sky130_fd_sc_hd__fill_2
XFILLER_16_330 VGND VGND VPWR VPWR sky130_fd_sc_hd__decap_3
XFILLER_16_363 VGND VGND VPWR VPWR sky130_fd_sc_hd__fill_1
XFILLER_31_311 VGND VGND VPWR VPWR sky130_fd_sc_hd__fill_1
XFILLER_91_6 VGND VGND VPWR VPWR sky130_fd_sc_hd__decap_3
XTAP_TAPCELL_ROW_42_851 VGND VPWR sky130_fd_sc_hd__tapvpwrvgnd_1
XFILLER_31_366 VGND VGND VPWR VPWR sky130_fd_sc_hd__decap_3
XFILLER_31_388 VGND VGND VPWR VPWR sky130_fd_sc_hd__decap_3
XFILLER_129_243 VGND VGND VPWR VPWR sky130_fd_sc_hd__fill_1
XFILLER_8_551 VGND VGND VPWR VPWR sky130_fd_sc_hd__decap_3
X_5480_ _5633_/A _5480_/B VGND VGND VPWR VPWR _5481_/B sky130_fd_sc_hd__nor2_2
XFILLER_117_427 VGND VGND VPWR VPWR sky130_fd_sc_hd__decap_3
XANTENNA_1 _5438_/B VGND VGND VPWR VPWR sky130_fd_sc_hd__diode_2
XFILLER_6_41 VGND VGND VPWR VPWR sky130_fd_sc_hd__decap_3
XTAP_TAPCELL_ROW_117_1861 VGND VPWR sky130_fd_sc_hd__tapvpwrvgnd_1
XFILLER_6_85 VGND VGND VPWR VPWR sky130_fd_sc_hd__fill_1
X_7150_ _7150_/A _7150_/B VGND VGND VPWR VPWR _7150_/X sky130_fd_sc_hd__or2_2
XFILLER_125_493 VGND VGND VPWR VPWR sky130_fd_sc_hd__decap_3
X_6101_ _6482_/A _6446_/A VGND VGND VPWR VPWR _7244_/B sky130_fd_sc_hd__nand2_2
X_7081_ _7081_/A _7094_/B _7081_/C VGND VGND VPWR VPWR _7090_/C sky130_fd_sc_hd__nand3_2
XFILLER_98_344 VGND VGND VPWR VPWR sky130_fd_sc_hd__decap_3
XFILLER_59_709 VGND VGND VPWR VPWR sky130_fd_sc_hd__decap_3
XFILLER_113_655 VGND VGND VPWR VPWR sky130_fd_sc_hd__decap_3
XFILLER_86_517 VGND VGND VPWR VPWR sky130_fd_sc_hd__decap_3
XFILLER_98_377 VGND VGND VPWR VPWR sky130_fd_sc_hd__decap_3
XFILLER_113_688 VGND VGND VPWR VPWR sky130_fd_sc_hd__decap_3
X_6032_ _6160_/A1 _8313_/A _5855_/B _5011_/X VGND VGND VPWR VPWR _6038_/A sky130_fd_sc_hd__a211o_2
XFILLER_86_539 VGND VGND VPWR VPWR sky130_fd_sc_hd__fill_1
XFILLER_79_591 VGND VGND VPWR VPWR sky130_fd_sc_hd__decap_3
XFILLER_94_550 VGND VGND VPWR VPWR sky130_fd_sc_hd__decap_3
XFILLER_27_606 VGND VGND VPWR VPWR sky130_fd_sc_hd__decap_3
XFILLER_82_701 VGND VGND VPWR VPWR sky130_fd_sc_hd__decap_3
XFILLER_39_466 VGND VGND VPWR VPWR sky130_fd_sc_hd__decap_3
XTAP_TAPCELL_ROW_68_1204 VGND VPWR sky130_fd_sc_hd__tapvpwrvgnd_1
XFILLER_27_617 VGND VGND VPWR VPWR sky130_fd_sc_hd__decap_3
X_7983_ _7983_/A _7983_/B VGND VGND VPWR VPWR _7984_/B sky130_fd_sc_hd__xnor2_2
XFILLER_66_296 VGND VGND VPWR VPWR sky130_fd_sc_hd__decap_3
XFILLER_54_436 VGND VGND VPWR VPWR sky130_fd_sc_hd__decap_3
XFILLER_54_458 VGND VGND VPWR VPWR sky130_fd_sc_hd__decap_3
X_6934_ _7480_/C _6934_/B VGND VGND VPWR VPWR _6934_/X sky130_fd_sc_hd__and2_2
XFILLER_41_119 VGND VGND VPWR VPWR sky130_fd_sc_hd__decap_3
X_6865_ _6865_/A VGND VGND VPWR VPWR _6865_/Y sky130_fd_sc_hd__inv_2
XFILLER_62_480 VGND VGND VPWR VPWR sky130_fd_sc_hd__decap_3
XFILLER_22_333 VGND VGND VPWR VPWR sky130_fd_sc_hd__decap_3
X_8604_ _8642_/A _8604_/B VGND VGND VPWR VPWR _8632_/A sky130_fd_sc_hd__xnor2_2
XFILLER_34_193 VGND VGND VPWR VPWR sky130_fd_sc_hd__decap_3
X_5816_ _5816_/A _5816_/B VGND VGND VPWR VPWR _5816_/X sky130_fd_sc_hd__or2_4
XFILLER_22_344 VGND VGND VPWR VPWR sky130_fd_sc_hd__decap_3
XFILLER_50_664 VGND VGND VPWR VPWR sky130_fd_sc_hd__decap_3
X_6796_ _7656_/A _8011_/B VGND VGND VPWR VPWR _7212_/A sky130_fd_sc_hd__nor2_2
XFILLER_10_517 VGND VGND VPWR VPWR sky130_fd_sc_hd__decap_3
X_8535_ _8557_/B _8535_/B VGND VGND VPWR VPWR _8554_/B sky130_fd_sc_hd__xnor2_2
XFILLER_41_27 VGND VGND VPWR VPWR sky130_fd_sc_hd__decap_3
X_5747_ _9204_/Q _7773_/A VGND VGND VPWR VPWR _5749_/B sky130_fd_sc_hd__nand2_2
XFILLER_22_399 VGND VGND VPWR VPWR sky130_fd_sc_hd__decap_3
XFILLER_108_405 VGND VGND VPWR VPWR sky130_fd_sc_hd__decap_3
XTAP_TAPCELL_ROW_20_545 VGND VPWR sky130_fd_sc_hd__tapvpwrvgnd_1
XTAP_TAPCELL_ROW_20_556 VGND VPWR sky130_fd_sc_hd__tapvpwrvgnd_1
X_8466_ _8446_/A _8447_/X _8465_/X VGND VGND VPWR VPWR _8467_/B sky130_fd_sc_hd__a21oi_2
X_5678_ _5676_/X _5677_/X _6808_/S _7227_/B1 VGND VGND VPWR VPWR _5678_/X sky130_fd_sc_hd__o211a_2
XTAP_TAPCELL_ROW_79_1344 VGND VPWR sky130_fd_sc_hd__tapvpwrvgnd_1
X_7417_ _7417_/A _7417_/B VGND VGND VPWR VPWR _7418_/B sky130_fd_sc_hd__nand2_2
X_4629_ hold939/X _4629_/A1 _4629_/S VGND VGND VPWR VPWR _4630_/A sky130_fd_sc_hd__mux2_2
X_8397_ _8397_/A _8397_/B VGND VGND VPWR VPWR _8397_/Y sky130_fd_sc_hd__xnor2_2
XFILLER_123_419 VGND VGND VPWR VPWR sky130_fd_sc_hd__decap_3
XFILLER_104_600 VGND VGND VPWR VPWR sky130_fd_sc_hd__decap_3
XTAP_TAPCELL_ROW_92_1522 VGND VPWR sky130_fd_sc_hd__tapvpwrvgnd_1
XFILLER_2_716 VGND VGND VPWR VPWR sky130_fd_sc_hd__decap_3
XFILLER_116_460 VGND VGND VPWR VPWR sky130_fd_sc_hd__decap_3
X_7348_ _7635_/A _7347_/C _7462_/A VGND VGND VPWR VPWR _7469_/C sky130_fd_sc_hd__a21o_2
XFILLER_2_749 VGND VGND VPWR VPWR sky130_fd_sc_hd__decap_3
XFILLER_89_344 VGND VGND VPWR VPWR sky130_fd_sc_hd__decap_3
X_7279_ _7279_/A _7279_/B _7279_/C VGND VGND VPWR VPWR _7280_/C sky130_fd_sc_hd__nand3_2
XFILLER_89_366 VGND VGND VPWR VPWR sky130_fd_sc_hd__fill_2
X_9018_ _9333_/CLK _9018_/D load_slew399/X VGND VGND VPWR VPWR _9018_/Q sky130_fd_sc_hd__dfrtp_2
XFILLER_104_699 VGND VGND VPWR VPWR sky130_fd_sc_hd__fill_1
XFILLER_77_539 VGND VGND VPWR VPWR sky130_fd_sc_hd__fill_1
XFILLER_58_753 VGND VGND VPWR VPWR sky130_fd_sc_hd__decap_3
XFILLER_58_764 VGND VGND VPWR VPWR sky130_fd_sc_hd__decap_3
XFILLER_57_241 VGND VGND VPWR VPWR sky130_fd_sc_hd__fill_1
Xhold1240 _7794_/A VGND VGND VPWR VPWR _8777_/A sky130_fd_sc_hd__dlygate4sd3_1
XFILLER_85_561 VGND VGND VPWR VPWR sky130_fd_sc_hd__decap_3
Xhold1251 _9217_/Q VGND VGND VPWR VPWR _7751_/A0 sky130_fd_sc_hd__dlygate4sd3_1
XFILLER_18_617 VGND VGND VPWR VPWR sky130_fd_sc_hd__decap_3
XFILLER_72_200 VGND VGND VPWR VPWR sky130_fd_sc_hd__decap_3
XFILLER_122_41 VGND VGND VPWR VPWR sky130_fd_sc_hd__decap_3
XFILLER_73_756 VGND VGND VPWR VPWR sky130_fd_sc_hd__decap_3
XTAP_TAPCELL_ROW_28_656 VGND VPWR sky130_fd_sc_hd__tapvpwrvgnd_1
XFILLER_82_12 VGND VGND VPWR VPWR sky130_fd_sc_hd__fill_1
XFILLER_122_74 VGND VGND VPWR VPWR sky130_fd_sc_hd__decap_3
XFILLER_122_85 VGND VGND VPWR VPWR sky130_fd_sc_hd__decap_3
XFILLER_72_277 VGND VGND VPWR VPWR sky130_fd_sc_hd__decap_3
XFILLER_60_417 VGND VGND VPWR VPWR sky130_fd_sc_hd__decap_3
XTAP_TAPCELL_ROW_0_270 VGND VPWR sky130_fd_sc_hd__tapvpwrvgnd_1
XFILLER_26_672 VGND VGND VPWR VPWR sky130_fd_sc_hd__decap_3
XTAP_TAPCELL_ROW_0_281 VGND VPWR sky130_fd_sc_hd__tapvpwrvgnd_1
XFILLER_13_300 VGND VGND VPWR VPWR sky130_fd_sc_hd__decap_3
XFILLER_53_491 VGND VGND VPWR VPWR sky130_fd_sc_hd__decap_3
XFILLER_25_193 VGND VGND VPWR VPWR sky130_fd_sc_hd__decap_3
XFILLER_15_72 VGND VGND VPWR VPWR sky130_fd_sc_hd__decap_3
XTAP_TAPCELL_ROW_101_1640 VGND VPWR sky130_fd_sc_hd__tapvpwrvgnd_1
XFILLER_13_366 VGND VGND VPWR VPWR sky130_fd_sc_hd__decap_3
XTAP_TAPCELL_ROW_101_1651 VGND VPWR sky130_fd_sc_hd__tapvpwrvgnd_1
XFILLER_40_163 VGND VGND VPWR VPWR sky130_fd_sc_hd__decap_3
XFILLER_41_697 VGND VGND VPWR VPWR sky130_fd_sc_hd__decap_3
XFILLER_127_703 VGND VGND VPWR VPWR sky130_fd_sc_hd__decap_3
XFILLER_127_747 VGND VGND VPWR VPWR sky130_fd_sc_hd__decap_3
XFILLER_5_521 VGND VGND VPWR VPWR sky130_fd_sc_hd__decap_3
XFILLER_126_224 VGND VGND VPWR VPWR sky130_fd_sc_hd__decap_3
Xrebuffer681 _6111_/X VGND VGND VPWR VPWR _7181_/B sky130_fd_sc_hd__buf_2
XTAP_TAPCELL_ROW_130_2036 VGND VPWR sky130_fd_sc_hd__tapvpwrvgnd_1
XFILLER_114_419 VGND VGND VPWR VPWR sky130_fd_sc_hd__fill_1
XTAP_TAPCELL_ROW_130_2047 VGND VPWR sky130_fd_sc_hd__tapvpwrvgnd_1
XPHY_EDGE_ROW_128_Right_128 VGND VGND VPWR VPWR sky130_fd_sc_hd__decap_3
XFILLER_122_441 VGND VGND VPWR VPWR sky130_fd_sc_hd__fill_2
XFILLER_122_474 VGND VGND VPWR VPWR sky130_fd_sc_hd__fill_2
XFILLER_68_539 VGND VGND VPWR VPWR sky130_fd_sc_hd__decap_3
XFILLER_1_771 VGND VGND VPWR VPWR sky130_fd_sc_hd__decap_3
XFILLER_110_625 VGND VGND VPWR VPWR sky130_fd_sc_hd__decap_3
XTAP_TAPCELL_ROW_8_392 VGND VPWR sky130_fd_sc_hd__tapvpwrvgnd_1
XTAP_TAPCELL_ROW_112_1791 VGND VPWR sky130_fd_sc_hd__tapvpwrvgnd_1
XFILLER_110_636 VGND VGND VPWR VPWR sky130_fd_sc_hd__decap_3
XFILLER_0_281 VGND VGND VPWR VPWR sky130_fd_sc_hd__decap_3
XFILLER_49_742 VGND VGND VPWR VPWR sky130_fd_sc_hd__decap_3
XFILLER_48_230 VGND VGND VPWR VPWR sky130_fd_sc_hd__decap_3
XFILLER_110_669 VGND VGND VPWR VPWR sky130_fd_sc_hd__decap_3
XFILLER_76_550 VGND VGND VPWR VPWR sky130_fd_sc_hd__decap_3
XFILLER_64_712 VGND VGND VPWR VPWR sky130_fd_sc_hd__decap_3
XTAP_TAPCELL_ROW_47_910 VGND VPWR sky130_fd_sc_hd__tapvpwrvgnd_1
XFILLER_76_583 VGND VGND VPWR VPWR sky130_fd_sc_hd__decap_3
XFILLER_36_414 VGND VGND VPWR VPWR sky130_fd_sc_hd__fill_1
XTAP_TAPCELL_ROW_47_921 VGND VPWR sky130_fd_sc_hd__tapvpwrvgnd_1
XFILLER_91_531 VGND VGND VPWR VPWR sky130_fd_sc_hd__decap_3
XFILLER_91_553 VGND VGND VPWR VPWR sky130_fd_sc_hd__decap_3
XFILLER_63_244 VGND VGND VPWR VPWR sky130_fd_sc_hd__decap_3
XFILLER_91_564 VGND VGND VPWR VPWR sky130_fd_sc_hd__decap_3
XFILLER_36_469 VGND VGND VPWR VPWR sky130_fd_sc_hd__decap_3
X_4980_ _6206_/A _5197_/A VGND VGND VPWR VPWR _4980_/X sky130_fd_sc_hd__or2_2
XFILLER_51_417 VGND VGND VPWR VPWR sky130_fd_sc_hd__fill_2
XFILLER_51_428 VGND VGND VPWR VPWR sky130_fd_sc_hd__decap_3
XTAP_TAPCELL_ROW_63_1134 VGND VPWR sky130_fd_sc_hd__tapvpwrvgnd_1
XFILLER_32_642 VGND VGND VPWR VPWR sky130_fd_sc_hd__fill_2
X_6650_ _6650_/A _6650_/B _6650_/C VGND VGND VPWR VPWR _6651_/B sky130_fd_sc_hd__or3_4
X_5601_ _5698_/A _7445_/A VGND VGND VPWR VPWR _5602_/B sky130_fd_sc_hd__nand2_2
X_6581_ _6581_/A _6581_/B VGND VGND VPWR VPWR _6582_/B sky130_fd_sc_hd__xnor2_2
XFILLER_31_185 VGND VGND VPWR VPWR sky130_fd_sc_hd__decap_3
X_8320_ _8320_/A _8320_/B VGND VGND VPWR VPWR _8416_/B sky130_fd_sc_hd__xnor2_2
X_5532_ _5094_/X _5498_/X _5649_/A _5531_/Y VGND VGND VPWR VPWR _9203_/D sky130_fd_sc_hd__a31o_2
XFILLER_118_725 VGND VGND VPWR VPWR sky130_fd_sc_hd__decap_3
XFILLER_117_235 VGND VGND VPWR VPWR sky130_fd_sc_hd__decap_3
X_8251_ _8251_/A _8245_/Y VGND VGND VPWR VPWR _8251_/X sky130_fd_sc_hd__or2b_2
XFILLER_8_392 VGND VGND VPWR VPWR sky130_fd_sc_hd__decap_3
XFILLER_118_769 VGND VGND VPWR VPWR sky130_fd_sc_hd__decap_3
X_5463_ _6232_/C _6231_/B _5463_/C _5611_/S VGND VGND VPWR VPWR _5463_/X sky130_fd_sc_hd__and4b_2
X_7202_ _8013_/A _7203_/B VGND VGND VPWR VPWR _7202_/X sky130_fd_sc_hd__or2_2
X_8182_ _8074_/A _8074_/B _8181_/X VGND VGND VPWR VPWR _8184_/B sky130_fd_sc_hd__o21a_2
XFILLER_99_620 VGND VGND VPWR VPWR sky130_fd_sc_hd__fill_1
X_5394_ _9202_/Q _5394_/B VGND VGND VPWR VPWR _5395_/B sky130_fd_sc_hd__xnor2_2
XFILLER_99_642 VGND VGND VPWR VPWR sky130_fd_sc_hd__decap_3
X_7133_ _7133_/A _7133_/B _7133_/C VGND VGND VPWR VPWR _7273_/A sky130_fd_sc_hd__and3_4
XTAP_TAPCELL_ROW_74_1274 VGND VPWR sky130_fd_sc_hd__tapvpwrvgnd_1
XFILLER_98_141 VGND VGND VPWR VPWR sky130_fd_sc_hd__decap_3
XFILLER_113_452 VGND VGND VPWR VPWR sky130_fd_sc_hd__decap_3
XFILLER_101_603 VGND VGND VPWR VPWR sky130_fd_sc_hd__decap_3
XTAP_TAPCELL_ROW_74_1285 VGND VPWR sky130_fd_sc_hd__tapvpwrvgnd_1
XFILLER_86_303 VGND VGND VPWR VPWR sky130_fd_sc_hd__decap_3
X_7064_ _7063_/B _7063_/C _7357_/B VGND VGND VPWR VPWR _7064_/Y sky130_fd_sc_hd__a21oi_2
XFILLER_98_185 VGND VGND VPWR VPWR sky130_fd_sc_hd__decap_3
XFILLER_86_347 VGND VGND VPWR VPWR sky130_fd_sc_hd__decap_3
XFILLER_101_669 VGND VGND VPWR VPWR sky130_fd_sc_hd__decap_3
X_6015_ _5840_/A _5841_/A _6014_/X VGND VGND VPWR VPWR _6190_/A sky130_fd_sc_hd__a21oi_2
XFILLER_39_241 VGND VGND VPWR VPWR sky130_fd_sc_hd__fill_2
XFILLER_67_561 VGND VGND VPWR VPWR sky130_fd_sc_hd__decap_3
XFILLER_55_712 VGND VGND VPWR VPWR sky130_fd_sc_hd__decap_3
XFILLER_27_403 VGND VGND VPWR VPWR sky130_fd_sc_hd__decap_3
XFILLER_39_274 VGND VGND VPWR VPWR sky130_fd_sc_hd__fill_2
XFILLER_94_380 VGND VGND VPWR VPWR sky130_fd_sc_hd__decap_3
XFILLER_36_27 VGND VGND VPWR VPWR sky130_fd_sc_hd__fill_1
XFILLER_36_38 VGND VGND VPWR VPWR sky130_fd_sc_hd__decap_3
XFILLER_82_542 VGND VGND VPWR VPWR sky130_fd_sc_hd__decap_3
XFILLER_54_244 VGND VGND VPWR VPWR sky130_fd_sc_hd__fill_2
X_7966_ _7790_/A _7789_/B _7789_/A VGND VGND VPWR VPWR _7966_/X sky130_fd_sc_hd__a21bo_2
XTAP_TAPCELL_ROW_25_615 VGND VPWR sky130_fd_sc_hd__tapvpwrvgnd_1
XFILLER_70_737 VGND VGND VPWR VPWR sky130_fd_sc_hd__decap_3
XFILLER_42_428 VGND VGND VPWR VPWR sky130_fd_sc_hd__decap_3
X_6917_ _6768_/A _6768_/B _6907_/A VGND VGND VPWR VPWR _6917_/X sky130_fd_sc_hd__o21a_2
XFILLER_23_620 VGND VGND VPWR VPWR sky130_fd_sc_hd__decap_3
X_7897_ _7897_/A _7897_/B VGND VGND VPWR VPWR _7897_/Y sky130_fd_sc_hd__xnor2_4
XFILLER_52_15 VGND VGND VPWR VPWR sky130_fd_sc_hd__decap_3
X_6848_ _6899_/A _6899_/B VGND VGND VPWR VPWR _6849_/B sky130_fd_sc_hd__xnor2_2
XFILLER_22_141 VGND VGND VPWR VPWR sky130_fd_sc_hd__decap_3
XFILLER_50_461 VGND VGND VPWR VPWR sky130_fd_sc_hd__decap_3
XFILLER_23_697 VGND VGND VPWR VPWR sky130_fd_sc_hd__decap_3
XFILLER_50_483 VGND VGND VPWR VPWR sky130_fd_sc_hd__fill_1
XFILLER_50_494 VGND VGND VPWR VPWR sky130_fd_sc_hd__fill_2
X_6779_ _6778_/B _6778_/C _6778_/A VGND VGND VPWR VPWR _6780_/B sky130_fd_sc_hd__a21oi_2
XFILLER_6_307 VGND VGND VPWR VPWR sky130_fd_sc_hd__fill_1
XFILLER_10_358 VGND VGND VPWR VPWR sky130_fd_sc_hd__decap_3
XFILLER_109_714 VGND VGND VPWR VPWR sky130_fd_sc_hd__decap_3
X_8518_ _8515_/X _8517_/X _8547_/A VGND VGND VPWR VPWR _8518_/X sky130_fd_sc_hd__mux2_2
XFILLER_6_318 VGND VGND VPWR VPWR sky130_fd_sc_hd__decap_3
X_8449_ _9221_/Q _8446_/A _8739_/B _8446_/Y _8448_/X VGND VGND VPWR VPWR _8449_/X
+ sky130_fd_sc_hd__o311a_2
XFILLER_124_728 VGND VGND VPWR VPWR sky130_fd_sc_hd__decap_3
XFILLER_123_205 VGND VGND VPWR VPWR sky130_fd_sc_hd__decap_3
XFILLER_2_524 VGND VGND VPWR VPWR sky130_fd_sc_hd__decap_3
XFILLER_117_30 VGND VGND VPWR VPWR sky130_fd_sc_hd__decap_3
XFILLER_77_12 VGND VGND VPWR VPWR sky130_fd_sc_hd__decap_3
XFILLER_117_63 VGND VGND VPWR VPWR sky130_fd_sc_hd__decap_3
XFILLER_104_474 VGND VGND VPWR VPWR sky130_fd_sc_hd__fill_2
XFILLER_117_96 VGND VGND VPWR VPWR sky130_fd_sc_hd__decap_3
XTAP_TAPCELL_ROW_5_351 VGND VPWR sky130_fd_sc_hd__tapvpwrvgnd_1
XFILLER_46_701 VGND VGND VPWR VPWR sky130_fd_sc_hd__decap_3
XFILLER_46_723 VGND VGND VPWR VPWR sky130_fd_sc_hd__decap_3
XFILLER_45_200 VGND VGND VPWR VPWR sky130_fd_sc_hd__decap_3
Xhold1070 _9287_/Q VGND VGND VPWR VPWR _8921_/A1 sky130_fd_sc_hd__dlygate4sd3_1
Xhold1081 _9310_/Q VGND VGND VPWR VPWR _8970_/A1 sky130_fd_sc_hd__dlygate4sd3_1
XFILLER_45_233 VGND VGND VPWR VPWR sky130_fd_sc_hd__decap_3
Xhold1092 _4769_/X VGND VGND VPWR VPWR _4770_/A sky130_fd_sc_hd__dlygate4sd3_1
XFILLER_18_458 VGND VGND VPWR VPWR sky130_fd_sc_hd__decap_3
XFILLER_73_564 VGND VGND VPWR VPWR sky130_fd_sc_hd__decap_3
XFILLER_45_277 VGND VGND VPWR VPWR sky130_fd_sc_hd__decap_3
XFILLER_33_428 VGND VGND VPWR VPWR sky130_fd_sc_hd__decap_3
XFILLER_26_480 VGND VGND VPWR VPWR sky130_fd_sc_hd__decap_3
XFILLER_14_631 VGND VGND VPWR VPWR sky130_fd_sc_hd__decap_3
XFILLER_60_247 VGND VGND VPWR VPWR sky130_fd_sc_hd__decap_3
XFILLER_60_269 VGND VGND VPWR VPWR sky130_fd_sc_hd__decap_3
XFILLER_13_141 VGND VGND VPWR VPWR sky130_fd_sc_hd__decap_3
XFILLER_13_163 VGND VGND VPWR VPWR sky130_fd_sc_hd__decap_3
XFILLER_41_483 VGND VGND VPWR VPWR sky130_fd_sc_hd__decap_3
XTAP_TAPCELL_ROW_52_990 VGND VPWR sky130_fd_sc_hd__tapvpwrvgnd_1
XFILLER_9_189 VGND VGND VPWR VPWR sky130_fd_sc_hd__decap_3
XFILLER_5_340 VGND VGND VPWR VPWR sky130_fd_sc_hd__decap_3
XFILLER_54_6 VGND VGND VPWR VPWR sky130_fd_sc_hd__fill_2
XTAP_TAPCELL_ROW_114_1820 VGND VPWR sky130_fd_sc_hd__tapvpwrvgnd_1
XFILLER_115_739 VGND VGND VPWR VPWR sky130_fd_sc_hd__decap_3
XFILLER_107_290 VGND VGND VPWR VPWR sky130_fd_sc_hd__decap_3
XFILLER_123_750 VGND VGND VPWR VPWR sky130_fd_sc_hd__decap_3
XFILLER_96_612 VGND VGND VPWR VPWR sky130_fd_sc_hd__fill_1
XFILLER_95_100 VGND VGND VPWR VPWR sky130_fd_sc_hd__fill_2
XFILLER_3_42 VGND VGND VPWR VPWR sky130_fd_sc_hd__decap_3
XFILLER_95_111 VGND VGND VPWR VPWR sky130_fd_sc_hd__fill_1
XFILLER_96_645 VGND VGND VPWR VPWR sky130_fd_sc_hd__decap_3
XFILLER_95_122 VGND VGND VPWR VPWR sky130_fd_sc_hd__decap_3
XFILLER_110_433 VGND VGND VPWR VPWR sky130_fd_sc_hd__decap_3
XFILLER_3_75 VGND VGND VPWR VPWR sky130_fd_sc_hd__decap_3
XFILLER_56_509 VGND VGND VPWR VPWR sky130_fd_sc_hd__decap_3
XFILLER_110_455 VGND VGND VPWR VPWR sky130_fd_sc_hd__decap_3
XFILLER_49_561 VGND VGND VPWR VPWR sky130_fd_sc_hd__decap_3
XFILLER_37_712 VGND VGND VPWR VPWR sky130_fd_sc_hd__decap_3
XFILLER_37_734 VGND VGND VPWR VPWR sky130_fd_sc_hd__decap_3
XFILLER_37_756 VGND VGND VPWR VPWR sky130_fd_sc_hd__decap_3
XFILLER_36_222 VGND VGND VPWR VPWR sky130_fd_sc_hd__fill_1
XFILLER_64_542 VGND VGND VPWR VPWR sky130_fd_sc_hd__decap_3
X_7820_ _7915_/B VGND VGND VPWR VPWR _8099_/C sky130_fd_sc_hd__clkbuf_1
XFILLER_36_244 VGND VGND VPWR VPWR sky130_fd_sc_hd__decap_3
XFILLER_52_704 VGND VGND VPWR VPWR sky130_fd_sc_hd__decap_3
Xwire48 wire48/A VGND VGND VPWR VPWR wire48/X sky130_fd_sc_hd__buf_6
XFILLER_24_406 VGND VGND VPWR VPWR sky130_fd_sc_hd__decap_3
XTAP_TAPCELL_ROW_125_1971 VGND VPWR sky130_fd_sc_hd__tapvpwrvgnd_1
X_7751_ _7751_/A0 wire39/X _8045_/S VGND VGND VPWR VPWR _7751_/X sky130_fd_sc_hd__mux2_2
X_4963_ _4974_/A _4974_/B _5743_/B _4974_/D _4975_/B VGND VGND VPWR VPWR _6953_/A
+ sky130_fd_sc_hd__a41o_4
XFILLER_51_236 VGND VGND VPWR VPWR sky130_fd_sc_hd__decap_3
XFILLER_17_480 VGND VGND VPWR VPWR sky130_fd_sc_hd__decap_3
X_6702_ _6701_/B _6701_/C _6924_/A VGND VGND VPWR VPWR _6912_/B sky130_fd_sc_hd__a21o_4
X_7682_ _7682_/A _7682_/B VGND VGND VPWR VPWR _8037_/A sky130_fd_sc_hd__xnor2_2
X_4894_ _4876_/X _4893_/Y _4878_/X hold782/X VGND VGND VPWR VPWR _4894_/X sky130_fd_sc_hd__a2bb2o_2
XFILLER_60_770 VGND VGND VPWR VPWR sky130_fd_sc_hd__decap_3
XFILLER_20_601 VGND VGND VPWR VPWR sky130_fd_sc_hd__fill_2
XFILLER_32_483 VGND VGND VPWR VPWR sky130_fd_sc_hd__decap_3
XFILLER_20_623 VGND VGND VPWR VPWR sky130_fd_sc_hd__decap_3
X_6633_ _5633_/A _8410_/S _9209_/Q VGND VGND VPWR VPWR _6633_/Y sky130_fd_sc_hd__o21ai_2
XFILLER_22_18 VGND VGND VPWR VPWR sky130_fd_sc_hd__decap_3
XFILLER_20_645 VGND VGND VPWR VPWR sky130_fd_sc_hd__decap_3
XFILLER_22_29 VGND VGND VPWR VPWR sky130_fd_sc_hd__fill_2
XFILLER_20_678 VGND VGND VPWR VPWR sky130_fd_sc_hd__decap_3
X_6564_ _6669_/B _6564_/B _6668_/B VGND VGND VPWR VPWR _6564_/X sky130_fd_sc_hd__and3_2
X_8303_ _8304_/B _8304_/A_N VGND VGND VPWR VPWR _8303_/X sky130_fd_sc_hd__or2b_2
XTAP_TAPCELL_ROW_30_684 VGND VPWR sky130_fd_sc_hd__tapvpwrvgnd_1
XFILLER_118_544 VGND VGND VPWR VPWR sky130_fd_sc_hd__decap_3
X_5515_ _4970_/X _6416_/B _5514_/Y VGND VGND VPWR VPWR _5516_/B sky130_fd_sc_hd__a21oi_2
XTAP_TAPCELL_ROW_76_1303 VGND VPWR sky130_fd_sc_hd__tapvpwrvgnd_1
X_9283_ _9331_/CLK _9283_/D fanout389/X VGND VGND VPWR VPWR _9283_/Q sky130_fd_sc_hd__dfrtp_2
XTAP_TAPCELL_ROW_76_1314 VGND VPWR sky130_fd_sc_hd__tapvpwrvgnd_1
X_6495_ _6495_/A _6495_/B VGND VGND VPWR VPWR _6506_/B sky130_fd_sc_hd__xnor2_4
XFILLER_106_739 VGND VGND VPWR VPWR sky130_fd_sc_hd__decap_3
X_8234_ _8149_/A _8228_/X _8229_/X _8230_/Y _8233_/X VGND VGND VPWR VPWR _8234_/X
+ sky130_fd_sc_hd__a41o_2
X_5446_ _5446_/A _5446_/B VGND VGND VPWR VPWR _5446_/X sky130_fd_sc_hd__or2_2
X_8165_ _8315_/A _8165_/B _8165_/C VGND VGND VPWR VPWR _8167_/B sky130_fd_sc_hd__and3_2
XFILLER_114_750 VGND VGND VPWR VPWR sky130_fd_sc_hd__decap_3
X_5377_ _9260_/Q _5062_/X _5002_/X _9340_/Q _5376_/X VGND VGND VPWR VPWR _5689_/B
+ sky130_fd_sc_hd__a221oi_2
XFILLER_99_461 VGND VGND VPWR VPWR sky130_fd_sc_hd__fill_2
X_7116_ _8309_/B _7114_/X _9212_/Q _8345_/A VGND VGND VPWR VPWR _7116_/X sky130_fd_sc_hd__a211o_2
XFILLER_87_623 VGND VGND VPWR VPWR sky130_fd_sc_hd__decap_3
XFILLER_86_100 VGND VGND VPWR VPWR sky130_fd_sc_hd__decap_3
X_8096_ _7979_/A _7979_/B _8095_/X VGND VGND VPWR VPWR _8108_/A sky130_fd_sc_hd__a21o_2
X_7047_ _7047_/A _7047_/B VGND VGND VPWR VPWR _7303_/B sky130_fd_sc_hd__xnor2_4
XFILLER_59_369 VGND VGND VPWR VPWR sky130_fd_sc_hd__decap_3
XFILLER_87_689 VGND VGND VPWR VPWR sky130_fd_sc_hd__fill_2
XFILLER_28_701 VGND VGND VPWR VPWR sky130_fd_sc_hd__fill_1
XTAP_TAPCELL_ROW_2_310 VGND VPWR sky130_fd_sc_hd__tapvpwrvgnd_1
XFILLER_86_177 VGND VGND VPWR VPWR sky130_fd_sc_hd__decap_3
XFILLER_28_723 VGND VGND VPWR VPWR sky130_fd_sc_hd__decap_3
XFILLER_27_200 VGND VGND VPWR VPWR sky130_fd_sc_hd__decap_3
XTAP_TAPCELL_ROW_87_1454 VGND VPWR sky130_fd_sc_hd__tapvpwrvgnd_1
XFILLER_55_564 VGND VGND VPWR VPWR sky130_fd_sc_hd__decap_3
XFILLER_103_54 VGND VGND VPWR VPWR sky130_fd_sc_hd__fill_2
X_8998_ _8998_/A VGND VGND VPWR VPWR _9339_/D sky130_fd_sc_hd__buf_1
XFILLER_82_372 VGND VGND VPWR VPWR sky130_fd_sc_hd__decap_3
XTAP_TAPCELL_ROW_38_795 VGND VPWR sky130_fd_sc_hd__tapvpwrvgnd_1
XFILLER_82_383 VGND VGND VPWR VPWR sky130_fd_sc_hd__fill_1
X_7949_ _7949_/A _7949_/B VGND VGND VPWR VPWR _7964_/A sky130_fd_sc_hd__xor2_2
XFILLER_82_394 VGND VGND VPWR VPWR sky130_fd_sc_hd__decap_3
XFILLER_42_236 VGND VGND VPWR VPWR sky130_fd_sc_hd__decap_3
XFILLER_42_269 VGND VGND VPWR VPWR sky130_fd_sc_hd__decap_3
XFILLER_30_409 VGND VGND VPWR VPWR sky130_fd_sc_hd__decap_3
XFILLER_7_605 VGND VGND VPWR VPWR sky130_fd_sc_hd__decap_3
XFILLER_11_667 VGND VGND VPWR VPWR sky130_fd_sc_hd__decap_3
XFILLER_10_144 VGND VGND VPWR VPWR sky130_fd_sc_hd__decap_3
XFILLER_109_522 VGND VGND VPWR VPWR sky130_fd_sc_hd__decap_3
XFILLER_6_126 VGND VGND VPWR VPWR sky130_fd_sc_hd__decap_3
XFILLER_12_51 VGND VGND VPWR VPWR sky130_fd_sc_hd__fill_2
XFILLER_6_159 VGND VGND VPWR VPWR sky130_fd_sc_hd__decap_3
XFILLER_128_62 VGND VGND VPWR VPWR sky130_fd_sc_hd__decap_3
XFILLER_109_599 VGND VGND VPWR VPWR sky130_fd_sc_hd__fill_1
XFILLER_2_321 VGND VGND VPWR VPWR sky130_fd_sc_hd__decap_3
XFILLER_2_365 VGND VGND VPWR VPWR sky130_fd_sc_hd__decap_3
XFILLER_88_99 VGND VGND VPWR VPWR sky130_fd_sc_hd__fill_1
XFILLER_104_271 VGND VGND VPWR VPWR sky130_fd_sc_hd__decap_3
XFILLER_77_111 VGND VGND VPWR VPWR sky130_fd_sc_hd__fill_1
XFILLER_120_731 VGND VGND VPWR VPWR sky130_fd_sc_hd__decap_3
XFILLER_78_645 VGND VGND VPWR VPWR sky130_fd_sc_hd__decap_3
XFILLER_77_122 VGND VGND VPWR VPWR sky130_fd_sc_hd__decap_3
XFILLER_120_775 VGND VGND VPWR VPWR sky130_fd_sc_hd__fill_2
XFILLER_19_701 VGND VGND VPWR VPWR sky130_fd_sc_hd__decap_3
XFILLER_19_9 VGND VGND VPWR VPWR sky130_fd_sc_hd__decap_3
XFILLER_93_637 VGND VGND VPWR VPWR sky130_fd_sc_hd__fill_2
XFILLER_18_200 VGND VGND VPWR VPWR sky130_fd_sc_hd__decap_3
XFILLER_58_380 VGND VGND VPWR VPWR sky130_fd_sc_hd__decap_3
XFILLER_46_542 VGND VGND VPWR VPWR sky130_fd_sc_hd__fill_2
XFILLER_19_756 VGND VGND VPWR VPWR sky130_fd_sc_hd__decap_3
XFILLER_80_309 VGND VGND VPWR VPWR sky130_fd_sc_hd__decap_3
XFILLER_46_564 VGND VGND VPWR VPWR sky130_fd_sc_hd__decap_3
XFILLER_34_704 VGND VGND VPWR VPWR sky130_fd_sc_hd__decap_3
XFILLER_73_361 VGND VGND VPWR VPWR sky130_fd_sc_hd__fill_2
XFILLER_61_501 VGND VGND VPWR VPWR sky130_fd_sc_hd__decap_3
XFILLER_46_597 VGND VGND VPWR VPWR sky130_fd_sc_hd__fill_1
XFILLER_34_737 VGND VGND VPWR VPWR sky130_fd_sc_hd__fill_2
XFILLER_18_288 VGND VGND VPWR VPWR sky130_fd_sc_hd__fill_1
XFILLER_61_523 VGND VGND VPWR VPWR sky130_fd_sc_hd__decap_3
XFILLER_33_214 VGND VGND VPWR VPWR sky130_fd_sc_hd__fill_1
XFILLER_33_225 VGND VGND VPWR VPWR sky130_fd_sc_hd__decap_3
XFILLER_14_450 VGND VGND VPWR VPWR sky130_fd_sc_hd__decap_3
XFILLER_14_483 VGND VGND VPWR VPWR sky130_fd_sc_hd__decap_3
XFILLER_14_494 VGND VGND VPWR VPWR sky130_fd_sc_hd__decap_3
XFILLER_127_352 VGND VGND VPWR VPWR sky130_fd_sc_hd__decap_3
XFILLER_6_660 VGND VGND VPWR VPWR sky130_fd_sc_hd__decap_3
X_5300_ _5137_/X _5138_/X _5146_/B VGND VGND VPWR VPWR _5369_/A sky130_fd_sc_hd__a21oi_2
XFILLER_52_3 VGND VGND VPWR VPWR sky130_fd_sc_hd__decap_3
XFILLER_127_385 VGND VGND VPWR VPWR sky130_fd_sc_hd__decap_3
X_6280_ _8050_/A _6550_/B _7430_/A _5707_/B VGND VGND VPWR VPWR _6280_/X sky130_fd_sc_hd__o22a_2
XFILLER_127_396 VGND VGND VPWR VPWR sky130_fd_sc_hd__decap_3
XFILLER_6_693 VGND VGND VPWR VPWR sky130_fd_sc_hd__decap_3
XTAP_TAPCELL_ROW_58_1066 VGND VPWR sky130_fd_sc_hd__tapvpwrvgnd_1
X_5231_ _6434_/B _6415_/A VGND VGND VPWR VPWR _5231_/Y sky130_fd_sc_hd__nor2_2
XFILLER_88_409 VGND VGND VPWR VPWR sky130_fd_sc_hd__decap_3
XFILLER_102_208 VGND VGND VPWR VPWR sky130_fd_sc_hd__decap_3
XFILLER_69_612 VGND VGND VPWR VPWR sky130_fd_sc_hd__decap_3
XFILLER_130_517 VGND VGND VPWR VPWR sky130_fd_sc_hd__decap_3
XFILLER_69_623 VGND VGND VPWR VPWR sky130_fd_sc_hd__decap_3
X_5162_ _5162_/A _5162_/B VGND VGND VPWR VPWR _5163_/B sky130_fd_sc_hd__xnor2_2
XTAP_TAPCELL_ROW_71_1244 VGND VPWR sky130_fd_sc_hd__tapvpwrvgnd_1
XFILLER_69_667 VGND VGND VPWR VPWR sky130_fd_sc_hd__decap_3
XFILLER_68_144 VGND VGND VPWR VPWR sky130_fd_sc_hd__decap_3
X_5093_ _8117_/S VGND VGND VPWR VPWR _5093_/X sky130_fd_sc_hd__buf_2
XFILLER_84_604 VGND VGND VPWR VPWR sky130_fd_sc_hd__decap_3
XFILLER_83_103 VGND VGND VPWR VPWR sky130_fd_sc_hd__decap_3
XFILLER_56_328 VGND VGND VPWR VPWR sky130_fd_sc_hd__decap_3
X_8921_ hold833/X _8921_/A1 _8925_/S VGND VGND VPWR VPWR _8922_/A sky130_fd_sc_hd__mux2_2
XFILLER_49_380 VGND VGND VPWR VPWR sky130_fd_sc_hd__decap_3
XFILLER_17_18 VGND VGND VPWR VPWR sky130_fd_sc_hd__decap_3
XFILLER_37_553 VGND VGND VPWR VPWR sky130_fd_sc_hd__decap_3
X_8852_ _9270_/Q hold862/X _8862_/S VGND VGND VPWR VPWR _8852_/X sky130_fd_sc_hd__mux2_2
XFILLER_37_564 VGND VGND VPWR VPWR sky130_fd_sc_hd__decap_3
XFILLER_25_704 VGND VGND VPWR VPWR sky130_fd_sc_hd__fill_1
XFILLER_64_350 VGND VGND VPWR VPWR sky130_fd_sc_hd__fill_1
X_7803_ _8137_/B _7569_/X _7448_/B VGND VGND VPWR VPWR _7803_/Y sky130_fd_sc_hd__a21boi_2
X_8783_ _8783_/A _8783_/B _8783_/C VGND VGND VPWR VPWR _8784_/A sky130_fd_sc_hd__and3_2
XFILLER_52_545 VGND VGND VPWR VPWR sky130_fd_sc_hd__fill_2
XFILLER_25_759 VGND VGND VPWR VPWR sky130_fd_sc_hd__decap_3
XFILLER_24_236 VGND VGND VPWR VPWR sky130_fd_sc_hd__decap_3
X_5995_ _9173_/Q _5995_/A2 _5730_/X _9061_/Q VGND VGND VPWR VPWR _5998_/B sky130_fd_sc_hd__a22o_2
XTAP_TAPCELL_ROW_35_754 VGND VPWR sky130_fd_sc_hd__tapvpwrvgnd_1
X_7734_ _7891_/A _7734_/B VGND VGND VPWR VPWR _7735_/B sky130_fd_sc_hd__and2_2
XFILLER_12_409 VGND VGND VPWR VPWR sky130_fd_sc_hd__decap_3
X_4946_ _6027_/B VGND VGND VPWR VPWR _5716_/A sky130_fd_sc_hd__clkbuf_2
XFILLER_52_589 VGND VGND VPWR VPWR sky130_fd_sc_hd__decap_3
XTAP_TAPCELL_ROW_82_1384 VGND VPWR sky130_fd_sc_hd__tapvpwrvgnd_1
X_7665_ _5930_/C _5786_/Y _7534_/B VGND VGND VPWR VPWR _7666_/B sky130_fd_sc_hd__a21oi_2
XTAP_TAPCELL_ROW_82_1395 VGND VPWR sky130_fd_sc_hd__tapvpwrvgnd_1
X_4877_ _9178_/D VGND VGND VPWR VPWR _4878_/A sky130_fd_sc_hd__inv_2
XFILLER_32_291 VGND VGND VPWR VPWR sky130_fd_sc_hd__decap_3
X_6616_ _6616_/A _6616_/B VGND VGND VPWR VPWR _6617_/A sky130_fd_sc_hd__and2_2
X_7596_ _8170_/A _7784_/B VGND VGND VPWR VPWR _7600_/A sky130_fd_sc_hd__nand2_2
XFILLER_20_475 VGND VGND VPWR VPWR sky130_fd_sc_hd__fill_1
XFILLER_123_9 VGND VGND VPWR VPWR sky130_fd_sc_hd__decap_3
XFILLER_20_497 VGND VGND VPWR VPWR sky130_fd_sc_hd__decap_3
X_9335_ _9335_/CLK _9335_/D load_slew399/X VGND VGND VPWR VPWR _9335_/Q sky130_fd_sc_hd__dfrtp_2
X_6547_ _6547_/A _6547_/B VGND VGND VPWR VPWR _6548_/B sky130_fd_sc_hd__xnor2_2
XFILLER_118_341 VGND VGND VPWR VPWR sky130_fd_sc_hd__decap_3
XFILLER_118_363 VGND VGND VPWR VPWR sky130_fd_sc_hd__fill_1
XFILLER_118_374 VGND VGND VPWR VPWR sky130_fd_sc_hd__decap_3
X_9266_ _9346_/CLK _9266_/D load_slew397/X VGND VGND VPWR VPWR _9266_/Q sky130_fd_sc_hd__dfrtp_2
X_6478_ _5084_/B _5935_/X _6478_/S VGND VGND VPWR VPWR _6478_/X sky130_fd_sc_hd__mux2_2
XFILLER_106_569 VGND VGND VPWR VPWR sky130_fd_sc_hd__decap_3
X_8217_ _8217_/A _8217_/B VGND VGND VPWR VPWR _8217_/Y sky130_fd_sc_hd__xnor2_2
X_5429_ _5429_/A _5429_/B _5429_/C VGND VGND VPWR VPWR _5698_/A sky130_fd_sc_hd__or3_4
X_9197_ clkload7/A _9197_/D fanout375/X VGND VGND VPWR VPWR _9197_/Q sky130_fd_sc_hd__dfrtp_2
XFILLER_121_517 VGND VGND VPWR VPWR sky130_fd_sc_hd__decap_3
XFILLER_58_25 VGND VGND VPWR VPWR sky130_fd_sc_hd__decap_3
X_8148_ _8148_/A _8148_/B VGND VGND VPWR VPWR _8186_/A sky130_fd_sc_hd__xnor2_2
XFILLER_114_580 VGND VGND VPWR VPWR sky130_fd_sc_hd__fill_1
XFILLER_102_731 VGND VGND VPWR VPWR sky130_fd_sc_hd__decap_3
XFILLER_58_58 VGND VGND VPWR VPWR sky130_fd_sc_hd__fill_2
X_8079_ _8080_/B _8079_/B VGND VGND VPWR VPWR _8126_/A sky130_fd_sc_hd__or2_2
XFILLER_75_615 VGND VGND VPWR VPWR sky130_fd_sc_hd__fill_1
XFILLER_87_497 VGND VGND VPWR VPWR sky130_fd_sc_hd__decap_3
XFILLER_74_114 VGND VGND VPWR VPWR sky130_fd_sc_hd__fill_2
XFILLER_47_328 VGND VGND VPWR VPWR sky130_fd_sc_hd__decap_3
XFILLER_75_648 VGND VGND VPWR VPWR sky130_fd_sc_hd__fill_1
XFILLER_114_53 VGND VGND VPWR VPWR sky130_fd_sc_hd__decap_3
XFILLER_74_136 VGND VGND VPWR VPWR sky130_fd_sc_hd__fill_1
XFILLER_28_531 VGND VGND VPWR VPWR sky130_fd_sc_hd__fill_1
XFILLER_74_147 VGND VGND VPWR VPWR sky130_fd_sc_hd__decap_3
XFILLER_90_607 VGND VGND VPWR VPWR sky130_fd_sc_hd__decap_3
XFILLER_90_618 VGND VGND VPWR VPWR sky130_fd_sc_hd__fill_1
XFILLER_28_564 VGND VGND VPWR VPWR sky130_fd_sc_hd__decap_3
XFILLER_16_704 VGND VGND VPWR VPWR sky130_fd_sc_hd__decap_3
XFILLER_83_670 VGND VGND VPWR VPWR sky130_fd_sc_hd__fill_2
XFILLER_55_361 VGND VGND VPWR VPWR sky130_fd_sc_hd__decap_3
XFILLER_28_586 VGND VGND VPWR VPWR sky130_fd_sc_hd__fill_2
XFILLER_16_737 VGND VGND VPWR VPWR sky130_fd_sc_hd__decap_3
XFILLER_15_225 VGND VGND VPWR VPWR sky130_fd_sc_hd__fill_2
XFILLER_130_41 VGND VGND VPWR VPWR sky130_fd_sc_hd__decap_3
XFILLER_15_258 VGND VGND VPWR VPWR sky130_fd_sc_hd__decap_3
XFILLER_90_12 VGND VGND VPWR VPWR sky130_fd_sc_hd__decap_3
XFILLER_130_63 VGND VGND VPWR VPWR sky130_fd_sc_hd__decap_3
XFILLER_31_729 VGND VGND VPWR VPWR sky130_fd_sc_hd__decap_3
XFILLER_130_85 VGND VGND VPWR VPWR sky130_fd_sc_hd__decap_3
XFILLER_30_228 VGND VGND VPWR VPWR sky130_fd_sc_hd__decap_3
XFILLER_30_239 VGND VGND VPWR VPWR sky130_fd_sc_hd__decap_3
XFILLER_129_606 VGND VGND VPWR VPWR sky130_fd_sc_hd__decap_3
XFILLER_129_617 VGND VGND VPWR VPWR sky130_fd_sc_hd__decap_3
XTAP_TAPCELL_ROW_13_459 VGND VPWR sky130_fd_sc_hd__tapvpwrvgnd_1
XFILLER_23_50 VGND VGND VPWR VPWR sky130_fd_sc_hd__decap_3
XFILLER_7_402 VGND VGND VPWR VPWR sky130_fd_sc_hd__decap_3
XFILLER_128_127 VGND VGND VPWR VPWR sky130_fd_sc_hd__decap_3
XFILLER_11_497 VGND VGND VPWR VPWR sky130_fd_sc_hd__decap_3
XFILLER_109_330 VGND VGND VPWR VPWR sky130_fd_sc_hd__decap_3
XFILLER_7_446 VGND VGND VPWR VPWR sky130_fd_sc_hd__fill_2
XFILLER_99_65 VGND VGND VPWR VPWR sky130_fd_sc_hd__decap_3
XFILLER_109_396 VGND VGND VPWR VPWR sky130_fd_sc_hd__decap_3
XFILLER_3_641 VGND VGND VPWR VPWR sky130_fd_sc_hd__decap_3
XFILLER_97_206 VGND VGND VPWR VPWR sky130_fd_sc_hd__decap_3
Xload_slew305 _5934_/A VGND VGND VPWR VPWR _5949_/A sky130_fd_sc_hd__buf_4
XFILLER_112_528 VGND VGND VPWR VPWR sky130_fd_sc_hd__decap_3
XFILLER_97_228 VGND VGND VPWR VPWR sky130_fd_sc_hd__fill_1
XFILLER_3_685 VGND VGND VPWR VPWR sky130_fd_sc_hd__decap_3
Xload_slew327 _5926_/B VGND VGND VPWR VPWR _7867_/A sky130_fd_sc_hd__buf_6
XFILLER_112_539 VGND VGND VPWR VPWR sky130_fd_sc_hd__decap_3
Xload_slew338 _7534_/A VGND VGND VPWR VPWR _5790_/A sky130_fd_sc_hd__buf_4
Xload_slew349 _6406_/B VGND VGND VPWR VPWR _6415_/A sky130_fd_sc_hd__buf_6
XFILLER_2_195 VGND VGND VPWR VPWR sky130_fd_sc_hd__fill_1
XFILLER_120_550 VGND VGND VPWR VPWR sky130_fd_sc_hd__decap_3
XFILLER_78_475 VGND VGND VPWR VPWR sky130_fd_sc_hd__fill_1
XFILLER_66_615 VGND VGND VPWR VPWR sky130_fd_sc_hd__decap_3
XFILLER_93_412 VGND VGND VPWR VPWR sky130_fd_sc_hd__decap_3
XFILLER_120_583 VGND VGND VPWR VPWR sky130_fd_sc_hd__decap_3
XFILLER_48_80 VGND VGND VPWR VPWR sky130_fd_sc_hd__decap_3
XFILLER_17_6 VGND VGND VPWR VPWR sky130_fd_sc_hd__decap_3
XFILLER_93_434 VGND VGND VPWR VPWR sky130_fd_sc_hd__fill_2
XFILLER_48_91 VGND VGND VPWR VPWR sky130_fd_sc_hd__decap_3
XFILLER_93_445 VGND VGND VPWR VPWR sky130_fd_sc_hd__decap_3
XFILLER_19_531 VGND VGND VPWR VPWR sky130_fd_sc_hd__decap_3
XFILLER_0_21 VGND VGND VPWR VPWR sky130_fd_sc_hd__decap_3
XFILLER_93_467 VGND VGND VPWR VPWR sky130_fd_sc_hd__decap_3
XFILLER_0_32 VGND VGND VPWR VPWR sky130_fd_sc_hd__decap_3
XTAP_TAPCELL_ROW_109_1752 VGND VPWR sky130_fd_sc_hd__tapvpwrvgnd_1
XFILLER_46_350 VGND VGND VPWR VPWR sky130_fd_sc_hd__decap_3
XFILLER_19_564 VGND VGND VPWR VPWR sky130_fd_sc_hd__decap_3
XFILLER_19_586 VGND VGND VPWR VPWR sky130_fd_sc_hd__decap_3
XFILLER_61_320 VGND VGND VPWR VPWR sky130_fd_sc_hd__fill_1
XFILLER_46_394 VGND VGND VPWR VPWR sky130_fd_sc_hd__decap_3
XFILLER_0_98 VGND VGND VPWR VPWR sky130_fd_sc_hd__decap_3
XFILLER_34_545 VGND VGND VPWR VPWR sky130_fd_sc_hd__decap_3
XTAP_TAPCELL_ROW_122_1930 VGND VPWR sky130_fd_sc_hd__tapvpwrvgnd_1
X_4800_ _4842_/A VGND VGND VPWR VPWR _4819_/S sky130_fd_sc_hd__clkbuf_2
XFILLER_61_364 VGND VGND VPWR VPWR sky130_fd_sc_hd__decap_3
X_5780_ _5780_/A _5780_/B VGND VGND VPWR VPWR _5780_/Y sky130_fd_sc_hd__nor2_2
XTAP_TAPCELL_ROW_32_713 VGND VPWR sky130_fd_sc_hd__tapvpwrvgnd_1
XFILLER_9_30 VGND VGND VPWR VPWR sky130_fd_sc_hd__decap_3
XFILLER_21_228 VGND VGND VPWR VPWR sky130_fd_sc_hd__decap_3
X_4731_ hold979/X _4731_/A1 _4735_/S VGND VGND VPWR VPWR _4732_/A sky130_fd_sc_hd__mux2_2
XFILLER_9_74 VGND VGND VPWR VPWR sky130_fd_sc_hd__decap_3
XFILLER_119_105 VGND VGND VPWR VPWR sky130_fd_sc_hd__decap_3
X_7450_ _7450_/A _7450_/B VGND VGND VPWR VPWR _7576_/A sky130_fd_sc_hd__or2_2
XFILLER_119_116 VGND VGND VPWR VPWR sky130_fd_sc_hd__decap_3
X_4662_ _9080_/Q _4662_/A1 _4672_/S VGND VGND VPWR VPWR _4662_/X sky130_fd_sc_hd__mux2_2
X_6401_ _6116_/B _6399_/X _6400_/X _6436_/B VGND VGND VPWR VPWR _6401_/X sky130_fd_sc_hd__o22a_2
X_7381_ _7496_/A _7379_/Y _7380_/X VGND VGND VPWR VPWR _7381_/X sky130_fd_sc_hd__a21o_2
X_4593_ _4593_/A VGND VGND VPWR VPWR _9047_/D sky130_fd_sc_hd__buf_1
XFILLER_128_672 VGND VGND VPWR VPWR sky130_fd_sc_hd__decap_3
Xhold903 _4824_/X VGND VGND VPWR VPWR _4825_/A sky130_fd_sc_hd__dlygate4sd3_1
X_9120_ _9168_/CLK _9120_/D load_slew378/X VGND VGND VPWR VPWR _9120_/Q sky130_fd_sc_hd__dfrtp_2
X_6332_ _9175_/Q _6332_/A2 _5056_/X _9127_/Q _6331_/X VGND VGND VPWR VPWR _6332_/Y
+ sky130_fd_sc_hd__a221oi_4
Xhold914 _9289_/Q VGND VGND VPWR VPWR hold914/X sky130_fd_sc_hd__dlygate4sd3_1
Xhold925 _4754_/X VGND VGND VPWR VPWR _4755_/A sky130_fd_sc_hd__dlygate4sd3_1
Xhold936 _4679_/X VGND VGND VPWR VPWR _4680_/A sky130_fd_sc_hd__dlygate4sd3_1
XFILLER_127_193 VGND VGND VPWR VPWR sky130_fd_sc_hd__decap_3
Xhold947 _9132_/Q VGND VGND VPWR VPWR hold947/X sky130_fd_sc_hd__dlygate4sd3_1
Xhold958 _9165_/Q VGND VGND VPWR VPWR hold958/X sky130_fd_sc_hd__dlygate4sd3_1
X_9051_ _9236_/CLK _9051_/D fanout398/X VGND VGND VPWR VPWR _9051_/Q sky130_fd_sc_hd__dfrtp_2
X_6263_ _6263_/A _6263_/B VGND VGND VPWR VPWR _6519_/C sky130_fd_sc_hd__xnor2_4
Xhold969 _9336_/Q VGND VGND VPWR VPWR hold969/X sky130_fd_sc_hd__dlygate4sd3_1
XFILLER_89_729 VGND VGND VPWR VPWR sky130_fd_sc_hd__decap_3
XFILLER_115_366 VGND VGND VPWR VPWR sky130_fd_sc_hd__decap_3
XFILLER_103_517 VGND VGND VPWR VPWR sky130_fd_sc_hd__decap_3
XFILLER_88_206 VGND VGND VPWR VPWR sky130_fd_sc_hd__decap_3
XFILLER_130_303 VGND VGND VPWR VPWR sky130_fd_sc_hd__decap_3
X_8002_ _8009_/B VGND VGND VPWR VPWR _8002_/Y sky130_fd_sc_hd__inv_2
X_5214_ _5149_/X _5150_/X _5213_/X _8271_/B VGND VGND VPWR VPWR _5214_/X sky130_fd_sc_hd__o211a_2
X_6194_ _7408_/B _7065_/A VGND VGND VPWR VPWR _6198_/A sky130_fd_sc_hd__nor2_2
XFILLER_69_431 VGND VGND VPWR VPWR sky130_fd_sc_hd__decap_3
XFILLER_130_358 VGND VGND VPWR VPWR sky130_fd_sc_hd__decap_3
X_5145_ _5145_/A VGND VGND VPWR VPWR _5146_/B sky130_fd_sc_hd__clkbuf_1
XFILLER_96_250 VGND VGND VPWR VPWR sky130_fd_sc_hd__fill_2
XFILLER_57_615 VGND VGND VPWR VPWR sky130_fd_sc_hd__fill_1
XFILLER_28_17 VGND VGND VPWR VPWR sky130_fd_sc_hd__decap_3
XFILLER_29_317 VGND VGND VPWR VPWR sky130_fd_sc_hd__decap_3
XFILLER_69_497 VGND VGND VPWR VPWR sky130_fd_sc_hd__decap_3
XFILLER_111_594 VGND VGND VPWR VPWR sky130_fd_sc_hd__decap_3
X_5076_ _7012_/A VGND VGND VPWR VPWR _7099_/B sky130_fd_sc_hd__buf_8
XFILLER_56_147 VGND VGND VPWR VPWR sky130_fd_sc_hd__decap_3
X_8904_ _8938_/A1 _8904_/A1 _8904_/S VGND VGND VPWR VPWR _8905_/A sky130_fd_sc_hd__mux2_2
XFILLER_56_169 VGND VGND VPWR VPWR sky130_fd_sc_hd__decap_3
XFILLER_25_501 VGND VGND VPWR VPWR sky130_fd_sc_hd__decap_3
XTAP_TAPCELL_ROW_84_1413 VGND VPWR sky130_fd_sc_hd__tapvpwrvgnd_1
XFILLER_37_383 VGND VGND VPWR VPWR sky130_fd_sc_hd__fill_2
XFILLER_25_523 VGND VGND VPWR VPWR sky130_fd_sc_hd__decap_3
X_8835_ hold930/X _8835_/A1 _8841_/S VGND VGND VPWR VPWR _8836_/A sky130_fd_sc_hd__mux2_2
XFILLER_64_191 VGND VGND VPWR VPWR sky130_fd_sc_hd__decap_3
XFILLER_13_718 VGND VGND VPWR VPWR sky130_fd_sc_hd__decap_3
X_8766_ _8770_/A _8770_/C VGND VGND VPWR VPWR _8766_/X sky130_fd_sc_hd__or2_2
XFILLER_25_589 VGND VGND VPWR VPWR sky130_fd_sc_hd__decap_3
XFILLER_13_729 VGND VGND VPWR VPWR sky130_fd_sc_hd__decap_3
X_5978_ _5899_/B _5978_/B VGND VGND VPWR VPWR _5978_/X sky130_fd_sc_hd__and2b_2
XFILLER_80_684 VGND VGND VPWR VPWR sky130_fd_sc_hd__decap_3
X_7717_ _7728_/B _7877_/A VGND VGND VPWR VPWR _7717_/X sky130_fd_sc_hd__or2_2
XFILLER_40_548 VGND VGND VPWR VPWR sky130_fd_sc_hd__decap_3
X_4929_ _9050_/Q _4955_/B _5006_/B VGND VGND VPWR VPWR _4940_/B sky130_fd_sc_hd__and3_2
X_8697_ _9227_/Q _8729_/S _8697_/C VGND VGND VPWR VPWR _8697_/X sky130_fd_sc_hd__or3_2
XFILLER_60_15 VGND VGND VPWR VPWR sky130_fd_sc_hd__decap_3
XFILLER_21_762 VGND VGND VPWR VPWR sky130_fd_sc_hd__decap_3
XFILLER_100_88 VGND VGND VPWR VPWR sky130_fd_sc_hd__decap_3
X_7648_ _7648_/A _7648_/B VGND VGND VPWR VPWR _7900_/A sky130_fd_sc_hd__xnor2_4
XFILLER_20_250 VGND VGND VPWR VPWR sky130_fd_sc_hd__fill_2
XTAP_TAPCELL_ROW_10_418 VGND VPWR sky130_fd_sc_hd__tapvpwrvgnd_1
XFILLER_20_283 VGND VGND VPWR VPWR sky130_fd_sc_hd__decap_3
XFILLER_121_6 VGND VGND VPWR VPWR sky130_fd_sc_hd__decap_3
X_7579_ _7579_/A _7579_/B VGND VGND VPWR VPWR _7579_/X sky130_fd_sc_hd__and2_2
XFILLER_125_108 VGND VGND VPWR VPWR sky130_fd_sc_hd__decap_3
XFILLER_125_119 VGND VGND VPWR VPWR sky130_fd_sc_hd__decap_3
XFILLER_109_42 VGND VGND VPWR VPWR sky130_fd_sc_hd__decap_3
X_9318_ _9334_/CLK _9318_/D fanout400/X VGND VGND VPWR VPWR _9318_/Q sky130_fd_sc_hd__dfrtp_2
XFILLER_118_171 VGND VGND VPWR VPWR sky130_fd_sc_hd__decap_3
XTAP_TAPCELL_ROW_95_1564 VGND VPWR sky130_fd_sc_hd__tapvpwrvgnd_1
XFILLER_69_24 VGND VGND VPWR VPWR sky130_fd_sc_hd__decap_3
XFILLER_109_75 VGND VGND VPWR VPWR sky130_fd_sc_hd__fill_1
X_9249_ _9308_/CLK _9249_/D fanout367/X VGND VGND VPWR VPWR _9249_/Q sky130_fd_sc_hd__dfrtp_2
XFILLER_109_97 VGND VGND VPWR VPWR sky130_fd_sc_hd__decap_3
XFILLER_125_30 VGND VGND VPWR VPWR sky130_fd_sc_hd__decap_3
XFILLER_121_358 VGND VGND VPWR VPWR sky130_fd_sc_hd__decap_3
XFILLER_0_666 VGND VGND VPWR VPWR sky130_fd_sc_hd__decap_3
XFILLER_125_63 VGND VGND VPWR VPWR sky130_fd_sc_hd__decap_3
XFILLER_0_688 VGND VGND VPWR VPWR sky130_fd_sc_hd__decap_3
XFILLER_87_261 VGND VGND VPWR VPWR sky130_fd_sc_hd__fill_1
XFILLER_125_96 VGND VGND VPWR VPWR sky130_fd_sc_hd__decap_3
XFILLER_47_147 VGND VGND VPWR VPWR sky130_fd_sc_hd__decap_3
XFILLER_47_169 VGND VGND VPWR VPWR sky130_fd_sc_hd__decap_3
XTAP_TAPCELL_ROW_18_518 VGND VPWR sky130_fd_sc_hd__tapvpwrvgnd_1
XTAP_TAPCELL_ROW_18_529 VGND VPWR sky130_fd_sc_hd__tapvpwrvgnd_1
XFILLER_28_383 VGND VGND VPWR VPWR sky130_fd_sc_hd__decap_3
XFILLER_90_448 VGND VGND VPWR VPWR sky130_fd_sc_hd__decap_3
XFILLER_71_640 VGND VGND VPWR VPWR sky130_fd_sc_hd__decap_3
XFILLER_43_364 VGND VGND VPWR VPWR sky130_fd_sc_hd__decap_3
XFILLER_16_589 VGND VGND VPWR VPWR sky130_fd_sc_hd__decap_3
XTAP_TAPCELL_ROW_104_1682 VGND VPWR sky130_fd_sc_hd__tapvpwrvgnd_1
XFILLER_31_548 VGND VGND VPWR VPWR sky130_fd_sc_hd__decap_3
XFILLER_12_740 VGND VGND VPWR VPWR sky130_fd_sc_hd__decap_3
XFILLER_86_9 VGND VGND VPWR VPWR sky130_fd_sc_hd__decap_3
XFILLER_8_722 VGND VGND VPWR VPWR sky130_fd_sc_hd__decap_3
XFILLER_11_250 VGND VGND VPWR VPWR sky130_fd_sc_hd__decap_3
Xwire130 _5146_/B VGND VGND VPWR VPWR _5984_/B sky130_fd_sc_hd__buf_2
Xwire141 wire142/X VGND VGND VPWR VPWR _6616_/A sky130_fd_sc_hd__clkbuf_2
XFILLER_8_755 VGND VGND VPWR VPWR sky130_fd_sc_hd__fill_1
Xwire152 _5692_/Y VGND VGND VPWR VPWR _7417_/A sky130_fd_sc_hd__buf_6
XFILLER_8_766 VGND VGND VPWR VPWR sky130_fd_sc_hd__decap_3
XFILLER_7_254 VGND VGND VPWR VPWR sky130_fd_sc_hd__fill_2
XFILLER_7_287 VGND VGND VPWR VPWR sky130_fd_sc_hd__decap_3
XFILLER_50_81 VGND VGND VPWR VPWR sky130_fd_sc_hd__decap_3
XFILLER_125_620 VGND VGND VPWR VPWR sky130_fd_sc_hd__decap_3
XFILLER_125_642 VGND VGND VPWR VPWR sky130_fd_sc_hd__decap_3
XFILLER_124_130 VGND VGND VPWR VPWR sky130_fd_sc_hd__decap_3
XFILLER_125_664 VGND VGND VPWR VPWR sky130_fd_sc_hd__decap_3
XFILLER_124_141 VGND VGND VPWR VPWR sky130_fd_sc_hd__decap_3
XTAP_TAPCELL_ROW_55_1025 VGND VPWR sky130_fd_sc_hd__tapvpwrvgnd_1
XFILLER_98_515 VGND VGND VPWR VPWR sky130_fd_sc_hd__decap_3
XFILLER_3_471 VGND VGND VPWR VPWR sky130_fd_sc_hd__decap_3
XFILLER_124_174 VGND VGND VPWR VPWR sky130_fd_sc_hd__decap_3
XFILLER_3_493 VGND VGND VPWR VPWR sky130_fd_sc_hd__decap_3
XFILLER_39_626 VGND VGND VPWR VPWR sky130_fd_sc_hd__decap_3
XFILLER_39_659 VGND VGND VPWR VPWR sky130_fd_sc_hd__decap_3
XFILLER_38_125 VGND VGND VPWR VPWR sky130_fd_sc_hd__decap_3
XFILLER_15_3 VGND VGND VPWR VPWR sky130_fd_sc_hd__decap_3
XFILLER_120_391 VGND VGND VPWR VPWR sky130_fd_sc_hd__decap_3
XFILLER_54_618 VGND VGND VPWR VPWR sky130_fd_sc_hd__decap_3
XFILLER_38_169 VGND VGND VPWR VPWR sky130_fd_sc_hd__decap_3
XFILLER_26_309 VGND VGND VPWR VPWR sky130_fd_sc_hd__decap_3
X_6950_ _6950_/A _6950_/B VGND VGND VPWR VPWR _7021_/A sky130_fd_sc_hd__xnor2_2
XFILLER_93_275 VGND VGND VPWR VPWR sky130_fd_sc_hd__decap_3
XFILLER_66_489 VGND VGND VPWR VPWR sky130_fd_sc_hd__fill_1
XFILLER_47_670 VGND VGND VPWR VPWR sky130_fd_sc_hd__fill_2
X_5901_ _6061_/C _6143_/B VGND VGND VPWR VPWR _5903_/A sky130_fd_sc_hd__nor2_2
XFILLER_47_692 VGND VGND VPWR VPWR sky130_fd_sc_hd__fill_2
X_6881_ _7203_/B _6881_/B VGND VGND VPWR VPWR _6882_/B sky130_fd_sc_hd__xnor2_2
XFILLER_81_459 VGND VGND VPWR VPWR sky130_fd_sc_hd__decap_3
XFILLER_62_640 VGND VGND VPWR VPWR sky130_fd_sc_hd__fill_1
XFILLER_46_191 VGND VGND VPWR VPWR sky130_fd_sc_hd__decap_3
X_8620_ _9225_/Q _6762_/D _8618_/X _8619_/Y _8654_/S VGND VGND VPWR VPWR _8620_/X
+ sky130_fd_sc_hd__o221a_2
XFILLER_34_353 VGND VGND VPWR VPWR sky130_fd_sc_hd__decap_3
X_5832_ _7114_/C _7773_/A _5984_/C _5984_/B VGND VGND VPWR VPWR _5833_/B sky130_fd_sc_hd__a211o_2
XFILLER_62_673 VGND VGND VPWR VPWR sky130_fd_sc_hd__decap_3
XTAP_TAPCELL_ROW_66_1176 VGND VPWR sky130_fd_sc_hd__tapvpwrvgnd_1
XFILLER_34_386 VGND VGND VPWR VPWR sky130_fd_sc_hd__decap_3
XTAP_TAPCELL_ROW_45_893 VGND VPWR sky130_fd_sc_hd__tapvpwrvgnd_1
X_8551_ _8627_/A _8515_/B _8538_/B _8550_/Y VGND VGND VPWR VPWR _8551_/X sky130_fd_sc_hd__a31o_2
X_5763_ _5763_/A _5973_/B VGND VGND VPWR VPWR _5764_/B sky130_fd_sc_hd__xnor2_2
XFILLER_22_559 VGND VGND VPWR VPWR sky130_fd_sc_hd__decap_3
X_7502_ _7502_/A _7502_/B _7502_/C VGND VGND VPWR VPWR _7565_/B sky130_fd_sc_hd__and3_2
X_4714_ _4748_/A1 _9089_/Q _4714_/S VGND VGND VPWR VPWR _4714_/X sky130_fd_sc_hd__mux2_2
X_8482_ _8482_/A _8482_/B VGND VGND VPWR VPWR _8482_/X sky130_fd_sc_hd__and2_2
X_5694_ _5694_/A _5694_/B VGND VGND VPWR VPWR _5695_/B sky130_fd_sc_hd__nand2_2
X_7433_ _7433_/A _7579_/A _7579_/B VGND VGND VPWR VPWR _7434_/C sky130_fd_sc_hd__nand3_2
X_4645_ _4645_/A VGND VGND VPWR VPWR _9072_/D sky130_fd_sc_hd__buf_1
XFILLER_128_480 VGND VGND VPWR VPWR sky130_fd_sc_hd__decap_3
X_7364_ _9214_/Q _7364_/B VGND VGND VPWR VPWR _7365_/B sky130_fd_sc_hd__xnor2_2
X_4576_ _4576_/A VGND VGND VPWR VPWR _9039_/D sky130_fd_sc_hd__buf_1
X_9103_ _9135_/CLK _9103_/D load_slew396/X VGND VGND VPWR VPWR _9103_/Q sky130_fd_sc_hd__dfrtp_2
XFILLER_115_130 VGND VGND VPWR VPWR sky130_fd_sc_hd__decap_3
X_6315_ _6315_/A _6315_/B VGND VGND VPWR VPWR _6563_/B sky130_fd_sc_hd__xnor2_2
Xhold755 _5946_/A VGND VGND VPWR VPWR _6122_/A sky130_fd_sc_hd__dlygate4sd3_1
X_7295_ _8080_/A _8237_/A _7295_/C VGND VGND VPWR VPWR _7295_/X sky130_fd_sc_hd__and3_2
Xhold766 _8799_/X VGND VGND VPWR VPWR _8800_/A sky130_fd_sc_hd__dlygate4sd3_1
Xhold777 _9198_/Q VGND VGND VPWR VPWR hold777/X sky130_fd_sc_hd__dlygate4sd3_1
XFILLER_130_100 VGND VGND VPWR VPWR sky130_fd_sc_hd__decap_3
Xhold788 _4908_/X VGND VGND VPWR VPWR _9194_/D sky130_fd_sc_hd__dlygate4sd3_1
X_9034_ _9335_/CLK _9034_/D load_slew399/X VGND VGND VPWR VPWR _9034_/Q sky130_fd_sc_hd__dfrtp_2
X_6246_ _6246_/A _6246_/B _6246_/C VGND VGND VPWR VPWR _6247_/B sky130_fd_sc_hd__or3_4
Xhold799 _9184_/Q VGND VGND VPWR VPWR hold799/X sky130_fd_sc_hd__dlygate4sd3_1
XFILLER_130_122 VGND VGND VPWR VPWR sky130_fd_sc_hd__decap_3
XFILLER_39_38 VGND VGND VPWR VPWR sky130_fd_sc_hd__decap_3
XFILLER_103_358 VGND VGND VPWR VPWR sky130_fd_sc_hd__decap_3
XFILLER_130_144 VGND VGND VPWR VPWR sky130_fd_sc_hd__decap_3
X_6177_ _6177_/A _6177_/B VGND VGND VPWR VPWR _6181_/B sky130_fd_sc_hd__nand2_4
XFILLER_97_570 VGND VGND VPWR VPWR sky130_fd_sc_hd__decap_3
XFILLER_85_710 VGND VGND VPWR VPWR sky130_fd_sc_hd__decap_3
XTAP_TAPCELL_ROW_90_1494 VGND VPWR sky130_fd_sc_hd__tapvpwrvgnd_1
XFILLER_85_721 VGND VGND VPWR VPWR sky130_fd_sc_hd__decap_3
XFILLER_85_732 VGND VGND VPWR VPWR sky130_fd_sc_hd__decap_3
X_5128_ _9305_/Q _6758_/B _6758_/C wire172/X _9117_/Q VGND VGND VPWR VPWR _5128_/X
+ sky130_fd_sc_hd__a32o_2
XFILLER_69_294 VGND VGND VPWR VPWR sky130_fd_sc_hd__decap_3
XFILLER_57_434 VGND VGND VPWR VPWR sky130_fd_sc_hd__decap_3
XFILLER_29_136 VGND VGND VPWR VPWR sky130_fd_sc_hd__decap_3
XFILLER_84_253 VGND VGND VPWR VPWR sky130_fd_sc_hd__fill_1
XFILLER_57_467 VGND VGND VPWR VPWR sky130_fd_sc_hd__decap_3
XFILLER_55_15 VGND VGND VPWR VPWR sky130_fd_sc_hd__decap_3
XFILLER_29_169 VGND VGND VPWR VPWR sky130_fd_sc_hd__fill_1
X_5059_ _9304_/Q _9100_/Q _5059_/S VGND VGND VPWR VPWR _5059_/X sky130_fd_sc_hd__mux2_2
XFILLER_55_48 VGND VGND VPWR VPWR sky130_fd_sc_hd__decap_3
XFILLER_38_670 VGND VGND VPWR VPWR sky130_fd_sc_hd__decap_3
XFILLER_37_191 VGND VGND VPWR VPWR sky130_fd_sc_hd__decap_3
XPHY_EDGE_ROW_9_Left_140 VGND VGND VPWR VPWR sky130_fd_sc_hd__decap_3
XFILLER_53_651 VGND VGND VPWR VPWR sky130_fd_sc_hd__decap_3
XFILLER_111_21 VGND VGND VPWR VPWR sky130_fd_sc_hd__decap_3
X_8818_ hold862/X _8818_/A1 _8820_/S VGND VGND VPWR VPWR _8819_/A sky130_fd_sc_hd__mux2_2
XFILLER_111_54 VGND VGND VPWR VPWR sky130_fd_sc_hd__fill_2
XFILLER_13_526 VGND VGND VPWR VPWR sky130_fd_sc_hd__decap_3
XFILLER_52_172 VGND VGND VPWR VPWR sky130_fd_sc_hd__decap_3
XFILLER_111_87 VGND VGND VPWR VPWR sky130_fd_sc_hd__decap_3
XFILLER_9_508 VGND VGND VPWR VPWR sky130_fd_sc_hd__decap_3
X_8749_ _6749_/X _8655_/B _9230_/Q VGND VGND VPWR VPWR _8749_/X sky130_fd_sc_hd__mux2_2
XFILLER_40_345 VGND VGND VPWR VPWR sky130_fd_sc_hd__decap_3
XPHY_EDGE_ROW_109_Right_109 VGND VGND VPWR VPWR sky130_fd_sc_hd__decap_3
XTAP_TAPCELL_ROW_23_587 VGND VPWR sky130_fd_sc_hd__tapvpwrvgnd_1
XTAP_TAPCELL_ROW_23_598 VGND VPWR sky130_fd_sc_hd__tapvpwrvgnd_1
XFILLER_5_703 VGND VGND VPWR VPWR sky130_fd_sc_hd__decap_3
XFILLER_126_428 VGND VGND VPWR VPWR sky130_fd_sc_hd__decap_3
XFILLER_107_620 VGND VGND VPWR VPWR sky130_fd_sc_hd__decap_3
XFILLER_5_747 VGND VGND VPWR VPWR sky130_fd_sc_hd__decap_3
XFILLER_4_224 VGND VGND VPWR VPWR sky130_fd_sc_hd__decap_3
XFILLER_107_642 VGND VGND VPWR VPWR sky130_fd_sc_hd__decap_3
XFILLER_4_246 VGND VGND VPWR VPWR sky130_fd_sc_hd__fill_1
XFILLER_106_141 VGND VGND VPWR VPWR sky130_fd_sc_hd__decap_3
XFILLER_4_268 VGND VGND VPWR VPWR sky130_fd_sc_hd__decap_3
XFILLER_122_601 VGND VGND VPWR VPWR sky130_fd_sc_hd__decap_3
XFILLER_107_686 VGND VGND VPWR VPWR sky130_fd_sc_hd__fill_2
XFILLER_107_697 VGND VGND VPWR VPWR sky130_fd_sc_hd__fill_1
XFILLER_121_111 VGND VGND VPWR VPWR sky130_fd_sc_hd__fill_1
XFILLER_121_122 VGND VGND VPWR VPWR sky130_fd_sc_hd__decap_3
XFILLER_0_430 VGND VGND VPWR VPWR sky130_fd_sc_hd__decap_3
XFILLER_122_678 VGND VGND VPWR VPWR sky130_fd_sc_hd__decap_3
XFILLER_0_452 VGND VGND VPWR VPWR sky130_fd_sc_hd__decap_3
XFILLER_95_518 VGND VGND VPWR VPWR sky130_fd_sc_hd__decap_3
XFILLER_121_155 VGND VGND VPWR VPWR sky130_fd_sc_hd__decap_3
XFILLER_76_721 VGND VGND VPWR VPWR sky130_fd_sc_hd__decap_3
XFILLER_29_60 VGND VGND VPWR VPWR sky130_fd_sc_hd__decap_3
XFILLER_121_199 VGND VGND VPWR VPWR sky130_fd_sc_hd__decap_3
XFILLER_76_754 VGND VGND VPWR VPWR sky130_fd_sc_hd__fill_2
XFILLER_48_456 VGND VGND VPWR VPWR sky130_fd_sc_hd__decap_3
XFILLER_48_489 VGND VGND VPWR VPWR sky130_fd_sc_hd__fill_2
XTAP_TAPCELL_ROW_106_1711 VGND VPWR sky130_fd_sc_hd__tapvpwrvgnd_1
XFILLER_28_180 VGND VGND VPWR VPWR sky130_fd_sc_hd__decap_3
XFILLER_90_289 VGND VGND VPWR VPWR sky130_fd_sc_hd__decap_3
XFILLER_45_92 VGND VGND VPWR VPWR sky130_fd_sc_hd__decap_3
XFILLER_43_161 VGND VGND VPWR VPWR sky130_fd_sc_hd__decap_3
XTAP_TAPCELL_ROW_42_852 VGND VPWR sky130_fd_sc_hd__tapvpwrvgnd_1
XFILLER_129_211 VGND VGND VPWR VPWR sky130_fd_sc_hd__decap_3
XFILLER_12_581 VGND VGND VPWR VPWR sky130_fd_sc_hd__decap_3
XFILLER_129_266 VGND VGND VPWR VPWR sky130_fd_sc_hd__decap_3
XFILLER_117_406 VGND VGND VPWR VPWR sky130_fd_sc_hd__decap_3
XFILLER_8_574 VGND VGND VPWR VPWR sky130_fd_sc_hd__decap_3
XANTENNA_2 _7897_/Y VGND VGND VPWR VPWR sky130_fd_sc_hd__diode_2
XTAP_TAPCELL_ROW_117_1862 VGND VPWR sky130_fd_sc_hd__tapvpwrvgnd_1
XFILLER_98_312 VGND VGND VPWR VPWR sky130_fd_sc_hd__decap_3
X_6100_ _6446_/A _6097_/X _6821_/S VGND VGND VPWR VPWR _6100_/X sky130_fd_sc_hd__mux2_2
XFILLER_98_323 VGND VGND VPWR VPWR sky130_fd_sc_hd__decap_3
XFILLER_113_623 VGND VGND VPWR VPWR sky130_fd_sc_hd__decap_3
X_7080_ _7093_/A _7099_/C _5850_/A VGND VGND VPWR VPWR _7081_/C sky130_fd_sc_hd__a21o_2
X_6031_ _7417_/B VGND VGND VPWR VPWR _8313_/A sky130_fd_sc_hd__clkbuf_2
XFILLER_58_209 VGND VGND VPWR VPWR sky130_fd_sc_hd__decap_3
XFILLER_112_155 VGND VGND VPWR VPWR sky130_fd_sc_hd__decap_3
XFILLER_79_570 VGND VGND VPWR VPWR sky130_fd_sc_hd__decap_3
XFILLER_67_721 VGND VGND VPWR VPWR sky130_fd_sc_hd__decap_3
XFILLER_67_732 VGND VGND VPWR VPWR sky130_fd_sc_hd__decap_3
XFILLER_67_776 VGND VGND VPWR VPWR sky130_fd_sc_hd__fill_1
XTAP_TAPCELL_ROW_68_1205 VGND VPWR sky130_fd_sc_hd__tapvpwrvgnd_1
XFILLER_94_562 VGND VGND VPWR VPWR sky130_fd_sc_hd__decap_3
XFILLER_66_253 VGND VGND VPWR VPWR sky130_fd_sc_hd__decap_3
XFILLER_82_713 VGND VGND VPWR VPWR sky130_fd_sc_hd__decap_3
X_7982_ _7812_/A _7980_/Y _7981_/Y VGND VGND VPWR VPWR _7983_/B sky130_fd_sc_hd__a21oi_2
XFILLER_66_275 VGND VGND VPWR VPWR sky130_fd_sc_hd__decap_3
XFILLER_54_415 VGND VGND VPWR VPWR sky130_fd_sc_hd__decap_3
XFILLER_39_489 VGND VGND VPWR VPWR sky130_fd_sc_hd__decap_3
XFILLER_94_595 VGND VGND VPWR VPWR sky130_fd_sc_hd__decap_3
XFILLER_81_212 VGND VGND VPWR VPWR sky130_fd_sc_hd__decap_3
XFILLER_82_757 VGND VGND VPWR VPWR sky130_fd_sc_hd__fill_2
X_6933_ _6764_/A _6934_/B _7951_/B _6932_/X VGND VGND VPWR VPWR _6933_/X sky130_fd_sc_hd__o31a_2
XFILLER_82_768 VGND VGND VPWR VPWR sky130_fd_sc_hd__fill_1
XFILLER_19_191 VGND VGND VPWR VPWR sky130_fd_sc_hd__decap_3
XFILLER_81_267 VGND VGND VPWR VPWR sky130_fd_sc_hd__decap_3
XFILLER_41_109 VGND VGND VPWR VPWR sky130_fd_sc_hd__decap_3
XFILLER_35_673 VGND VGND VPWR VPWR sky130_fd_sc_hd__fill_1
XFILLER_34_150 VGND VGND VPWR VPWR sky130_fd_sc_hd__decap_3
X_6864_ _6859_/A _6856_/Y _6857_/Y _6863_/X _6801_/A VGND VGND VPWR VPWR _6892_/A
+ sky130_fd_sc_hd__a32o_2
XFILLER_22_312 VGND VGND VPWR VPWR sky130_fd_sc_hd__decap_3
XFILLER_50_632 VGND VGND VPWR VPWR sky130_fd_sc_hd__decap_3
X_5815_ _5815_/A0 _5814_/X _5968_/S VGND VGND VPWR VPWR _5815_/X sky130_fd_sc_hd__mux2_2
X_8603_ _8676_/B _8603_/B VGND VGND VPWR VPWR _8604_/B sky130_fd_sc_hd__xnor2_2
X_6795_ _6885_/B VGND VGND VPWR VPWR _7681_/A sky130_fd_sc_hd__clkbuf_1
X_8534_ _9225_/Q _8534_/B VGND VGND VPWR VPWR _8535_/B sky130_fd_sc_hd__xnor2_2
X_5746_ _7417_/A VGND VGND VPWR VPWR _7773_/A sky130_fd_sc_hd__clkbuf_4
X_8465_ _9221_/Q wire71/X wire61/X _8446_/A VGND VGND VPWR VPWR _8465_/X sky130_fd_sc_hd__o22a_2
XTAP_TAPCELL_ROW_20_546 VGND VPWR sky130_fd_sc_hd__tapvpwrvgnd_1
XFILLER_108_417 VGND VGND VPWR VPWR sky130_fd_sc_hd__decap_3
X_5677_ _6490_/A _6416_/B _5930_/C VGND VGND VPWR VPWR _5677_/X sky130_fd_sc_hd__and3_2
XTAP_TAPCELL_ROW_20_557 VGND VPWR sky130_fd_sc_hd__tapvpwrvgnd_1
XTAP_TAPCELL_ROW_79_1345 VGND VPWR sky130_fd_sc_hd__tapvpwrvgnd_1
XFILLER_108_439 VGND VGND VPWR VPWR sky130_fd_sc_hd__decap_3
X_7416_ _7416_/A _7416_/B VGND VGND VPWR VPWR _7418_/A sky130_fd_sc_hd__nand2_2
X_4628_ _4628_/A VGND VGND VPWR VPWR _9064_/D sky130_fd_sc_hd__buf_1
X_8396_ _8383_/A _8379_/B _8395_/X VGND VGND VPWR VPWR _8463_/A sky130_fd_sc_hd__o21a_2
XTAP_TAPCELL_ROW_92_1523 VGND VPWR sky130_fd_sc_hd__tapvpwrvgnd_1
X_7347_ _7462_/A _7635_/A _7347_/C VGND VGND VPWR VPWR _7469_/B sky130_fd_sc_hd__nand3_4
X_4559_ _4559_/A VGND VGND VPWR VPWR _9031_/D sky130_fd_sc_hd__buf_1
XFILLER_2_728 VGND VGND VPWR VPWR sky130_fd_sc_hd__decap_3
XFILLER_1_205 VGND VGND VPWR VPWR sky130_fd_sc_hd__fill_2
XFILLER_116_472 VGND VGND VPWR VPWR sky130_fd_sc_hd__decap_3
XFILLER_103_100 VGND VGND VPWR VPWR sky130_fd_sc_hd__decap_3
XFILLER_104_645 VGND VGND VPWR VPWR sky130_fd_sc_hd__fill_1
XFILLER_103_122 VGND VGND VPWR VPWR sky130_fd_sc_hd__decap_3
X_7278_ _7277_/B _7278_/B VGND VGND VPWR VPWR _7279_/C sky130_fd_sc_hd__and2b_2
XFILLER_106_21 VGND VGND VPWR VPWR sky130_fd_sc_hd__decap_3
X_9017_ _9317_/CLK _9017_/D wire406/A VGND VGND VPWR VPWR _9017_/Q sky130_fd_sc_hd__dfrtp_2
X_6229_ _9094_/Q _6754_/B _6753_/B VGND VGND VPWR VPWR _6229_/X sky130_fd_sc_hd__and3_2
XFILLER_57_231 VGND VGND VPWR VPWR sky130_fd_sc_hd__decap_3
Xhold1230 _9196_/Q VGND VGND VPWR VPWR _4972_/A1 sky130_fd_sc_hd__dlygate4sd3_1
Xhold1241 _5059_/S VGND VGND VPWR VPWR _8779_/A sky130_fd_sc_hd__dlygate4sd3_1
XFILLER_58_776 VGND VGND VPWR VPWR sky130_fd_sc_hd__fill_1
Xhold1252 _9202_/Q VGND VGND VPWR VPWR _5339_/A0 sky130_fd_sc_hd__dlygate4sd3_1
XFILLER_73_702 VGND VGND VPWR VPWR sky130_fd_sc_hd__decap_3
XFILLER_73_724 VGND VGND VPWR VPWR sky130_fd_sc_hd__decap_3
XFILLER_57_275 VGND VGND VPWR VPWR sky130_fd_sc_hd__fill_2
XFILLER_45_415 VGND VGND VPWR VPWR sky130_fd_sc_hd__decap_3
XFILLER_18_629 VGND VGND VPWR VPWR sky130_fd_sc_hd__decap_3
XFILLER_122_53 VGND VGND VPWR VPWR sky130_fd_sc_hd__decap_3
XTAP_TAPCELL_ROW_28_657 VGND VPWR sky130_fd_sc_hd__tapvpwrvgnd_1
XFILLER_26_651 VGND VGND VPWR VPWR sky130_fd_sc_hd__decap_3
XTAP_TAPCELL_ROW_0_271 VGND VPWR sky130_fd_sc_hd__tapvpwrvgnd_1
XFILLER_122_97 VGND VGND VPWR VPWR sky130_fd_sc_hd__decap_3
XFILLER_25_150 VGND VGND VPWR VPWR sky130_fd_sc_hd__decap_3
XTAP_TAPCELL_ROW_0_282 VGND VPWR sky130_fd_sc_hd__tapvpwrvgnd_1
XFILLER_41_632 VGND VGND VPWR VPWR sky130_fd_sc_hd__decap_3
XFILLER_25_183 VGND VGND VPWR VPWR sky130_fd_sc_hd__fill_2
XFILLER_13_334 VGND VGND VPWR VPWR sky130_fd_sc_hd__fill_2
XFILLER_15_51 VGND VGND VPWR VPWR sky130_fd_sc_hd__decap_3
XTAP_TAPCELL_ROW_101_1641 VGND VPWR sky130_fd_sc_hd__tapvpwrvgnd_1
XFILLER_41_676 VGND VGND VPWR VPWR sky130_fd_sc_hd__fill_1
XFILLER_15_84 VGND VGND VPWR VPWR sky130_fd_sc_hd__decap_3
XFILLER_13_378 VGND VGND VPWR VPWR sky130_fd_sc_hd__decap_3
XFILLER_40_175 VGND VGND VPWR VPWR sky130_fd_sc_hd__decap_3
XFILLER_40_197 VGND VGND VPWR VPWR sky130_fd_sc_hd__decap_3
XFILLER_127_715 VGND VGND VPWR VPWR sky130_fd_sc_hd__decap_3
XFILLER_5_500 VGND VGND VPWR VPWR sky130_fd_sc_hd__decap_3
XFILLER_126_203 VGND VGND VPWR VPWR sky130_fd_sc_hd__decap_3
XFILLER_127_759 VGND VGND VPWR VPWR sky130_fd_sc_hd__decap_3
XFILLER_126_236 VGND VGND VPWR VPWR sky130_fd_sc_hd__decap_3
Xrebuffer682 _6494_/B VGND VGND VPWR VPWR _6837_/A2 sky130_fd_sc_hd__buf_2
XTAP_TAPCELL_ROW_130_2037 VGND VPWR sky130_fd_sc_hd__tapvpwrvgnd_1
XTAP_TAPCELL_ROW_130_2048 VGND VPWR sky130_fd_sc_hd__tapvpwrvgnd_1
XFILLER_68_507 VGND VGND VPWR VPWR sky130_fd_sc_hd__decap_3
XFILLER_1_750 VGND VGND VPWR VPWR sky130_fd_sc_hd__decap_3
XFILLER_110_604 VGND VGND VPWR VPWR sky130_fd_sc_hd__decap_3
XFILLER_95_326 VGND VGND VPWR VPWR sky130_fd_sc_hd__decap_3
XFILLER_122_486 VGND VGND VPWR VPWR sky130_fd_sc_hd__decap_3
XTAP_TAPCELL_ROW_8_393 VGND VPWR sky130_fd_sc_hd__tapvpwrvgnd_1
XTAP_TAPCELL_ROW_112_1792 VGND VPWR sky130_fd_sc_hd__tapvpwrvgnd_1
XFILLER_49_732 VGND VGND VPWR VPWR sky130_fd_sc_hd__decap_3
XFILLER_110_648 VGND VGND VPWR VPWR sky130_fd_sc_hd__decap_3
XFILLER_95_359 VGND VGND VPWR VPWR sky130_fd_sc_hd__fill_1
XFILLER_49_754 VGND VGND VPWR VPWR sky130_fd_sc_hd__decap_3
XFILLER_0_293 VGND VGND VPWR VPWR sky130_fd_sc_hd__decap_3
XFILLER_48_242 VGND VGND VPWR VPWR sky130_fd_sc_hd__decap_3
XFILLER_76_562 VGND VGND VPWR VPWR sky130_fd_sc_hd__decap_3
XFILLER_49_776 VGND VGND VPWR VPWR sky130_fd_sc_hd__fill_1
XTAP_TAPCELL_ROW_47_911 VGND VPWR sky130_fd_sc_hd__tapvpwrvgnd_1
XTAP_TAPCELL_ROW_47_922 VGND VPWR sky130_fd_sc_hd__tapvpwrvgnd_1
XFILLER_36_437 VGND VGND VPWR VPWR sky130_fd_sc_hd__decap_3
XFILLER_64_757 VGND VGND VPWR VPWR sky130_fd_sc_hd__decap_3
XFILLER_36_448 VGND VGND VPWR VPWR sky130_fd_sc_hd__decap_3
XFILLER_56_91 VGND VGND VPWR VPWR sky130_fd_sc_hd__decap_3
XFILLER_91_576 VGND VGND VPWR VPWR sky130_fd_sc_hd__decap_3
XFILLER_17_673 VGND VGND VPWR VPWR sky130_fd_sc_hd__decap_3
XFILLER_16_150 VGND VGND VPWR VPWR sky130_fd_sc_hd__decap_3
XTAP_TAPCELL_ROW_63_1135 VGND VPWR sky130_fd_sc_hd__tapvpwrvgnd_1
XFILLER_16_183 VGND VGND VPWR VPWR sky130_fd_sc_hd__decap_3
X_5600_ _5137_/X _5138_/X _6550_/B VGND VGND VPWR VPWR _5602_/A sky130_fd_sc_hd__a21o_2
XFILLER_32_687 VGND VGND VPWR VPWR sky130_fd_sc_hd__fill_1
XFILLER_31_164 VGND VGND VPWR VPWR sky130_fd_sc_hd__decap_3
X_6580_ _6311_/A _8066_/A _6578_/Y _6579_/Y VGND VGND VPWR VPWR _6581_/B sky130_fd_sc_hd__o31ai_2
XFILLER_82_3 VGND VGND VPWR VPWR sky130_fd_sc_hd__decap_3
XFILLER_118_704 VGND VGND VPWR VPWR sky130_fd_sc_hd__decap_3
X_5531_ _6270_/S _5531_/B VGND VGND VPWR VPWR _5531_/Y sky130_fd_sc_hd__nor2_2
XFILLER_118_737 VGND VGND VPWR VPWR sky130_fd_sc_hd__decap_3
X_8250_ _8245_/Y _8251_/A VGND VGND VPWR VPWR _8252_/A sky130_fd_sc_hd__and2b_2
XFILLER_117_225 VGND VGND VPWR VPWR sky130_fd_sc_hd__fill_2
X_5462_ _9089_/Q _9153_/Q _5462_/S VGND VGND VPWR VPWR _5462_/X sky130_fd_sc_hd__mux2_2
XFILLER_117_247 VGND VGND VPWR VPWR sky130_fd_sc_hd__decap_3
XFILLER_117_258 VGND VGND VPWR VPWR sky130_fd_sc_hd__decap_3
XFILLER_105_409 VGND VGND VPWR VPWR sky130_fd_sc_hd__decap_3
X_7201_ _7256_/A _7256_/B VGND VGND VPWR VPWR _7208_/A sky130_fd_sc_hd__xnor2_2
X_8181_ _8074_/A _8074_/B _8075_/A VGND VGND VPWR VPWR _8181_/X sky130_fd_sc_hd__a21o_2
X_5393_ _5633_/A _5393_/B VGND VGND VPWR VPWR _5394_/B sky130_fd_sc_hd__nor2_2
X_7132_ _7388_/A _7388_/B _7032_/X _7132_/C1 VGND VGND VPWR VPWR _7133_/C sky130_fd_sc_hd__o211ai_2
XFILLER_113_420 VGND VGND VPWR VPWR sky130_fd_sc_hd__fill_2
Xfanout306 hold757/X VGND VGND VPWR VPWR _5957_/A sky130_fd_sc_hd__clkdlybuf4s25_1
XTAP_TAPCELL_ROW_74_1275 VGND VPWR sky130_fd_sc_hd__tapvpwrvgnd_1
Xfanout317 _7174_/A VGND VGND VPWR VPWR _6098_/A sky130_fd_sc_hd__dlygate4sd1_1
XTAP_TAPCELL_ROW_74_1286 VGND VPWR sky130_fd_sc_hd__tapvpwrvgnd_1
XFILLER_99_676 VGND VGND VPWR VPWR sky130_fd_sc_hd__fill_2
Xfanout328 hold763/X VGND VGND VPWR VPWR _7227_/B1 sky130_fd_sc_hd__buf_4
XFILLER_113_464 VGND VGND VPWR VPWR sky130_fd_sc_hd__decap_3
XFILLER_101_615 VGND VGND VPWR VPWR sky130_fd_sc_hd__fill_1
X_7063_ _7357_/B _7063_/B _7063_/C VGND VGND VPWR VPWR _7063_/X sky130_fd_sc_hd__and3_4
Xfanout339 _6426_/A VGND VGND VPWR VPWR _5804_/B sky130_fd_sc_hd__clkdlybuf4s25_1
XFILLER_99_698 VGND VGND VPWR VPWR sky130_fd_sc_hd__decap_3
XFILLER_59_529 VGND VGND VPWR VPWR sky130_fd_sc_hd__decap_3
XFILLER_101_626 VGND VGND VPWR VPWR sky130_fd_sc_hd__decap_3
XFILLER_100_103 VGND VGND VPWR VPWR sky130_fd_sc_hd__fill_1
XFILLER_86_326 VGND VGND VPWR VPWR sky130_fd_sc_hd__decap_3
XFILLER_98_197 VGND VGND VPWR VPWR sky130_fd_sc_hd__decap_3
X_6014_ _5840_/A _5841_/A _5840_/B VGND VGND VPWR VPWR _6014_/X sky130_fd_sc_hd__o21ba_2
XFILLER_86_359 VGND VGND VPWR VPWR sky130_fd_sc_hd__decap_3
XFILLER_67_540 VGND VGND VPWR VPWR sky130_fd_sc_hd__decap_3
XFILLER_67_573 VGND VGND VPWR VPWR sky130_fd_sc_hd__decap_3
XFILLER_27_415 VGND VGND VPWR VPWR sky130_fd_sc_hd__decap_3
XFILLER_67_595 VGND VGND VPWR VPWR sky130_fd_sc_hd__fill_1
XFILLER_55_735 VGND VGND VPWR VPWR sky130_fd_sc_hd__decap_3
XFILLER_55_768 VGND VGND VPWR VPWR sky130_fd_sc_hd__decap_3
X_7965_ _7965_/A _7965_/B VGND VGND VPWR VPWR _7977_/A sky130_fd_sc_hd__xnor2_2
XFILLER_42_407 VGND VGND VPWR VPWR sky130_fd_sc_hd__decap_3
XTAP_TAPCELL_ROW_25_616 VGND VPWR sky130_fd_sc_hd__tapvpwrvgnd_1
XFILLER_82_587 VGND VGND VPWR VPWR sky130_fd_sc_hd__fill_1
XFILLER_23_610 VGND VGND VPWR VPWR sky130_fd_sc_hd__decap_3
XFILLER_70_749 VGND VGND VPWR VPWR sky130_fd_sc_hd__decap_3
X_7896_ _7997_/A _7997_/B VGND VGND VPWR VPWR _7897_/B sky130_fd_sc_hd__xnor2_2
XFILLER_52_27 VGND VGND VPWR VPWR sky130_fd_sc_hd__fill_1
X_6847_ _6859_/A _6843_/A _6856_/A _6846_/X _7729_/C1 VGND VGND VPWR VPWR _6899_/B
+ sky130_fd_sc_hd__a32o_2
XPHY_EDGE_ROW_99_Left_230 VGND VGND VPWR VPWR sky130_fd_sc_hd__decap_3
XFILLER_50_473 VGND VGND VPWR VPWR sky130_fd_sc_hd__decap_3
XFILLER_10_315 VGND VGND VPWR VPWR sky130_fd_sc_hd__decap_3
X_6778_ _6778_/A _6778_/B _6778_/C VGND VGND VPWR VPWR _6905_/A sky130_fd_sc_hd__and3_2
X_5729_ _5729_/A _5729_/B VGND VGND VPWR VPWR _5752_/A sky130_fd_sc_hd__nand2_2
X_8517_ _8515_/B _8737_/A _8547_/B VGND VGND VPWR VPWR _8517_/X sky130_fd_sc_hd__mux2_2
XFILLER_109_726 VGND VGND VPWR VPWR sky130_fd_sc_hd__fill_2
XFILLER_108_236 VGND VGND VPWR VPWR sky130_fd_sc_hd__decap_3
X_8448_ _9221_/Q _8446_/A _8447_/X VGND VGND VPWR VPWR _8448_/X sky130_fd_sc_hd__a21o_2
XFILLER_124_707 VGND VGND VPWR VPWR sky130_fd_sc_hd__decap_3
X_8379_ _8379_/A _8379_/B VGND VGND VPWR VPWR _8379_/X sky130_fd_sc_hd__or2_2
XFILLER_2_503 VGND VGND VPWR VPWR sky130_fd_sc_hd__decap_3
XFILLER_123_217 VGND VGND VPWR VPWR sky130_fd_sc_hd__decap_3
XFILLER_2_536 VGND VGND VPWR VPWR sky130_fd_sc_hd__decap_3
XFILLER_117_42 VGND VGND VPWR VPWR sky130_fd_sc_hd__decap_3
XFILLER_116_291 VGND VGND VPWR VPWR sky130_fd_sc_hd__decap_3
XFILLER_117_75 VGND VGND VPWR VPWR sky130_fd_sc_hd__decap_3
XFILLER_77_35 VGND VGND VPWR VPWR sky130_fd_sc_hd__decap_3
XFILLER_89_186 VGND VGND VPWR VPWR sky130_fd_sc_hd__decap_3
XFILLER_77_57 VGND VGND VPWR VPWR sky130_fd_sc_hd__decap_3
XFILLER_77_68 VGND VGND VPWR VPWR sky130_fd_sc_hd__fill_1
XTAP_TAPCELL_ROW_5_352 VGND VPWR sky130_fd_sc_hd__tapvpwrvgnd_1
XFILLER_92_307 VGND VGND VPWR VPWR sky130_fd_sc_hd__fill_1
XFILLER_58_573 VGND VGND VPWR VPWR sky130_fd_sc_hd__decap_3
Xhold1060 _9037_/Q VGND VGND VPWR VPWR _4604_/A1 sky130_fd_sc_hd__dlygate4sd3_1
XFILLER_58_595 VGND VGND VPWR VPWR sky130_fd_sc_hd__decap_3
Xhold1071 _9332_/Q VGND VGND VPWR VPWR _9015_/A1 sky130_fd_sc_hd__dlygate4sd3_1
XFILLER_85_381 VGND VGND VPWR VPWR sky130_fd_sc_hd__decap_3
XFILLER_73_521 VGND VGND VPWR VPWR sky130_fd_sc_hd__decap_3
XFILLER_45_212 VGND VGND VPWR VPWR sky130_fd_sc_hd__decap_3
XFILLER_18_437 VGND VGND VPWR VPWR sky130_fd_sc_hd__decap_3
Xhold1082 _8970_/X VGND VGND VPWR VPWR _8971_/A sky130_fd_sc_hd__dlygate4sd3_1
Xhold1093 _9330_/Q VGND VGND VPWR VPWR _9011_/A1 sky130_fd_sc_hd__dlygate4sd3_1
XFILLER_45_245 VGND VGND VPWR VPWR sky130_fd_sc_hd__decap_3
XFILLER_33_407 VGND VGND VPWR VPWR sky130_fd_sc_hd__decap_3
XFILLER_73_587 VGND VGND VPWR VPWR sky130_fd_sc_hd__decap_3
XFILLER_60_259 VGND VGND VPWR VPWR sky130_fd_sc_hd__decap_3
XFILLER_13_120 VGND VGND VPWR VPWR sky130_fd_sc_hd__decap_3
XFILLER_14_665 VGND VGND VPWR VPWR sky130_fd_sc_hd__decap_3
XFILLER_41_462 VGND VGND VPWR VPWR sky130_fd_sc_hd__fill_2
XTAP_TAPCELL_ROW_52_980 VGND VPWR sky130_fd_sc_hd__tapvpwrvgnd_1
XFILLER_9_113 VGND VGND VPWR VPWR sky130_fd_sc_hd__decap_3
XFILLER_14_698 VGND VGND VPWR VPWR sky130_fd_sc_hd__fill_2
XFILLER_9_135 VGND VGND VPWR VPWR sky130_fd_sc_hd__decap_3
XFILLER_13_186 VGND VGND VPWR VPWR sky130_fd_sc_hd__decap_3
XFILLER_9_157 VGND VGND VPWR VPWR sky130_fd_sc_hd__decap_3
XFILLER_5_330 VGND VGND VPWR VPWR sky130_fd_sc_hd__decap_3
XFILLER_127_556 VGND VGND VPWR VPWR sky130_fd_sc_hd__decap_3
Xrebuffer490 _6719_/Y VGND VGND VPWR VPWR _7014_/B sky130_fd_sc_hd__buf_2
XFILLER_5_352 VGND VGND VPWR VPWR sky130_fd_sc_hd__decap_3
XFILLER_127_589 VGND VGND VPWR VPWR sky130_fd_sc_hd__decap_3
XFILLER_115_729 VGND VGND VPWR VPWR sky130_fd_sc_hd__fill_1
XFILLER_114_206 VGND VGND VPWR VPWR sky130_fd_sc_hd__decap_3
XTAP_TAPCELL_ROW_114_1821 VGND VPWR sky130_fd_sc_hd__tapvpwrvgnd_1
XFILLER_5_374 VGND VGND VPWR VPWR sky130_fd_sc_hd__decap_3
XFILLER_47_6 VGND VGND VPWR VPWR sky130_fd_sc_hd__decap_3
XFILLER_123_762 VGND VGND VPWR VPWR sky130_fd_sc_hd__decap_3
XFILLER_3_21 VGND VGND VPWR VPWR sky130_fd_sc_hd__decap_3
XFILLER_68_315 VGND VGND VPWR VPWR sky130_fd_sc_hd__decap_3
XFILLER_3_54 VGND VGND VPWR VPWR sky130_fd_sc_hd__fill_2
XFILLER_96_657 VGND VGND VPWR VPWR sky130_fd_sc_hd__decap_3
XFILLER_1_591 VGND VGND VPWR VPWR sky130_fd_sc_hd__decap_3
XFILLER_110_445 VGND VGND VPWR VPWR sky130_fd_sc_hd__decap_3
XFILLER_3_87 VGND VGND VPWR VPWR sky130_fd_sc_hd__decap_3
XFILLER_49_551 VGND VGND VPWR VPWR sky130_fd_sc_hd__decap_3
XFILLER_110_467 VGND VGND VPWR VPWR sky130_fd_sc_hd__decap_3
XFILLER_95_167 VGND VGND VPWR VPWR sky130_fd_sc_hd__fill_1
XFILLER_83_329 VGND VGND VPWR VPWR sky130_fd_sc_hd__fill_1
XFILLER_64_510 VGND VGND VPWR VPWR sky130_fd_sc_hd__decap_3
XFILLER_49_584 VGND VGND VPWR VPWR sky130_fd_sc_hd__decap_3
XFILLER_76_381 VGND VGND VPWR VPWR sky130_fd_sc_hd__decap_3
XFILLER_64_576 VGND VGND VPWR VPWR sky130_fd_sc_hd__decap_3
XFILLER_64_587 VGND VGND VPWR VPWR sky130_fd_sc_hd__fill_1
XFILLER_52_727 VGND VGND VPWR VPWR sky130_fd_sc_hd__fill_2
XFILLER_64_598 VGND VGND VPWR VPWR sky130_fd_sc_hd__decap_3
XFILLER_52_738 VGND VGND VPWR VPWR sky130_fd_sc_hd__decap_3
X_4962_ _9238_/Q _5743_/B VGND VGND VPWR VPWR _4975_/B sky130_fd_sc_hd__nor2_2
X_7750_ _7856_/A _7750_/B VGND VGND VPWR VPWR wire39/A sky130_fd_sc_hd__xnor2_2
XTAP_TAPCELL_ROW_125_1972 VGND VPWR sky130_fd_sc_hd__tapvpwrvgnd_1
XFILLER_51_215 VGND VGND VPWR VPWR sky130_fd_sc_hd__decap_3
X_6701_ _6924_/A _6701_/B _6701_/C VGND VGND VPWR VPWR _6912_/A sky130_fd_sc_hd__nand3_2
X_7681_ _7681_/A _7681_/B VGND VGND VPWR VPWR _7682_/B sky130_fd_sc_hd__xnor2_2
X_4893_ _9218_/Q _4899_/B VGND VGND VPWR VPWR _4893_/Y sky130_fd_sc_hd__nor2_2
XFILLER_60_760 VGND VGND VPWR VPWR sky130_fd_sc_hd__fill_2
X_6632_ _6632_/A _6632_/B VGND VGND VPWR VPWR _6632_/Y sky130_fd_sc_hd__nor2_2
XFILLER_32_495 VGND VGND VPWR VPWR sky130_fd_sc_hd__fill_1
XFILLER_20_657 VGND VGND VPWR VPWR sky130_fd_sc_hd__decap_3
X_6563_ _6563_/A _6563_/B VGND VGND VPWR VPWR _6668_/B sky130_fd_sc_hd__or2_4
X_5514_ _5514_/A _6807_/A VGND VGND VPWR VPWR _5514_/Y sky130_fd_sc_hd__nor2_2
X_8302_ _8277_/A _8296_/X _8301_/X VGND VGND VPWR VPWR _8388_/A sky130_fd_sc_hd__a21o_2
XFILLER_9_691 VGND VGND VPWR VPWR sky130_fd_sc_hd__decap_3
X_9282_ _9346_/CLK _9282_/D load_slew397/X VGND VGND VPWR VPWR _9282_/Q sky130_fd_sc_hd__dfrtp_2
XTAP_TAPCELL_ROW_30_685 VGND VPWR sky130_fd_sc_hd__tapvpwrvgnd_1
X_6494_ _6494_/A _6494_/B VGND VGND VPWR VPWR _6495_/A sky130_fd_sc_hd__xnor2_4
XTAP_TAPCELL_ROW_76_1304 VGND VPWR sky130_fd_sc_hd__tapvpwrvgnd_1
XFILLER_106_707 VGND VGND VPWR VPWR sky130_fd_sc_hd__fill_2
XFILLER_106_718 VGND VGND VPWR VPWR sky130_fd_sc_hd__decap_3
XFILLER_118_578 VGND VGND VPWR VPWR sky130_fd_sc_hd__decap_3
X_8233_ _8229_/B _8231_/Y _8322_/B _8233_/B2 _8047_/S VGND VGND VPWR VPWR _8233_/X
+ sky130_fd_sc_hd__o221a_2
XFILLER_105_206 VGND VGND VPWR VPWR sky130_fd_sc_hd__decap_3
X_5445_ _5443_/A _5444_/Y _7794_/B VGND VGND VPWR VPWR _5446_/B sky130_fd_sc_hd__a21oi_2
XFILLER_118_589 VGND VGND VPWR VPWR sky130_fd_sc_hd__decap_3
XFILLER_105_228 VGND VGND VPWR VPWR sky130_fd_sc_hd__decap_3
X_8164_ _7604_/A _7065_/B _8050_/B VGND VGND VPWR VPWR _8165_/C sky130_fd_sc_hd__a21o_2
X_5376_ _5463_/C _5624_/B _5376_/C VGND VGND VPWR VPWR _5376_/X sky130_fd_sc_hd__and3_2
XFILLER_87_602 VGND VGND VPWR VPWR sky130_fd_sc_hd__fill_1
X_7115_ _7117_/B VGND VGND VPWR VPWR _8345_/A sky130_fd_sc_hd__clkbuf_2
XFILLER_101_401 VGND VGND VPWR VPWR sky130_fd_sc_hd__decap_3
XFILLER_99_473 VGND VGND VPWR VPWR sky130_fd_sc_hd__decap_3
X_8095_ _7979_/A _7979_/B _7983_/B VGND VGND VPWR VPWR _8095_/X sky130_fd_sc_hd__o21a_2
XFILLER_113_261 VGND VGND VPWR VPWR sky130_fd_sc_hd__decap_3
XFILLER_87_635 VGND VGND VPWR VPWR sky130_fd_sc_hd__fill_1
XFILLER_86_112 VGND VGND VPWR VPWR sky130_fd_sc_hd__decap_3
XFILLER_59_337 VGND VGND VPWR VPWR sky130_fd_sc_hd__decap_3
XFILLER_87_657 VGND VGND VPWR VPWR sky130_fd_sc_hd__decap_3
X_7046_ _7295_/C _7046_/B VGND VGND VPWR VPWR _7047_/A sky130_fd_sc_hd__xnor2_4
XFILLER_101_456 VGND VGND VPWR VPWR sky130_fd_sc_hd__decap_3
XFILLER_74_307 VGND VGND VPWR VPWR sky130_fd_sc_hd__fill_1
XFILLER_101_478 VGND VGND VPWR VPWR sky130_fd_sc_hd__decap_3
XTAP_TAPCELL_ROW_2_311 VGND VPWR sky130_fd_sc_hd__tapvpwrvgnd_1
XFILLER_86_189 VGND VGND VPWR VPWR sky130_fd_sc_hd__fill_1
XFILLER_28_757 VGND VGND VPWR VPWR sky130_fd_sc_hd__decap_3
XFILLER_55_543 VGND VGND VPWR VPWR sky130_fd_sc_hd__decap_3
XTAP_TAPCELL_ROW_87_1455 VGND VPWR sky130_fd_sc_hd__tapvpwrvgnd_1
XFILLER_82_340 VGND VGND VPWR VPWR sky130_fd_sc_hd__decap_3
X_8997_ hold932/X _8997_/A1 _9009_/S VGND VGND VPWR VPWR _8998_/A sky130_fd_sc_hd__mux2_2
XFILLER_55_576 VGND VGND VPWR VPWR sky130_fd_sc_hd__decap_3
XFILLER_103_66 VGND VGND VPWR VPWR sky130_fd_sc_hd__decap_3
XFILLER_63_37 VGND VGND VPWR VPWR sky130_fd_sc_hd__decap_3
X_7948_ _8239_/A _7948_/B _7948_/C VGND VGND VPWR VPWR _7949_/B sky130_fd_sc_hd__or3_2
XTAP_TAPCELL_ROW_38_796 VGND VPWR sky130_fd_sc_hd__tapvpwrvgnd_1
XFILLER_43_749 VGND VGND VPWR VPWR sky130_fd_sc_hd__decap_3
XFILLER_70_579 VGND VGND VPWR VPWR sky130_fd_sc_hd__fill_2
X_7879_ _7885_/B _7881_/C _7877_/X _7878_/X VGND VGND VPWR VPWR _7879_/X sky130_fd_sc_hd__o211a_2
XFILLER_23_462 VGND VGND VPWR VPWR sky130_fd_sc_hd__decap_3
XFILLER_11_602 VGND VGND VPWR VPWR sky130_fd_sc_hd__decap_3
XFILLER_10_123 VGND VGND VPWR VPWR sky130_fd_sc_hd__decap_3
XFILLER_7_617 VGND VGND VPWR VPWR sky130_fd_sc_hd__decap_3
XFILLER_109_545 VGND VGND VPWR VPWR sky130_fd_sc_hd__decap_3
XFILLER_12_41 VGND VGND VPWR VPWR sky130_fd_sc_hd__decap_3
XFILLER_128_41 VGND VGND VPWR VPWR sky130_fd_sc_hd__decap_3
XFILLER_128_74 VGND VGND VPWR VPWR sky130_fd_sc_hd__decap_3
XFILLER_128_85 VGND VGND VPWR VPWR sky130_fd_sc_hd__decap_3
XFILLER_105_740 VGND VGND VPWR VPWR sky130_fd_sc_hd__decap_3
XFILLER_78_602 VGND VGND VPWR VPWR sky130_fd_sc_hd__decap_3
XFILLER_2_355 VGND VGND VPWR VPWR sky130_fd_sc_hd__fill_1
XFILLER_111_209 VGND VGND VPWR VPWR sky130_fd_sc_hd__decap_3
XFILLER_78_624 VGND VGND VPWR VPWR sky130_fd_sc_hd__decap_3
XFILLER_120_710 VGND VGND VPWR VPWR sky130_fd_sc_hd__decap_3
XFILLER_120_743 VGND VGND VPWR VPWR sky130_fd_sc_hd__decap_3
XFILLER_78_668 VGND VGND VPWR VPWR sky130_fd_sc_hd__decap_3
XFILLER_19_713 VGND VGND VPWR VPWR sky130_fd_sc_hd__decap_3
XFILLER_93_649 VGND VGND VPWR VPWR sky130_fd_sc_hd__decap_3
XFILLER_19_735 VGND VGND VPWR VPWR sky130_fd_sc_hd__decap_3
XFILLER_86_690 VGND VGND VPWR VPWR sky130_fd_sc_hd__fill_2
XFILLER_18_212 VGND VGND VPWR VPWR sky130_fd_sc_hd__decap_3
XFILLER_18_234 VGND VGND VPWR VPWR sky130_fd_sc_hd__decap_3
XFILLER_19_768 VGND VGND VPWR VPWR sky130_fd_sc_hd__decap_3
XPHY_EDGE_ROW_16_Right_16 VGND VGND VPWR VPWR sky130_fd_sc_hd__decap_3
XFILLER_73_340 VGND VGND VPWR VPWR sky130_fd_sc_hd__decap_3
XFILLER_46_576 VGND VGND VPWR VPWR sky130_fd_sc_hd__decap_3
XFILLER_73_384 VGND VGND VPWR VPWR sky130_fd_sc_hd__fill_2
XFILLER_61_535 VGND VGND VPWR VPWR sky130_fd_sc_hd__fill_1
XFILLER_61_546 VGND VGND VPWR VPWR sky130_fd_sc_hd__decap_3
XFILLER_33_259 VGND VGND VPWR VPWR sky130_fd_sc_hd__decap_3
XFILLER_42_760 VGND VGND VPWR VPWR sky130_fd_sc_hd__fill_2
XFILLER_53_81 VGND VGND VPWR VPWR sky130_fd_sc_hd__decap_3
XFILLER_41_281 VGND VGND VPWR VPWR sky130_fd_sc_hd__decap_3
XFILLER_119_309 VGND VGND VPWR VPWR sky130_fd_sc_hd__decap_3
XPHY_EDGE_ROW_25_Right_25 VGND VGND VPWR VPWR sky130_fd_sc_hd__decap_3
XFILLER_127_364 VGND VGND VPWR VPWR sky130_fd_sc_hd__decap_3
XFILLER_6_672 VGND VGND VPWR VPWR sky130_fd_sc_hd__decap_3
XFILLER_115_537 VGND VGND VPWR VPWR sky130_fd_sc_hd__decap_3
X_5230_ _5219_/Y _5228_/Y _5229_/X VGND VGND VPWR VPWR _5230_/Y sky130_fd_sc_hd__a21oi_2
XTAP_TAPCELL_ROW_58_1067 VGND VPWR sky130_fd_sc_hd__tapvpwrvgnd_1
XFILLER_5_193 VGND VGND VPWR VPWR sky130_fd_sc_hd__decap_3
XFILLER_45_3 VGND VGND VPWR VPWR sky130_fd_sc_hd__decap_3
X_5161_ _5045_/A _5159_/X _5160_/X VGND VGND VPWR VPWR _5162_/B sky130_fd_sc_hd__o21ai_2
XTAP_TAPCELL_ROW_71_1234 VGND VPWR sky130_fd_sc_hd__tapvpwrvgnd_1
XFILLER_69_635 VGND VGND VPWR VPWR sky130_fd_sc_hd__decap_3
XFILLER_68_101 VGND VGND VPWR VPWR sky130_fd_sc_hd__decap_3
XFILLER_123_581 VGND VGND VPWR VPWR sky130_fd_sc_hd__decap_3
XFILLER_111_721 VGND VGND VPWR VPWR sky130_fd_sc_hd__decap_3
XTAP_TAPCELL_ROW_71_1245 VGND VPWR sky130_fd_sc_hd__tapvpwrvgnd_1
XFILLER_96_421 VGND VGND VPWR VPWR sky130_fd_sc_hd__decap_3
XFILLER_111_732 VGND VGND VPWR VPWR sky130_fd_sc_hd__decap_3
XFILLER_110_220 VGND VGND VPWR VPWR sky130_fd_sc_hd__decap_3
X_5092_ _5092_/A VGND VGND VPWR VPWR _9198_/D sky130_fd_sc_hd__buf_1
XFILLER_110_253 VGND VGND VPWR VPWR sky130_fd_sc_hd__decap_3
X_8920_ _8920_/A VGND VGND VPWR VPWR _9302_/D sky130_fd_sc_hd__buf_1
XFILLER_84_638 VGND VGND VPWR VPWR sky130_fd_sc_hd__decap_3
XPHY_EDGE_ROW_34_Right_34 VGND VGND VPWR VPWR sky130_fd_sc_hd__decap_3
XFILLER_37_532 VGND VGND VPWR VPWR sky130_fd_sc_hd__decap_3
X_8851_ _8851_/A VGND VGND VPWR VPWR _9269_/D sky130_fd_sc_hd__buf_1
XFILLER_92_660 VGND VGND VPWR VPWR sky130_fd_sc_hd__decap_3
XFILLER_52_502 VGND VGND VPWR VPWR sky130_fd_sc_hd__decap_3
XFILLER_25_716 VGND VGND VPWR VPWR sky130_fd_sc_hd__decap_3
X_7802_ _7448_/A _7448_/B _7449_/A VGND VGND VPWR VPWR _7802_/X sky130_fd_sc_hd__o21a_2
XFILLER_92_693 VGND VGND VPWR VPWR sky130_fd_sc_hd__decap_3
X_5994_ _9125_/Q _5056_/X _5126_/X _9141_/Q VGND VGND VPWR VPWR _5998_/A sky130_fd_sc_hd__a22o_2
X_8782_ _8780_/A _4956_/B _8780_/B VGND VGND VPWR VPWR _8783_/C sky130_fd_sc_hd__o21ai_2
XTAP_TAPCELL_ROW_35_755 VGND VPWR sky130_fd_sc_hd__tapvpwrvgnd_1
XFILLER_24_259 VGND VGND VPWR VPWR sky130_fd_sc_hd__decap_3
X_4945_ _8778_/A VGND VGND VPWR VPWR _6027_/B sky130_fd_sc_hd__inv_6
X_7733_ _8034_/A _8006_/A VGND VGND VPWR VPWR _7734_/B sky130_fd_sc_hd__or2_2
XFILLER_40_719 VGND VGND VPWR VPWR sky130_fd_sc_hd__decap_3
XTAP_TAPCELL_ROW_82_1385 VGND VPWR sky130_fd_sc_hd__tapvpwrvgnd_1
X_4876_ _4876_/A VGND VGND VPWR VPWR _4876_/X sky130_fd_sc_hd__buf_1
X_7664_ _7549_/B _7655_/X _7658_/X _7663_/X VGND VGND VPWR VPWR _7744_/A sky130_fd_sc_hd__o211a_2
XFILLER_20_421 VGND VGND VPWR VPWR sky130_fd_sc_hd__decap_3
XTAP_TAPCELL_ROW_15_490 VGND VPWR sky130_fd_sc_hd__tapvpwrvgnd_1
X_6615_ _9252_/Q _6751_/A2 _6613_/X _6614_/X VGND VGND VPWR VPWR _6741_/B sky130_fd_sc_hd__a211oi_4
X_7595_ _7960_/C VGND VGND VPWR VPWR _7784_/B sky130_fd_sc_hd__clkbuf_1
XPHY_EDGE_ROW_43_Right_43 VGND VGND VPWR VPWR sky130_fd_sc_hd__decap_3
XFILLER_20_487 VGND VGND VPWR VPWR sky130_fd_sc_hd__decap_3
X_6546_ wire122/X _6546_/A2 _6992_/A VGND VGND VPWR VPWR _6547_/B sky130_fd_sc_hd__a21oi_2
X_9334_ _9334_/CLK _9334_/D wire417/X VGND VGND VPWR VPWR _9334_/Q sky130_fd_sc_hd__dfrtp_2
XFILLER_116_9 VGND VGND VPWR VPWR sky130_fd_sc_hd__decap_3
XFILLER_3_108 VGND VGND VPWR VPWR sky130_fd_sc_hd__decap_3
X_6477_ _5950_/X _6096_/B _6478_/S VGND VGND VPWR VPWR _6477_/X sky130_fd_sc_hd__mux2_2
X_9265_ _9308_/CLK _9265_/D fanout367/X VGND VGND VPWR VPWR _9265_/Q sky130_fd_sc_hd__dfrtp_2
XFILLER_3_119 VGND VGND VPWR VPWR sky130_fd_sc_hd__decap_3
XFILLER_118_386 VGND VGND VPWR VPWR sky130_fd_sc_hd__decap_3
XFILLER_106_548 VGND VGND VPWR VPWR sky130_fd_sc_hd__decap_3
XPHY_EDGE_ROW_18_Left_149 VGND VGND VPWR VPWR sky130_fd_sc_hd__decap_3
X_5428_ _5439_/S _5357_/X _5427_/X VGND VGND VPWR VPWR _5576_/B sky130_fd_sc_hd__a21o_2
X_8216_ _8216_/A _8216_/B VGND VGND VPWR VPWR _8217_/B sky130_fd_sc_hd__and2_2
X_9196_ clkload7/A _9196_/D fanout375/X VGND VGND VPWR VPWR _9196_/Q sky130_fd_sc_hd__dfrtp_2
X_5359_ _5356_/A _8080_/A _8137_/A VGND VGND VPWR VPWR _5359_/X sky130_fd_sc_hd__a21o_2
X_8147_ _8217_/A _8218_/B VGND VGND VPWR VPWR _8148_/B sky130_fd_sc_hd__xor2_2
X_8078_ _8078_/A _8078_/B VGND VGND VPWR VPWR _8131_/A sky130_fd_sc_hd__xnor2_2
XPHY_EDGE_ROW_52_Right_52 VGND VGND VPWR VPWR sky130_fd_sc_hd__decap_3
XFILLER_59_167 VGND VGND VPWR VPWR sky130_fd_sc_hd__fill_1
XFILLER_114_21 VGND VGND VPWR VPWR sky130_fd_sc_hd__decap_3
XFILLER_59_178 VGND VGND VPWR VPWR sky130_fd_sc_hd__decap_3
XFILLER_114_32 VGND VGND VPWR VPWR sky130_fd_sc_hd__decap_3
X_7029_ _7029_/A _7029_/B VGND VGND VPWR VPWR _7029_/Y sky130_fd_sc_hd__nor2_2
XFILLER_68_690 VGND VGND VPWR VPWR sky130_fd_sc_hd__decap_3
XFILLER_114_65 VGND VGND VPWR VPWR sky130_fd_sc_hd__decap_3
XFILLER_74_159 VGND VGND VPWR VPWR sky130_fd_sc_hd__decap_3
XFILLER_55_340 VGND VGND VPWR VPWR sky130_fd_sc_hd__decap_3
XFILLER_74_47 VGND VGND VPWR VPWR sky130_fd_sc_hd__fill_1
XFILLER_16_716 VGND VGND VPWR VPWR sky130_fd_sc_hd__decap_3
XPHY_EDGE_ROW_27_Left_158 VGND VGND VPWR VPWR sky130_fd_sc_hd__decap_3
XFILLER_55_373 VGND VGND VPWR VPWR sky130_fd_sc_hd__decap_3
XFILLER_28_598 VGND VGND VPWR VPWR sky130_fd_sc_hd__decap_3
XFILLER_15_215 VGND VGND VPWR VPWR sky130_fd_sc_hd__decap_3
XFILLER_43_535 VGND VGND VPWR VPWR sky130_fd_sc_hd__fill_1
XFILLER_16_749 VGND VGND VPWR VPWR sky130_fd_sc_hd__decap_3
XFILLER_130_53 VGND VGND VPWR VPWR sky130_fd_sc_hd__decap_3
XFILLER_70_365 VGND VGND VPWR VPWR sky130_fd_sc_hd__fill_1
XFILLER_24_760 VGND VGND VPWR VPWR sky130_fd_sc_hd__decap_3
XFILLER_130_75 VGND VGND VPWR VPWR sky130_fd_sc_hd__decap_3
XFILLER_130_97 VGND VGND VPWR VPWR sky130_fd_sc_hd__decap_3
XPHY_EDGE_ROW_61_Right_61 VGND VGND VPWR VPWR sky130_fd_sc_hd__decap_3
XFILLER_90_68 VGND VGND VPWR VPWR sky130_fd_sc_hd__decap_3
XFILLER_51_590 VGND VGND VPWR VPWR sky130_fd_sc_hd__decap_3
XFILLER_23_281 VGND VGND VPWR VPWR sky130_fd_sc_hd__decap_3
XFILLER_11_432 VGND VGND VPWR VPWR sky130_fd_sc_hd__decap_3
XFILLER_129_629 VGND VGND VPWR VPWR sky130_fd_sc_hd__decap_3
XFILLER_128_106 VGND VGND VPWR VPWR sky130_fd_sc_hd__decap_3
XFILLER_7_414 VGND VGND VPWR VPWR sky130_fd_sc_hd__fill_1
XFILLER_23_73 VGND VGND VPWR VPWR sky130_fd_sc_hd__decap_3
XFILLER_109_320 VGND VGND VPWR VPWR sky130_fd_sc_hd__fill_2
XFILLER_128_139 VGND VGND VPWR VPWR sky130_fd_sc_hd__fill_1
XPHY_EDGE_ROW_36_Left_167 VGND VGND VPWR VPWR sky130_fd_sc_hd__decap_3
XFILLER_3_620 VGND VGND VPWR VPWR sky130_fd_sc_hd__decap_3
XFILLER_98_719 VGND VGND VPWR VPWR sky130_fd_sc_hd__fill_1
XFILLER_3_653 VGND VGND VPWR VPWR sky130_fd_sc_hd__decap_3
XFILLER_2_130 VGND VGND VPWR VPWR sky130_fd_sc_hd__decap_3
XFILLER_2_141 VGND VGND VPWR VPWR sky130_fd_sc_hd__fill_1
XPHY_EDGE_ROW_70_Right_70 VGND VGND VPWR VPWR sky130_fd_sc_hd__decap_3
XFILLER_78_421 VGND VGND VPWR VPWR sky130_fd_sc_hd__fill_1
XFILLER_3_697 VGND VGND VPWR VPWR sky130_fd_sc_hd__decap_3
XFILLER_78_432 VGND VGND VPWR VPWR sky130_fd_sc_hd__decap_3
XFILLER_66_627 VGND VGND VPWR VPWR sky130_fd_sc_hd__decap_3
XFILLER_120_573 VGND VGND VPWR VPWR sky130_fd_sc_hd__decap_3
XPHY_EDGE_ROW_45_Left_176 VGND VGND VPWR VPWR sky130_fd_sc_hd__decap_3
XFILLER_19_543 VGND VGND VPWR VPWR sky130_fd_sc_hd__decap_3
XTAP_TAPCELL_ROW_109_1753 VGND VPWR sky130_fd_sc_hd__tapvpwrvgnd_1
XFILLER_93_479 VGND VGND VPWR VPWR sky130_fd_sc_hd__decap_3
XFILLER_0_44 VGND VGND VPWR VPWR sky130_fd_sc_hd__decap_3
XFILLER_46_362 VGND VGND VPWR VPWR sky130_fd_sc_hd__fill_2
XFILLER_19_576 VGND VGND VPWR VPWR sky130_fd_sc_hd__decap_3
XFILLER_19_598 VGND VGND VPWR VPWR sky130_fd_sc_hd__decap_3
XTAP_TAPCELL_ROW_122_1931 VGND VPWR sky130_fd_sc_hd__tapvpwrvgnd_1
XFILLER_61_343 VGND VGND VPWR VPWR sky130_fd_sc_hd__decap_3
XFILLER_34_579 VGND VGND VPWR VPWR sky130_fd_sc_hd__fill_1
XFILLER_22_719 VGND VGND VPWR VPWR sky130_fd_sc_hd__decap_3
XFILLER_61_376 VGND VGND VPWR VPWR sky130_fd_sc_hd__decap_3
XFILLER_15_771 VGND VGND VPWR VPWR sky130_fd_sc_hd__decap_3
XTAP_TAPCELL_ROW_32_714 VGND VPWR sky130_fd_sc_hd__tapvpwrvgnd_1
XFILLER_21_218 VGND VGND VPWR VPWR sky130_fd_sc_hd__decap_3
X_4730_ _4730_/A VGND VGND VPWR VPWR _9112_/D sky130_fd_sc_hd__buf_1
XFILLER_9_42 VGND VGND VPWR VPWR sky130_fd_sc_hd__decap_3
XFILLER_14_281 VGND VGND VPWR VPWR sky130_fd_sc_hd__decap_3
X_4661_ _4661_/A VGND VGND VPWR VPWR _9079_/D sky130_fd_sc_hd__buf_1
XFILLER_30_763 VGND VGND VPWR VPWR sky130_fd_sc_hd__decap_3
XFILLER_9_97 VGND VGND VPWR VPWR sky130_fd_sc_hd__decap_3
XFILLER_119_128 VGND VGND VPWR VPWR sky130_fd_sc_hd__decap_3
X_6400_ _5317_/A _6083_/X _6116_/B _5095_/X VGND VGND VPWR VPWR _6400_/X sky130_fd_sc_hd__o2bb2a_2
XPHY_EDGE_ROW_54_Left_185 VGND VGND VPWR VPWR sky130_fd_sc_hd__decap_3
X_7380_ _7496_/B _7380_/B VGND VGND VPWR VPWR _7380_/X sky130_fd_sc_hd__and2_2
XFILLER_128_640 VGND VGND VPWR VPWR sky130_fd_sc_hd__decap_3
X_4592_ hold977/X _4592_/A1 _4608_/S VGND VGND VPWR VPWR _4593_/A sky130_fd_sc_hd__mux2_2
XFILLER_128_651 VGND VGND VPWR VPWR sky130_fd_sc_hd__decap_3
X_6331_ _9031_/Q _6608_/C _6756_/C _5457_/X _9299_/Q VGND VGND VPWR VPWR _6331_/X
+ sky130_fd_sc_hd__a32o_2
Xhold904 _9346_/Q VGND VGND VPWR VPWR hold904/X sky130_fd_sc_hd__dlygate4sd3_1
XFILLER_128_684 VGND VGND VPWR VPWR sky130_fd_sc_hd__decap_3
XFILLER_127_161 VGND VGND VPWR VPWR sky130_fd_sc_hd__decap_3
Xhold915 _8925_/X VGND VGND VPWR VPWR _8926_/A sky130_fd_sc_hd__dlygate4sd3_1
XFILLER_127_172 VGND VGND VPWR VPWR sky130_fd_sc_hd__decap_3
Xhold926 _9026_/Q VGND VGND VPWR VPWR hold926/X sky130_fd_sc_hd__dlygate4sd3_1
XFILLER_115_323 VGND VGND VPWR VPWR sky130_fd_sc_hd__fill_2
Xhold937 _9258_/Q VGND VGND VPWR VPWR hold937/X sky130_fd_sc_hd__dlygate4sd3_1
XFILLER_6_480 VGND VGND VPWR VPWR sky130_fd_sc_hd__decap_3
Xhold948 _4805_/X VGND VGND VPWR VPWR _4806_/A sky130_fd_sc_hd__dlygate4sd3_1
X_9050_ _9335_/CLK _9050_/D fanout400/X VGND VGND VPWR VPWR _9050_/Q sky130_fd_sc_hd__dfrtp_2
X_6262_ _6262_/A _6262_/B VGND VGND VPWR VPWR _6263_/B sky130_fd_sc_hd__xnor2_4
Xhold959 _4840_/X VGND VGND VPWR VPWR _4841_/A sky130_fd_sc_hd__dlygate4sd3_1
X_5213_ _5152_/A _5167_/Y _5213_/S VGND VGND VPWR VPWR _5213_/X sky130_fd_sc_hd__mux2_2
X_8001_ _7997_/A _7997_/B _8000_/X VGND VGND VPWR VPWR _8044_/B sky130_fd_sc_hd__o21ai_2
XFILLER_88_218 VGND VGND VPWR VPWR sky130_fd_sc_hd__decap_3
XFILLER_130_315 VGND VGND VPWR VPWR sky130_fd_sc_hd__decap_3
X_6193_ _6193_/A _6193_/B _6193_/C VGND VGND VPWR VPWR _6528_/B sky130_fd_sc_hd__nand3_4
XFILLER_130_337 VGND VGND VPWR VPWR sky130_fd_sc_hd__decap_3
XFILLER_97_752 VGND VGND VPWR VPWR sky130_fd_sc_hd__decap_3
XFILLER_69_443 VGND VGND VPWR VPWR sky130_fd_sc_hd__decap_3
X_5144_ _5143_/X _5142_/Y _5350_/B _8175_/A VGND VGND VPWR VPWR _5145_/A sky130_fd_sc_hd__a31o_4
XFILLER_69_465 VGND VGND VPWR VPWR sky130_fd_sc_hd__decap_3
XFILLER_96_262 VGND VGND VPWR VPWR sky130_fd_sc_hd__decap_3
XFILLER_28_29 VGND VGND VPWR VPWR sky130_fd_sc_hd__decap_3
XPHY_EDGE_ROW_63_Left_194 VGND VGND VPWR VPWR sky130_fd_sc_hd__decap_3
XFILLER_84_424 VGND VGND VPWR VPWR sky130_fd_sc_hd__decap_3
XFILLER_29_329 VGND VGND VPWR VPWR sky130_fd_sc_hd__decap_3
X_5075_ _6976_/B _6976_/C VGND VGND VPWR VPWR _7012_/A sky130_fd_sc_hd__and2_2
XFILLER_84_446 VGND VGND VPWR VPWR sky130_fd_sc_hd__decap_3
X_8903_ _8903_/A VGND VGND VPWR VPWR _9294_/D sky130_fd_sc_hd__buf_1
XFILLER_56_159 VGND VGND VPWR VPWR sky130_fd_sc_hd__decap_3
XFILLER_72_619 VGND VGND VPWR VPWR sky130_fd_sc_hd__decap_3
XFILLER_37_351 VGND VGND VPWR VPWR sky130_fd_sc_hd__decap_3
XFILLER_65_671 VGND VGND VPWR VPWR sky130_fd_sc_hd__fill_1
XTAP_TAPCELL_ROW_84_1414 VGND VPWR sky130_fd_sc_hd__tapvpwrvgnd_1
XFILLER_71_129 VGND VGND VPWR VPWR sky130_fd_sc_hd__fill_2
X_8834_ _8834_/A VGND VGND VPWR VPWR _9261_/D sky130_fd_sc_hd__buf_1
XFILLER_80_641 VGND VGND VPWR VPWR sky130_fd_sc_hd__decap_3
XFILLER_25_568 VGND VGND VPWR VPWR sky130_fd_sc_hd__decap_3
XFILLER_80_663 VGND VGND VPWR VPWR sky130_fd_sc_hd__decap_3
X_8765_ _8765_/A _8765_/B _8765_/C VGND VGND VPWR VPWR _8772_/A sky130_fd_sc_hd__or3_4
X_5977_ _9205_/Q _7955_/A VGND VGND VPWR VPWR _5978_/B sky130_fd_sc_hd__nand2_2
XFILLER_100_12 VGND VGND VPWR VPWR sky130_fd_sc_hd__decap_3
XFILLER_80_696 VGND VGND VPWR VPWR sky130_fd_sc_hd__decap_3
XFILLER_12_229 VGND VGND VPWR VPWR sky130_fd_sc_hd__decap_3
X_7716_ _7716_/A _7716_/B VGND VGND VPWR VPWR _7721_/A sky130_fd_sc_hd__xnor2_2
X_4928_ _5875_/B VGND VGND VPWR VPWR _5006_/B sky130_fd_sc_hd__clkbuf_2
X_8696_ _8729_/S _8690_/A _8758_/A _8695_/X VGND VGND VPWR VPWR _8696_/X sky130_fd_sc_hd__o31a_2
XFILLER_21_741 VGND VGND VPWR VPWR sky130_fd_sc_hd__decap_3
XFILLER_60_27 VGND VGND VPWR VPWR sky130_fd_sc_hd__fill_1
X_7647_ _7647_/A _7647_/B VGND VGND VPWR VPWR _7648_/A sky130_fd_sc_hd__xnor2_4
XFILLER_21_774 VGND VGND VPWR VPWR sky130_fd_sc_hd__decap_3
X_4859_ _9174_/Q hold850/X _4861_/S VGND VGND VPWR VPWR _4859_/X sky130_fd_sc_hd__mux2_2
XTAP_TAPCELL_ROW_10_419 VGND VPWR sky130_fd_sc_hd__tapvpwrvgnd_1
XFILLER_20_262 VGND VGND VPWR VPWR sky130_fd_sc_hd__decap_3
X_7578_ _7576_/X _7454_/A _7577_/X VGND VGND VPWR VPWR _7582_/A sky130_fd_sc_hd__o21ai_2
XFILLER_109_21 VGND VGND VPWR VPWR sky130_fd_sc_hd__decap_3
XFILLER_119_673 VGND VGND VPWR VPWR sky130_fd_sc_hd__decap_3
XFILLER_114_6 VGND VGND VPWR VPWR sky130_fd_sc_hd__decap_3
X_9317_ _9317_/CLK _9317_/D fanout407/X VGND VGND VPWR VPWR _9317_/Q sky130_fd_sc_hd__dfrtp_2
XFILLER_118_161 VGND VGND VPWR VPWR sky130_fd_sc_hd__fill_1
X_6529_ _6529_/A _6529_/B VGND VGND VPWR VPWR _6529_/X sky130_fd_sc_hd__or2_2
XFILLER_4_428 VGND VGND VPWR VPWR sky130_fd_sc_hd__fill_1
XFILLER_109_54 VGND VGND VPWR VPWR sky130_fd_sc_hd__fill_2
XFILLER_106_334 VGND VGND VPWR VPWR sky130_fd_sc_hd__decap_3
XTAP_TAPCELL_ROW_95_1565 VGND VPWR sky130_fd_sc_hd__tapvpwrvgnd_1
XFILLER_106_356 VGND VGND VPWR VPWR sky130_fd_sc_hd__decap_3
X_9248_ clkload3/A _9248_/D load_slew370/X VGND VGND VPWR VPWR _9248_/Q sky130_fd_sc_hd__dfrtp_2
XFILLER_0_601 VGND VGND VPWR VPWR sky130_fd_sc_hd__decap_3
XFILLER_0_623 VGND VGND VPWR VPWR sky130_fd_sc_hd__decap_3
X_9179_ _9228_/CLK _9179_/D wire406/A VGND VGND VPWR VPWR _9179_/Q sky130_fd_sc_hd__dfrtp_2
XFILLER_121_337 VGND VGND VPWR VPWR sky130_fd_sc_hd__decap_3
XFILLER_88_741 VGND VGND VPWR VPWR sky130_fd_sc_hd__decap_3
XFILLER_0_645 VGND VGND VPWR VPWR sky130_fd_sc_hd__decap_3
XFILLER_125_42 VGND VGND VPWR VPWR sky130_fd_sc_hd__decap_3
XFILLER_85_24 VGND VGND VPWR VPWR sky130_fd_sc_hd__decap_3
XFILLER_125_75 VGND VGND VPWR VPWR sky130_fd_sc_hd__decap_3
XFILLER_102_584 VGND VGND VPWR VPWR sky130_fd_sc_hd__decap_3
XFILLER_102_595 VGND VGND VPWR VPWR sky130_fd_sc_hd__decap_3
XFILLER_85_46 VGND VGND VPWR VPWR sky130_fd_sc_hd__fill_1
XFILLER_85_57 VGND VGND VPWR VPWR sky130_fd_sc_hd__decap_3
XFILLER_47_126 VGND VGND VPWR VPWR sky130_fd_sc_hd__decap_3
XFILLER_90_416 VGND VGND VPWR VPWR sky130_fd_sc_hd__decap_3
XTAP_TAPCELL_ROW_18_519 VGND VPWR sky130_fd_sc_hd__tapvpwrvgnd_1
XFILLER_28_362 VGND VGND VPWR VPWR sky130_fd_sc_hd__fill_2
XFILLER_16_524 VGND VGND VPWR VPWR sky130_fd_sc_hd__decap_3
XFILLER_71_630 VGND VGND VPWR VPWR sky130_fd_sc_hd__decap_3
XFILLER_55_181 VGND VGND VPWR VPWR sky130_fd_sc_hd__fill_1
XFILLER_16_546 VGND VGND VPWR VPWR sky130_fd_sc_hd__decap_3
XFILLER_16_579 VGND VGND VPWR VPWR sky130_fd_sc_hd__decap_3
XFILLER_43_376 VGND VGND VPWR VPWR sky130_fd_sc_hd__fill_1
XFILLER_70_162 VGND VGND VPWR VPWR sky130_fd_sc_hd__decap_3
XTAP_TAPCELL_ROW_104_1683 VGND VPWR sky130_fd_sc_hd__tapvpwrvgnd_1
XFILLER_8_701 VGND VGND VPWR VPWR sky130_fd_sc_hd__decap_3
XFILLER_12_752 VGND VGND VPWR VPWR sky130_fd_sc_hd__decap_3
XFILLER_12_763 VGND VGND VPWR VPWR sky130_fd_sc_hd__decap_3
Xwire120 _5998_/Y VGND VGND VPWR VPWR _6250_/B sky130_fd_sc_hd__buf_2
XFILLER_8_734 VGND VGND VPWR VPWR sky130_fd_sc_hd__decap_3
Xwire131 _5129_/Y VGND VGND VPWR VPWR _5165_/B sky130_fd_sc_hd__clkbuf_2
XFILLER_11_284 VGND VGND VPWR VPWR sky130_fd_sc_hd__decap_3
Xwire142 _6612_/Y VGND VGND VPWR VPWR wire142/X sky130_fd_sc_hd__buf_6
Xwire164 _4961_/Y VGND VGND VPWR VPWR _4974_/D sky130_fd_sc_hd__buf_1
XFILLER_116_109 VGND VGND VPWR VPWR sky130_fd_sc_hd__decap_3
XTAP_TAPCELL_ROW_55_1026 VGND VPWR sky130_fd_sc_hd__tapvpwrvgnd_1
XFILLER_124_153 VGND VGND VPWR VPWR sky130_fd_sc_hd__decap_3
XFILLER_98_527 VGND VGND VPWR VPWR sky130_fd_sc_hd__decap_3
XFILLER_125_698 VGND VGND VPWR VPWR sky130_fd_sc_hd__decap_3
XFILLER_124_186 VGND VGND VPWR VPWR sky130_fd_sc_hd__decap_3
XFILLER_124_197 VGND VGND VPWR VPWR sky130_fd_sc_hd__decap_3
Xload_slew147 wire148/X VGND VGND VPWR VPWR _5975_/B sky130_fd_sc_hd__buf_8
XFILLER_78_262 VGND VGND VPWR VPWR sky130_fd_sc_hd__fill_1
XFILLER_66_424 VGND VGND VPWR VPWR sky130_fd_sc_hd__decap_3
XFILLER_94_744 VGND VGND VPWR VPWR sky130_fd_sc_hd__decap_3
XFILLER_38_137 VGND VGND VPWR VPWR sky130_fd_sc_hd__decap_3
XFILLER_66_457 VGND VGND VPWR VPWR sky130_fd_sc_hd__decap_3
XFILLER_93_254 VGND VGND VPWR VPWR sky130_fd_sc_hd__fill_1
XFILLER_53_107 VGND VGND VPWR VPWR sky130_fd_sc_hd__decap_3
XFILLER_47_682 VGND VGND VPWR VPWR sky130_fd_sc_hd__fill_1
X_5900_ _5900_/A _5900_/B VGND VGND VPWR VPWR _6143_/B sky130_fd_sc_hd__xnor2_4
XFILLER_81_438 VGND VGND VPWR VPWR sky130_fd_sc_hd__decap_3
XFILLER_81_449 VGND VGND VPWR VPWR sky130_fd_sc_hd__decap_3
XFILLER_46_170 VGND VGND VPWR VPWR sky130_fd_sc_hd__fill_2
X_6880_ _6880_/A _6880_/B VGND VGND VPWR VPWR _6881_/B sky130_fd_sc_hd__and2_2
X_5831_ _5984_/B _5984_/C _7773_/A _7114_/C VGND VGND VPWR VPWR _5833_/A sky130_fd_sc_hd__o211ai_2
XTAP_TAPCELL_ROW_66_1166 VGND VPWR sky130_fd_sc_hd__tapvpwrvgnd_1
XTAP_TAPCELL_ROW_66_1177 VGND VPWR sky130_fd_sc_hd__tapvpwrvgnd_1
XFILLER_34_365 VGND VGND VPWR VPWR sky130_fd_sc_hd__decap_3
XFILLER_62_685 VGND VGND VPWR VPWR sky130_fd_sc_hd__decap_3
XTAP_TAPCELL_ROW_45_883 VGND VPWR sky130_fd_sc_hd__tapvpwrvgnd_1
XTAP_TAPCELL_ROW_45_894 VGND VPWR sky130_fd_sc_hd__tapvpwrvgnd_1
X_5762_ _5760_/Y _5605_/Y _5761_/Y VGND VGND VPWR VPWR _5820_/C sky130_fd_sc_hd__a21oi_4
X_8550_ _8549_/Y _8554_/B _8548_/A _8515_/B VGND VGND VPWR VPWR _8550_/Y sky130_fd_sc_hd__a211oi_2
XFILLER_15_590 VGND VGND VPWR VPWR sky130_fd_sc_hd__decap_3
X_7501_ _7382_/B _7500_/X _7387_/A VGND VGND VPWR VPWR _7502_/C sky130_fd_sc_hd__a21o_2
X_4713_ _4713_/A VGND VGND VPWR VPWR _9104_/D sky130_fd_sc_hd__buf_1
X_5693_ _7050_/A _7417_/A _7430_/A _5040_/A VGND VGND VPWR VPWR _5694_/B sky130_fd_sc_hd__a211o_2
X_8481_ _8480_/Y _8482_/B _8328_/Y VGND VGND VPWR VPWR _8481_/Y sky130_fd_sc_hd__a21oi_2
X_4644_ _9072_/Q hold884/X _4650_/S VGND VGND VPWR VPWR _4644_/X sky130_fd_sc_hd__mux2_2
X_7432_ _7579_/A _7579_/B _7431_/X VGND VGND VPWR VPWR _7434_/B sky130_fd_sc_hd__a21o_2
X_4575_ _4608_/A1 _4575_/A1 _4587_/S VGND VGND VPWR VPWR _4576_/A sky130_fd_sc_hd__mux2_2
X_7363_ _9213_/Q _7924_/B VGND VGND VPWR VPWR _7364_/B sky130_fd_sc_hd__or2_2
XFILLER_128_492 VGND VGND VPWR VPWR sky130_fd_sc_hd__fill_2
XFILLER_116_643 VGND VGND VPWR VPWR sky130_fd_sc_hd__fill_1
X_9102_ _9338_/CLK _9102_/D fanout367/X VGND VGND VPWR VPWR _9102_/Q sky130_fd_sc_hd__dfrtp_2
X_6314_ _6579_/A _6578_/B VGND VGND VPWR VPWR _6315_/B sky130_fd_sc_hd__xnor2_2
XFILLER_116_654 VGND VGND VPWR VPWR sky130_fd_sc_hd__fill_1
X_7294_ _8080_/A _8237_/A _7295_/C VGND VGND VPWR VPWR _7294_/X sky130_fd_sc_hd__a21o_2
XFILLER_89_505 VGND VGND VPWR VPWR sky130_fd_sc_hd__decap_3
Xhold756 _8795_/X VGND VGND VPWR VPWR _8796_/A sky130_fd_sc_hd__dlygate4sd3_1
Xhold767 _9199_/Q VGND VGND VPWR VPWR _5101_/B sky130_fd_sc_hd__dlygate4sd3_1
Xhold778 _7243_/A VGND VGND VPWR VPWR hold778/X sky130_fd_sc_hd__dlygate4sd3_1
XFILLER_103_315 VGND VGND VPWR VPWR sky130_fd_sc_hd__decap_3
X_6245_ _9207_/Q _6680_/B _6244_/C VGND VGND VPWR VPWR _6246_/C sky130_fd_sc_hd__a21oi_2
X_9033_ _9228_/CLK _9033_/D wire406/A VGND VGND VPWR VPWR _9033_/Q sky130_fd_sc_hd__dfrtp_2
Xhold789 _9183_/Q VGND VGND VPWR VPWR hold789/X sky130_fd_sc_hd__dlygate4sd3_1
XFILLER_39_17 VGND VGND VPWR VPWR sky130_fd_sc_hd__fill_1
XPHY_EDGE_ROW_71_Left_202 VGND VGND VPWR VPWR sky130_fd_sc_hd__decap_3
XFILLER_130_134 VGND VGND VPWR VPWR sky130_fd_sc_hd__decap_3
X_6176_ _6184_/C _6184_/D _6174_/X _6175_/X VGND VGND VPWR VPWR _6176_/X sky130_fd_sc_hd__o211a_2
XFILLER_130_156 VGND VGND VPWR VPWR sky130_fd_sc_hd__decap_3
XFILLER_69_251 VGND VGND VPWR VPWR sky130_fd_sc_hd__decap_3
XFILLER_130_178 VGND VGND VPWR VPWR sky130_fd_sc_hd__decap_3
XTAP_TAPCELL_ROW_90_1495 VGND VPWR sky130_fd_sc_hd__tapvpwrvgnd_1
XFILLER_69_273 VGND VGND VPWR VPWR sky130_fd_sc_hd__decap_3
XFILLER_29_104 VGND VGND VPWR VPWR sky130_fd_sc_hd__decap_3
X_5127_ _9337_/Q _5002_/X _5126_/X _9133_/Q VGND VGND VPWR VPWR _5127_/X sky130_fd_sc_hd__a22o_2
XFILLER_85_744 VGND VGND VPWR VPWR sky130_fd_sc_hd__decap_3
XFILLER_57_446 VGND VGND VPWR VPWR sky130_fd_sc_hd__fill_2
XPHY_EDGE_ROW_2_Right_2 VGND VGND VPWR VPWR sky130_fd_sc_hd__decap_3
XFILLER_29_148 VGND VGND VPWR VPWR sky130_fd_sc_hd__decap_3
X_5058_ _6232_/C _6231_/B _5187_/C _5180_/S VGND VGND VPWR VPWR _5267_/A sky130_fd_sc_hd__nor4b_2
XFILLER_57_479 VGND VGND VPWR VPWR sky130_fd_sc_hd__decap_3
XFILLER_72_405 VGND VGND VPWR VPWR sky130_fd_sc_hd__decap_3
XFILLER_44_118 VGND VGND VPWR VPWR sky130_fd_sc_hd__decap_3
XFILLER_38_682 VGND VGND VPWR VPWR sky130_fd_sc_hd__decap_3
XFILLER_72_449 VGND VGND VPWR VPWR sky130_fd_sc_hd__decap_3
XFILLER_25_343 VGND VGND VPWR VPWR sky130_fd_sc_hd__decap_3
XFILLER_111_33 VGND VGND VPWR VPWR sky130_fd_sc_hd__decap_3
X_8817_ _8817_/A VGND VGND VPWR VPWR _9253_/D sky130_fd_sc_hd__buf_1
XFILLER_53_663 VGND VGND VPWR VPWR sky130_fd_sc_hd__fill_1
XFILLER_80_460 VGND VGND VPWR VPWR sky130_fd_sc_hd__decap_3
XFILLER_52_151 VGND VGND VPWR VPWR sky130_fd_sc_hd__decap_3
XFILLER_25_365 VGND VGND VPWR VPWR sky130_fd_sc_hd__decap_3
XFILLER_13_505 VGND VGND VPWR VPWR sky130_fd_sc_hd__fill_1
XFILLER_111_66 VGND VGND VPWR VPWR sky130_fd_sc_hd__decap_3
XPHY_EDGE_ROW_80_Left_211 VGND VGND VPWR VPWR sky130_fd_sc_hd__decap_3
XFILLER_13_538 VGND VGND VPWR VPWR sky130_fd_sc_hd__decap_3
XFILLER_25_398 VGND VGND VPWR VPWR sky130_fd_sc_hd__decap_3
X_8748_ wire110/X _8746_/Y _8747_/X VGND VGND VPWR VPWR _9231_/D sky130_fd_sc_hd__a21oi_2
XFILLER_52_195 VGND VGND VPWR VPWR sky130_fd_sc_hd__fill_1
XFILLER_71_48 VGND VGND VPWR VPWR sky130_fd_sc_hd__fill_1
XFILLER_111_99 VGND VGND VPWR VPWR sky130_fd_sc_hd__fill_1
XFILLER_40_368 VGND VGND VPWR VPWR sky130_fd_sc_hd__decap_3
X_8679_ _8681_/A _8715_/A VGND VGND VPWR VPWR _8679_/Y sky130_fd_sc_hd__nand2_2
XTAP_TAPCELL_ROW_23_588 VGND VPWR sky130_fd_sc_hd__tapvpwrvgnd_1
XFILLER_21_582 VGND VGND VPWR VPWR sky130_fd_sc_hd__decap_3
XFILLER_126_418 VGND VGND VPWR VPWR sky130_fd_sc_hd__fill_2
XFILLER_5_715 VGND VGND VPWR VPWR sky130_fd_sc_hd__decap_3
XFILLER_4_203 VGND VGND VPWR VPWR sky130_fd_sc_hd__fill_1
XFILLER_4_214 VGND VGND VPWR VPWR sky130_fd_sc_hd__decap_3
XFILLER_112_3 VGND VGND VPWR VPWR sky130_fd_sc_hd__decap_3
XFILLER_5_759 VGND VGND VPWR VPWR sky130_fd_sc_hd__decap_3
XFILLER_107_676 VGND VGND VPWR VPWR sky130_fd_sc_hd__fill_2
XFILLER_106_153 VGND VGND VPWR VPWR sky130_fd_sc_hd__fill_1
XFILLER_106_164 VGND VGND VPWR VPWR sky130_fd_sc_hd__decap_3
XFILLER_122_613 VGND VGND VPWR VPWR sky130_fd_sc_hd__decap_3
XFILLER_20_85 VGND VGND VPWR VPWR sky130_fd_sc_hd__decap_3
XFILLER_106_186 VGND VGND VPWR VPWR sky130_fd_sc_hd__decap_3
XFILLER_106_197 VGND VGND VPWR VPWR sky130_fd_sc_hd__decap_3
XFILLER_121_134 VGND VGND VPWR VPWR sky130_fd_sc_hd__decap_3
XFILLER_0_442 VGND VGND VPWR VPWR sky130_fd_sc_hd__decap_3
XFILLER_121_167 VGND VGND VPWR VPWR sky130_fd_sc_hd__fill_1
XFILLER_121_178 VGND VGND VPWR VPWR sky130_fd_sc_hd__decap_3
XFILLER_76_733 VGND VGND VPWR VPWR sky130_fd_sc_hd__decap_3
XFILLER_48_424 VGND VGND VPWR VPWR sky130_fd_sc_hd__fill_1
XFILLER_0_497 VGND VGND VPWR VPWR sky130_fd_sc_hd__decap_3
XFILLER_29_72 VGND VGND VPWR VPWR sky130_fd_sc_hd__decap_3
XFILLER_76_766 VGND VGND VPWR VPWR sky130_fd_sc_hd__decap_3
XFILLER_48_468 VGND VGND VPWR VPWR sky130_fd_sc_hd__decap_3
XFILLER_29_94 VGND VGND VPWR VPWR sky130_fd_sc_hd__fill_2
XFILLER_75_254 VGND VGND VPWR VPWR sky130_fd_sc_hd__decap_3
XFILLER_91_725 VGND VGND VPWR VPWR sky130_fd_sc_hd__decap_3
XFILLER_63_427 VGND VGND VPWR VPWR sky130_fd_sc_hd__decap_3
XTAP_TAPCELL_ROW_106_1712 VGND VPWR sky130_fd_sc_hd__tapvpwrvgnd_1
XFILLER_29_693 VGND VGND VPWR VPWR sky130_fd_sc_hd__decap_3
XFILLER_63_449 VGND VGND VPWR VPWR sky130_fd_sc_hd__fill_2
XFILLER_16_321 VGND VGND VPWR VPWR sky130_fd_sc_hd__decap_3
XFILLER_56_490 VGND VGND VPWR VPWR sky130_fd_sc_hd__fill_2
XPHY_EDGE_ROW_119_Left_250 VGND VGND VPWR VPWR sky130_fd_sc_hd__decap_3
XFILLER_45_60 VGND VGND VPWR VPWR sky130_fd_sc_hd__decap_3
XFILLER_44_663 VGND VGND VPWR VPWR sky130_fd_sc_hd__fill_1
XFILLER_43_140 VGND VGND VPWR VPWR sky130_fd_sc_hd__decap_3
XFILLER_16_365 VGND VGND VPWR VPWR sky130_fd_sc_hd__fill_1
XFILLER_45_82 VGND VGND VPWR VPWR sky130_fd_sc_hd__decap_3
XFILLER_44_696 VGND VGND VPWR VPWR sky130_fd_sc_hd__decap_3
XFILLER_16_387 VGND VGND VPWR VPWR sky130_fd_sc_hd__decap_3
XFILLER_71_493 VGND VGND VPWR VPWR sky130_fd_sc_hd__decap_3
XFILLER_31_335 VGND VGND VPWR VPWR sky130_fd_sc_hd__fill_1
XTAP_TAPCELL_ROW_42_842 VGND VPWR sky130_fd_sc_hd__tapvpwrvgnd_1
XFILLER_31_346 VGND VGND VPWR VPWR sky130_fd_sc_hd__decap_3
XTAP_TAPCELL_ROW_42_853 VGND VPWR sky130_fd_sc_hd__tapvpwrvgnd_1
XFILLER_12_560 VGND VGND VPWR VPWR sky130_fd_sc_hd__decap_3
XFILLER_8_520 VGND VGND VPWR VPWR sky130_fd_sc_hd__decap_3
XFILLER_129_223 VGND VGND VPWR VPWR sky130_fd_sc_hd__fill_1
XFILLER_129_234 VGND VGND VPWR VPWR sky130_fd_sc_hd__decap_3
XFILLER_8_542 VGND VGND VPWR VPWR sky130_fd_sc_hd__decap_3
XFILLER_77_6 VGND VGND VPWR VPWR sky130_fd_sc_hd__decap_3
XFILLER_129_278 VGND VGND VPWR VPWR sky130_fd_sc_hd__fill_2
XFILLER_6_21 VGND VGND VPWR VPWR sky130_fd_sc_hd__decap_3
XFILLER_6_32 VGND VGND VPWR VPWR sky130_fd_sc_hd__decap_3
XANTENNA_3 wire39/X VGND VGND VPWR VPWR sky130_fd_sc_hd__diode_2
XFILLER_8_597 VGND VGND VPWR VPWR sky130_fd_sc_hd__decap_3
XTAP_TAPCELL_ROW_117_1863 VGND VPWR sky130_fd_sc_hd__tapvpwrvgnd_1
XFILLER_6_76 VGND VGND VPWR VPWR sky130_fd_sc_hd__decap_3
XFILLER_113_613 VGND VGND VPWR VPWR sky130_fd_sc_hd__decap_3
XFILLER_125_484 VGND VGND VPWR VPWR sky130_fd_sc_hd__decap_3
XFILLER_98_335 VGND VGND VPWR VPWR sky130_fd_sc_hd__decap_3
XFILLER_113_646 VGND VGND VPWR VPWR sky130_fd_sc_hd__decap_3
X_6030_ _6030_/A VGND VGND VPWR VPWR _6717_/B sky130_fd_sc_hd__clkbuf_1
XFILLER_86_508 VGND VGND VPWR VPWR sky130_fd_sc_hd__decap_3
XFILLER_113_679 VGND VGND VPWR VPWR sky130_fd_sc_hd__decap_3
XFILLER_100_307 VGND VGND VPWR VPWR sky130_fd_sc_hd__fill_1
XFILLER_39_402 VGND VGND VPWR VPWR sky130_fd_sc_hd__decap_3
XFILLER_79_582 VGND VGND VPWR VPWR sky130_fd_sc_hd__decap_3
XFILLER_112_189 VGND VGND VPWR VPWR sky130_fd_sc_hd__decap_3
XFILLER_39_435 VGND VGND VPWR VPWR sky130_fd_sc_hd__decap_3
XFILLER_94_530 VGND VGND VPWR VPWR sky130_fd_sc_hd__fill_2
XFILLER_39_457 VGND VGND VPWR VPWR sky130_fd_sc_hd__decap_3
XTAP_TAPCELL_ROW_68_1206 VGND VPWR sky130_fd_sc_hd__tapvpwrvgnd_1
XFILLER_66_265 VGND VGND VPWR VPWR sky130_fd_sc_hd__fill_1
X_7981_ _7981_/A _7981_/B VGND VGND VPWR VPWR _7981_/Y sky130_fd_sc_hd__nor2_2
XFILLER_26_118 VGND VGND VPWR VPWR sky130_fd_sc_hd__decap_3
X_6932_ _6747_/A _6764_/A _6747_/B _6931_/Y VGND VGND VPWR VPWR _6932_/X sky130_fd_sc_hd__a31o_2
XFILLER_35_630 VGND VGND VPWR VPWR sky130_fd_sc_hd__decap_3
X_6863_ _7212_/A _7153_/A _6862_/X _6788_/B VGND VGND VPWR VPWR _6863_/X sky130_fd_sc_hd__a2bb2o_2
XFILLER_62_460 VGND VGND VPWR VPWR sky130_fd_sc_hd__decap_3
X_8602_ _8516_/Y _8649_/B _8494_/X VGND VGND VPWR VPWR _8603_/B sky130_fd_sc_hd__a21oi_2
X_5814_ _5814_/A _5814_/B VGND VGND VPWR VPWR _5814_/X sky130_fd_sc_hd__xor2_2
XFILLER_34_184 VGND VGND VPWR VPWR sky130_fd_sc_hd__decap_3
X_6794_ _6483_/S _6792_/X _6793_/Y _6485_/A VGND VGND VPWR VPWR _6801_/A sky130_fd_sc_hd__a22o_2
XFILLER_22_357 VGND VGND VPWR VPWR sky130_fd_sc_hd__decap_3
XFILLER_22_368 VGND VGND VPWR VPWR sky130_fd_sc_hd__decap_3
X_8533_ _8532_/Y _8562_/B _8525_/Y VGND VGND VPWR VPWR _8534_/B sky130_fd_sc_hd__o21ai_2
X_5745_ _5893_/B VGND VGND VPWR VPWR _7955_/A sky130_fd_sc_hd__buf_6
XFILLER_41_18 VGND VGND VPWR VPWR sky130_fd_sc_hd__decap_3
X_8464_ _8393_/X _8459_/A _8457_/A _8463_/X VGND VGND VPWR VPWR _8464_/Y sky130_fd_sc_hd__a31oi_4
XTAP_TAPCELL_ROW_20_547 VGND VPWR sky130_fd_sc_hd__tapvpwrvgnd_1
X_5676_ _6406_/B _5804_/A _5804_/B VGND VGND VPWR VPWR _5676_/X sky130_fd_sc_hd__and3_2
XTAP_TAPCELL_ROW_20_558 VGND VPWR sky130_fd_sc_hd__tapvpwrvgnd_1
XTAP_TAPCELL_ROW_79_1346 VGND VPWR sky130_fd_sc_hd__tapvpwrvgnd_1
X_7415_ _7955_/A _8405_/A VGND VGND VPWR VPWR _7419_/A sky130_fd_sc_hd__nand2_2
X_4627_ _4662_/A1 _4627_/A1 _4629_/S VGND VGND VPWR VPWR _4628_/A sky130_fd_sc_hd__mux2_2
X_8395_ _8383_/A _8379_/B _8374_/B _8379_/A _8394_/X VGND VGND VPWR VPWR _8395_/X
+ sky130_fd_sc_hd__a221o_2
XFILLER_116_440 VGND VGND VPWR VPWR sky130_fd_sc_hd__fill_2
X_4558_ _9031_/Q _4558_/A1 _4566_/S VGND VGND VPWR VPWR _4558_/X sky130_fd_sc_hd__mux2_2
X_7346_ _7346_/A _7346_/B _7346_/C _7346_/D VGND VGND VPWR VPWR _7347_/C sky130_fd_sc_hd__nand4_2
XFILLER_2_707 VGND VGND VPWR VPWR sky130_fd_sc_hd__decap_3
XTAP_TAPCELL_ROW_92_1524 VGND VPWR sky130_fd_sc_hd__tapvpwrvgnd_1
Xmax_cap272 _6414_/X VGND VGND VPWR VPWR _7170_/S sky130_fd_sc_hd__buf_4
XFILLER_9_9 VGND VGND VPWR VPWR sky130_fd_sc_hd__decap_3
XFILLER_89_335 VGND VGND VPWR VPWR sky130_fd_sc_hd__fill_1
X_7277_ _7279_/A _7277_/B _7278_/B _7285_/C VGND VGND VPWR VPWR _7280_/A sky130_fd_sc_hd__or4_4
X_9016_ _9016_/A VGND VGND VPWR VPWR _9348_/D sky130_fd_sc_hd__buf_1
X_6228_ _9062_/Q _5730_/X _6225_/X _6226_/X _6227_/X VGND VGND VPWR VPWR _6228_/X
+ sky130_fd_sc_hd__a2111o_2
XFILLER_103_167 VGND VGND VPWR VPWR sky130_fd_sc_hd__fill_1
XFILLER_58_711 VGND VGND VPWR VPWR sky130_fd_sc_hd__decap_3
X_6159_ wire76/X _6159_/B VGND VGND VPWR VPWR _6159_/Y sky130_fd_sc_hd__nand2_2
Xhold1220 _9201_/Q VGND VGND VPWR VPWR _5235_/A0 sky130_fd_sc_hd__dlygate4sd3_1
XFILLER_97_390 VGND VGND VPWR VPWR sky130_fd_sc_hd__fill_2
XFILLER_66_37 VGND VGND VPWR VPWR sky130_fd_sc_hd__fill_1
Xhold1231 _9204_/Q VGND VGND VPWR VPWR _5562_/A0 sky130_fd_sc_hd__dlygate4sd3_1
XFILLER_66_59 VGND VGND VPWR VPWR sky130_fd_sc_hd__decap_3
Xhold1242 _9228_/Q VGND VGND VPWR VPWR _8611_/A sky130_fd_sc_hd__dlygate4sd3_1
Xhold1253 _9207_/Q VGND VGND VPWR VPWR _5968_/A0 sky130_fd_sc_hd__dlygate4sd3_1
XFILLER_73_714 VGND VGND VPWR VPWR sky130_fd_sc_hd__decap_3
XFILLER_122_21 VGND VGND VPWR VPWR sky130_fd_sc_hd__decap_3
XFILLER_122_32 VGND VGND VPWR VPWR sky130_fd_sc_hd__decap_3
XFILLER_73_747 VGND VGND VPWR VPWR sky130_fd_sc_hd__decap_3
XFILLER_17_129 VGND VGND VPWR VPWR sky130_fd_sc_hd__decap_3
XFILLER_38_490 VGND VGND VPWR VPWR sky130_fd_sc_hd__decap_3
Xclkbuf_leaf_37_clk clkload0/A VGND VGND VPWR VPWR clkload7/A sky130_fd_sc_hd__clkbuf_8
XFILLER_122_65 VGND VGND VPWR VPWR sky130_fd_sc_hd__decap_3
XTAP_TAPCELL_ROW_28_658 VGND VPWR sky130_fd_sc_hd__tapvpwrvgnd_1
XFILLER_72_268 VGND VGND VPWR VPWR sky130_fd_sc_hd__decap_3
XFILLER_26_663 VGND VGND VPWR VPWR sky130_fd_sc_hd__decap_3
XTAP_TAPCELL_ROW_0_272 VGND VPWR sky130_fd_sc_hd__tapvpwrvgnd_1
XTAP_TAPCELL_ROW_0_283 VGND VPWR sky130_fd_sc_hd__tapvpwrvgnd_1
XFILLER_53_471 VGND VGND VPWR VPWR sky130_fd_sc_hd__fill_2
XFILLER_53_482 VGND VGND VPWR VPWR sky130_fd_sc_hd__decap_3
XFILLER_15_30 VGND VGND VPWR VPWR sky130_fd_sc_hd__decap_3
XFILLER_40_110 VGND VGND VPWR VPWR sky130_fd_sc_hd__fill_2
XFILLER_40_132 VGND VGND VPWR VPWR sky130_fd_sc_hd__decap_3
XFILLER_15_63 VGND VGND VPWR VPWR sky130_fd_sc_hd__decap_3
XTAP_TAPCELL_ROW_101_1642 VGND VPWR sky130_fd_sc_hd__tapvpwrvgnd_1
XFILLER_9_317 VGND VGND VPWR VPWR sky130_fd_sc_hd__decap_3
XFILLER_15_96 VGND VGND VPWR VPWR sky130_fd_sc_hd__decap_3
XFILLER_40_187 VGND VGND VPWR VPWR sky130_fd_sc_hd__decap_3
XFILLER_127_727 VGND VGND VPWR VPWR sky130_fd_sc_hd__fill_1
XFILLER_127_738 VGND VGND VPWR VPWR sky130_fd_sc_hd__decap_3
XFILLER_126_215 VGND VGND VPWR VPWR sky130_fd_sc_hd__decap_3
Xrebuffer661 _7145_/A VGND VGND VPWR VPWR _7025_/A sky130_fd_sc_hd__buf_4
Xrebuffer683 _7512_/Y VGND VGND VPWR VPWR _7559_/A sky130_fd_sc_hd__buf_2
XTAP_TAPCELL_ROW_130_2038 VGND VPWR sky130_fd_sc_hd__tapvpwrvgnd_1
XFILLER_107_462 VGND VGND VPWR VPWR sky130_fd_sc_hd__decap_3
XTAP_TAPCELL_ROW_130_2049 VGND VPWR sky130_fd_sc_hd__tapvpwrvgnd_1
XFILLER_68_519 VGND VGND VPWR VPWR sky130_fd_sc_hd__decap_3
XFILLER_1_762 VGND VGND VPWR VPWR sky130_fd_sc_hd__decap_3
XTAP_TAPCELL_ROW_8_383 VGND VPWR sky130_fd_sc_hd__tapvpwrvgnd_1
XTAP_TAPCELL_ROW_8_394 VGND VPWR sky130_fd_sc_hd__tapvpwrvgnd_1
XTAP_TAPCELL_ROW_112_1793 VGND VPWR sky130_fd_sc_hd__tapvpwrvgnd_1
XFILLER_122_498 VGND VGND VPWR VPWR sky130_fd_sc_hd__decap_3
XFILLER_76_530 VGND VGND VPWR VPWR sky130_fd_sc_hd__fill_2
XFILLER_48_221 VGND VGND VPWR VPWR sky130_fd_sc_hd__decap_3
XFILLER_76_574 VGND VGND VPWR VPWR sky130_fd_sc_hd__fill_1
XTAP_TAPCELL_ROW_47_912 VGND VPWR sky130_fd_sc_hd__tapvpwrvgnd_1
XFILLER_91_522 VGND VGND VPWR VPWR sky130_fd_sc_hd__decap_3
XFILLER_48_298 VGND VGND VPWR VPWR sky130_fd_sc_hd__fill_2
XFILLER_91_544 VGND VGND VPWR VPWR sky130_fd_sc_hd__decap_3
XFILLER_56_81 VGND VGND VPWR VPWR sky130_fd_sc_hd__decap_3
Xclkbuf_leaf_28_clk clkload1/A VGND VGND VPWR VPWR _9335_/CLK sky130_fd_sc_hd__clkbuf_8
XFILLER_51_408 VGND VGND VPWR VPWR sky130_fd_sc_hd__decap_3
XFILLER_17_663 VGND VGND VPWR VPWR sky130_fd_sc_hd__decap_3
XFILLER_91_588 VGND VGND VPWR VPWR sky130_fd_sc_hd__fill_1
XFILLER_63_279 VGND VGND VPWR VPWR sky130_fd_sc_hd__fill_1
XFILLER_16_162 VGND VGND VPWR VPWR sky130_fd_sc_hd__decap_3
XFILLER_44_482 VGND VGND VPWR VPWR sky130_fd_sc_hd__decap_3
XFILLER_32_633 VGND VGND VPWR VPWR sky130_fd_sc_hd__decap_3
XFILLER_31_110 VGND VGND VPWR VPWR sky130_fd_sc_hd__fill_2
XTAP_TAPCELL_ROW_63_1136 VGND VPWR sky130_fd_sc_hd__tapvpwrvgnd_1
XFILLER_16_195 VGND VGND VPWR VPWR sky130_fd_sc_hd__fill_1
XFILLER_72_91 VGND VGND VPWR VPWR sky130_fd_sc_hd__fill_2
XFILLER_31_176 VGND VGND VPWR VPWR sky130_fd_sc_hd__decap_3
XFILLER_31_198 VGND VGND VPWR VPWR sky130_fd_sc_hd__fill_1
X_5530_ _5481_/A _5530_/A1 _5530_/S VGND VGND VPWR VPWR _5530_/X sky130_fd_sc_hd__mux2_2
XFILLER_75_3 VGND VGND VPWR VPWR sky130_fd_sc_hd__decap_3
XFILLER_118_716 VGND VGND VPWR VPWR sky130_fd_sc_hd__decap_3
X_5461_ _9277_/Q _9341_/Q _5462_/S VGND VGND VPWR VPWR _5461_/X sky130_fd_sc_hd__mux2_2
XFILLER_118_749 VGND VGND VPWR VPWR sky130_fd_sc_hd__decap_3
XFILLER_8_383 VGND VGND VPWR VPWR sky130_fd_sc_hd__decap_3
X_7200_ _7877_/A _7196_/B _7197_/X _6821_/S _7199_/X VGND VGND VPWR VPWR _7256_/B
+ sky130_fd_sc_hd__o221a_2
X_5392_ _7763_/A _5392_/B VGND VGND VPWR VPWR _5393_/B sky130_fd_sc_hd__xnor2_2
X_8180_ _8180_/A _8180_/B VGND VGND VPWR VPWR _8184_/A sky130_fd_sc_hd__xnor2_2
XFILLER_99_600 VGND VGND VPWR VPWR sky130_fd_sc_hd__decap_3
XFILLER_126_760 VGND VGND VPWR VPWR sky130_fd_sc_hd__decap_3
XPHY_EDGE_ROW_99_Right_99 VGND VGND VPWR VPWR sky130_fd_sc_hd__decap_3
X_7131_ _7033_/X _7032_/X _7388_/A _7388_/B VGND VGND VPWR VPWR _7133_/B sky130_fd_sc_hd__a211o_4
XFILLER_125_270 VGND VGND VPWR VPWR sky130_fd_sc_hd__decap_3
XFILLER_98_121 VGND VGND VPWR VPWR sky130_fd_sc_hd__decap_3
XFILLER_125_281 VGND VGND VPWR VPWR sky130_fd_sc_hd__decap_3
XFILLER_99_666 VGND VGND VPWR VPWR sky130_fd_sc_hd__decap_3
XFILLER_113_443 VGND VGND VPWR VPWR sky130_fd_sc_hd__decap_3
XTAP_TAPCELL_ROW_74_1276 VGND VPWR sky130_fd_sc_hd__tapvpwrvgnd_1
X_7062_ _7357_/A _7357_/C _7062_/C VGND VGND VPWR VPWR _7063_/C sky130_fd_sc_hd__nand3_2
XTAP_TAPCELL_ROW_74_1287 VGND VPWR sky130_fd_sc_hd__tapvpwrvgnd_1
XFILLER_98_154 VGND VGND VPWR VPWR sky130_fd_sc_hd__decap_3
XFILLER_98_176 VGND VGND VPWR VPWR sky130_fd_sc_hd__decap_3
XFILLER_113_487 VGND VGND VPWR VPWR sky130_fd_sc_hd__decap_3
XFILLER_100_115 VGND VGND VPWR VPWR sky130_fd_sc_hd__fill_2
X_6013_ _6013_/A _6013_/B VGND VGND VPWR VPWR _6023_/B sky130_fd_sc_hd__xnor2_2
XFILLER_86_338 VGND VGND VPWR VPWR sky130_fd_sc_hd__decap_3
XFILLER_79_390 VGND VGND VPWR VPWR sky130_fd_sc_hd__fill_2
XFILLER_39_254 VGND VGND VPWR VPWR sky130_fd_sc_hd__decap_3
XFILLER_94_371 VGND VGND VPWR VPWR sky130_fd_sc_hd__decap_3
XFILLER_82_511 VGND VGND VPWR VPWR sky130_fd_sc_hd__fill_2
XFILLER_36_29 VGND VGND VPWR VPWR sky130_fd_sc_hd__decap_3
XFILLER_27_427 VGND VGND VPWR VPWR sky130_fd_sc_hd__decap_3
XFILLER_82_533 VGND VGND VPWR VPWR sky130_fd_sc_hd__decap_3
XFILLER_39_298 VGND VGND VPWR VPWR sky130_fd_sc_hd__decap_3
XFILLER_27_449 VGND VGND VPWR VPWR sky130_fd_sc_hd__decap_3
X_7964_ _7964_/A _7964_/B VGND VGND VPWR VPWR _7965_/B sky130_fd_sc_hd__xor2_2
Xclkbuf_leaf_19_clk clkbuf_leaf_9_clk/A VGND VGND VPWR VPWR _9159_/CLK sky130_fd_sc_hd__clkbuf_8
XFILLER_82_555 VGND VGND VPWR VPWR sky130_fd_sc_hd__decap_3
XFILLER_70_717 VGND VGND VPWR VPWR sky130_fd_sc_hd__decap_3
X_6915_ _6915_/A _6915_/B VGND VGND VPWR VPWR _7274_/B sky130_fd_sc_hd__and2_4
XTAP_TAPCELL_ROW_25_617 VGND VPWR sky130_fd_sc_hd__tapvpwrvgnd_1
XFILLER_23_600 VGND VGND VPWR VPWR sky130_fd_sc_hd__decap_3
X_7895_ _7895_/A _7895_/B VGND VGND VPWR VPWR _7997_/B sky130_fd_sc_hd__xnor2_2
XFILLER_35_471 VGND VGND VPWR VPWR sky130_fd_sc_hd__decap_3
XFILLER_35_493 VGND VGND VPWR VPWR sky130_fd_sc_hd__decap_3
X_6846_ _6788_/B _7885_/B _6843_/X _6845_/Y VGND VGND VPWR VPWR _6846_/X sky130_fd_sc_hd__a31o_2
XFILLER_22_121 VGND VGND VPWR VPWR sky130_fd_sc_hd__decap_3
XFILLER_23_655 VGND VGND VPWR VPWR sky130_fd_sc_hd__fill_2
XFILLER_50_452 VGND VGND VPWR VPWR sky130_fd_sc_hd__decap_3
XFILLER_23_666 VGND VGND VPWR VPWR sky130_fd_sc_hd__fill_1
X_6777_ _6777_/A _6777_/B _6777_/C VGND VGND VPWR VPWR _6778_/C sky130_fd_sc_hd__nand3_2
X_8516_ _7593_/X _8350_/B _8494_/X VGND VGND VPWR VPWR _8516_/Y sky130_fd_sc_hd__a21oi_2
XFILLER_10_349 VGND VGND VPWR VPWR sky130_fd_sc_hd__decap_3
X_5728_ _5727_/A _5727_/B _5595_/B VGND VGND VPWR VPWR _5729_/B sky130_fd_sc_hd__a21o_2
XFILLER_6_309 VGND VGND VPWR VPWR sky130_fd_sc_hd__decap_3
X_8447_ wire61/X VGND VGND VPWR VPWR _8447_/X sky130_fd_sc_hd__clkbuf_1
X_5659_ _5930_/C _6817_/A VGND VGND VPWR VPWR _5659_/Y sky130_fd_sc_hd__nor2_2
XFILLER_108_259 VGND VGND VPWR VPWR sky130_fd_sc_hd__decap_3
XFILLER_124_719 VGND VGND VPWR VPWR sky130_fd_sc_hd__decap_3
X_8378_ _8379_/A _8374_/B _8379_/B VGND VGND VPWR VPWR _8378_/Y sky130_fd_sc_hd__o21ai_2
XFILLER_117_771 VGND VGND VPWR VPWR sky130_fd_sc_hd__decap_3
XFILLER_117_21 VGND VGND VPWR VPWR sky130_fd_sc_hd__decap_3
X_7329_ _7413_/A _7416_/A _7329_/C _7417_/B VGND VGND VPWR VPWR _7329_/X sky130_fd_sc_hd__and4_2
XFILLER_7_6 VGND VGND VPWR VPWR sky130_fd_sc_hd__decap_3
XFILLER_89_121 VGND VGND VPWR VPWR sky130_fd_sc_hd__fill_2
XFILLER_117_54 VGND VGND VPWR VPWR sky130_fd_sc_hd__fill_2
XFILLER_104_454 VGND VGND VPWR VPWR sky130_fd_sc_hd__decap_3
XFILLER_89_154 VGND VGND VPWR VPWR sky130_fd_sc_hd__decap_3
XFILLER_117_87 VGND VGND VPWR VPWR sky130_fd_sc_hd__decap_3
XFILLER_77_47 VGND VGND VPWR VPWR sky130_fd_sc_hd__decap_3
XFILLER_77_316 VGND VGND VPWR VPWR sky130_fd_sc_hd__decap_3
XFILLER_58_530 VGND VGND VPWR VPWR sky130_fd_sc_hd__fill_2
XTAP_TAPCELL_ROW_5_353 VGND VPWR sky130_fd_sc_hd__tapvpwrvgnd_1
Xhold1050 _8999_/X VGND VGND VPWR VPWR _9000_/A sky130_fd_sc_hd__dlygate4sd3_1
XFILLER_93_13 VGND VGND VPWR VPWR sky130_fd_sc_hd__decap_3
XFILLER_58_585 VGND VGND VPWR VPWR sky130_fd_sc_hd__decap_3
Xhold1061 _9107_/Q VGND VGND VPWR VPWR _4752_/A1 sky130_fd_sc_hd__dlygate4sd3_1
Xhold1072 _9015_/X VGND VGND VPWR VPWR _9016_/A sky130_fd_sc_hd__dlygate4sd3_1
XFILLER_73_533 VGND VGND VPWR VPWR sky130_fd_sc_hd__decap_3
Xhold1083 _9152_/Q VGND VGND VPWR VPWR _4847_/A1 sky130_fd_sc_hd__dlygate4sd3_1
XFILLER_85_393 VGND VGND VPWR VPWR sky130_fd_sc_hd__decap_3
XFILLER_18_449 VGND VGND VPWR VPWR sky130_fd_sc_hd__decap_3
Xhold1094 _8978_/X VGND VGND VPWR VPWR _8979_/A sky130_fd_sc_hd__dlygate4sd3_1
XFILLER_46_769 VGND VGND VPWR VPWR sky130_fd_sc_hd__decap_3
XFILLER_61_706 VGND VGND VPWR VPWR sky130_fd_sc_hd__decap_3
XFILLER_45_257 VGND VGND VPWR VPWR sky130_fd_sc_hd__decap_3
XFILLER_33_419 VGND VGND VPWR VPWR sky130_fd_sc_hd__fill_2
XFILLER_60_205 VGND VGND VPWR VPWR sky130_fd_sc_hd__decap_3
XFILLER_26_471 VGND VGND VPWR VPWR sky130_fd_sc_hd__decap_3
XFILLER_14_622 VGND VGND VPWR VPWR sky130_fd_sc_hd__decap_3
XFILLER_60_238 VGND VGND VPWR VPWR sky130_fd_sc_hd__fill_1
XTAP_TAPCELL_ROW_52_981 VGND VPWR sky130_fd_sc_hd__tapvpwrvgnd_1
XFILLER_9_147 VGND VGND VPWR VPWR sky130_fd_sc_hd__decap_3
XFILLER_13_198 VGND VGND VPWR VPWR sky130_fd_sc_hd__decap_3
XFILLER_127_502 VGND VGND VPWR VPWR sky130_fd_sc_hd__fill_2
XFILLER_42_83 VGND VGND VPWR VPWR sky130_fd_sc_hd__fill_1
XFILLER_127_524 VGND VGND VPWR VPWR sky130_fd_sc_hd__decap_3
XFILLER_127_535 VGND VGND VPWR VPWR sky130_fd_sc_hd__decap_3
XFILLER_61_9 VGND VGND VPWR VPWR sky130_fd_sc_hd__decap_3
Xrebuffer480 _5986_/Y VGND VGND VPWR VPWR _6256_/B1 sky130_fd_sc_hd__buf_2
XFILLER_115_719 VGND VGND VPWR VPWR sky130_fd_sc_hd__decap_3
Xrebuffer491 _5010_/X VGND VGND VPWR VPWR _6953_/B sky130_fd_sc_hd__buf_4
XTAP_TAPCELL_ROW_114_1822 VGND VPWR sky130_fd_sc_hd__tapvpwrvgnd_1
XFILLER_5_364 VGND VGND VPWR VPWR sky130_fd_sc_hd__decap_3
XFILLER_123_741 VGND VGND VPWR VPWR sky130_fd_sc_hd__decap_3
XFILLER_122_240 VGND VGND VPWR VPWR sky130_fd_sc_hd__decap_3
XFILLER_123_774 VGND VGND VPWR VPWR sky130_fd_sc_hd__decap_3
XFILLER_3_33 VGND VGND VPWR VPWR sky130_fd_sc_hd__decap_3
XFILLER_96_625 VGND VGND VPWR VPWR sky130_fd_sc_hd__decap_3
XFILLER_95_113 VGND VGND VPWR VPWR sky130_fd_sc_hd__decap_3
XFILLER_68_327 VGND VGND VPWR VPWR sky130_fd_sc_hd__decap_3
XFILLER_122_273 VGND VGND VPWR VPWR sky130_fd_sc_hd__decap_3
XFILLER_110_413 VGND VGND VPWR VPWR sky130_fd_sc_hd__decap_3
XFILLER_110_424 VGND VGND VPWR VPWR sky130_fd_sc_hd__decap_3
XFILLER_3_66 VGND VGND VPWR VPWR sky130_fd_sc_hd__decap_3
XFILLER_122_295 VGND VGND VPWR VPWR sky130_fd_sc_hd__decap_3
XFILLER_95_146 VGND VGND VPWR VPWR sky130_fd_sc_hd__decap_3
XFILLER_49_541 VGND VGND VPWR VPWR sky130_fd_sc_hd__fill_2
XFILLER_3_99 VGND VGND VPWR VPWR sky130_fd_sc_hd__decap_3
XFILLER_37_703 VGND VGND VPWR VPWR sky130_fd_sc_hd__decap_3
XFILLER_49_596 VGND VGND VPWR VPWR sky130_fd_sc_hd__decap_3
XFILLER_37_747 VGND VGND VPWR VPWR sky130_fd_sc_hd__decap_3
XFILLER_36_213 VGND VGND VPWR VPWR sky130_fd_sc_hd__decap_3
XFILLER_64_533 VGND VGND VPWR VPWR sky130_fd_sc_hd__decap_3
Xwire39 wire39/A VGND VGND VPWR VPWR wire39/X sky130_fd_sc_hd__buf_2
XFILLER_91_374 VGND VGND VPWR VPWR sky130_fd_sc_hd__fill_2
XFILLER_51_205 VGND VGND VPWR VPWR sky130_fd_sc_hd__fill_1
XFILLER_36_279 VGND VGND VPWR VPWR sky130_fd_sc_hd__fill_2
X_4961_ _9162_/Q _4516_/X _4955_/X _4956_/X _4960_/X VGND VGND VPWR VPWR _4961_/Y
+ sky130_fd_sc_hd__a2111oi_2
XTAP_TAPCELL_ROW_125_1973 VGND VPWR sky130_fd_sc_hd__tapvpwrvgnd_1
XFILLER_91_396 VGND VGND VPWR VPWR sky130_fd_sc_hd__decap_3
X_6700_ _6699_/B _6699_/C _6699_/A VGND VGND VPWR VPWR _6701_/C sky130_fd_sc_hd__a21o_4
X_7680_ _6446_/B _6856_/A _6790_/Y VGND VGND VPWR VPWR _7681_/B sky130_fd_sc_hd__a21oi_2
X_4892_ _4876_/X _4891_/Y _4878_/X hold797/X VGND VGND VPWR VPWR _4892_/X sky130_fd_sc_hd__a2bb2o_2
X_6631_ _6351_/B _6629_/Y _8410_/S _9209_/Q VGND VGND VPWR VPWR _6632_/B sky130_fd_sc_hd__a211oi_2
X_6562_ _6563_/A _6563_/B _6321_/B VGND VGND VPWR VPWR _6564_/B sky130_fd_sc_hd__a21o_2
XFILLER_20_669 VGND VGND VPWR VPWR sky130_fd_sc_hd__decap_3
XFILLER_118_513 VGND VGND VPWR VPWR sky130_fd_sc_hd__decap_3
X_8301_ _8299_/A _8297_/Y _8300_/Y VGND VGND VPWR VPWR _8301_/X sky130_fd_sc_hd__a21o_2
X_5513_ _5513_/A _5664_/A VGND VGND VPWR VPWR _5550_/B sky130_fd_sc_hd__xnor2_2
X_9281_ _9313_/CLK _9281_/D load_slew388/X VGND VGND VPWR VPWR _9281_/Q sky130_fd_sc_hd__dfrtp_2
XTAP_TAPCELL_ROW_30_686 VGND VPWR sky130_fd_sc_hd__tapvpwrvgnd_1
X_6493_ _6493_/A _6493_/B VGND VGND VPWR VPWR _6494_/B sky130_fd_sc_hd__xnor2_4
XTAP_TAPCELL_ROW_76_1305 VGND VPWR sky130_fd_sc_hd__tapvpwrvgnd_1
X_8232_ _8232_/A _8315_/A VGND VGND VPWR VPWR _8322_/B sky130_fd_sc_hd__nand2_2
X_5444_ _8174_/A _7472_/A VGND VGND VPWR VPWR _5444_/Y sky130_fd_sc_hd__nor2b_2
Xclkbuf_leaf_8_clk clkload1/A VGND VGND VPWR VPWR _9171_/CLK sky130_fd_sc_hd__clkbuf_8
X_8163_ _8163_/A _8163_/B VGND VGND VPWR VPWR _8229_/B sky130_fd_sc_hd__xnor2_2
X_5375_ _9292_/Q _9088_/Q _5384_/A VGND VGND VPWR VPWR _5376_/C sky130_fd_sc_hd__mux2_2
XFILLER_99_441 VGND VGND VPWR VPWR sky130_fd_sc_hd__decap_3
XFILLER_114_741 VGND VGND VPWR VPWR sky130_fd_sc_hd__decap_3
XFILLER_99_452 VGND VGND VPWR VPWR sky130_fd_sc_hd__decap_3
X_7114_ _9211_/Q _7114_/B _7114_/C VGND VGND VPWR VPWR _7114_/X sky130_fd_sc_hd__and3_2
X_8094_ _8094_/A _8094_/B VGND VGND VPWR VPWR _8109_/A sky130_fd_sc_hd__xnor2_2
XFILLER_59_316 VGND VGND VPWR VPWR sky130_fd_sc_hd__decap_3
XFILLER_101_424 VGND VGND VPWR VPWR sky130_fd_sc_hd__decap_3
X_7045_ _5999_/A _5999_/B _5353_/X VGND VGND VPWR VPWR _7295_/C sky130_fd_sc_hd__a21oi_2
XFILLER_86_168 VGND VGND VPWR VPWR sky130_fd_sc_hd__fill_1
XTAP_TAPCELL_ROW_2_312 VGND VPWR sky130_fd_sc_hd__tapvpwrvgnd_1
XFILLER_28_714 VGND VGND VPWR VPWR sky130_fd_sc_hd__decap_3
XFILLER_103_12 VGND VGND VPWR VPWR sky130_fd_sc_hd__decap_3
XFILLER_55_555 VGND VGND VPWR VPWR sky130_fd_sc_hd__decap_3
XFILLER_28_769 VGND VGND VPWR VPWR sky130_fd_sc_hd__decap_3
X_8996_ _8996_/A VGND VGND VPWR VPWR _9338_/D sky130_fd_sc_hd__buf_1
XTAP_TAPCELL_ROW_87_1456 VGND VPWR sky130_fd_sc_hd__tapvpwrvgnd_1
XFILLER_82_363 VGND VGND VPWR VPWR sky130_fd_sc_hd__fill_1
XFILLER_15_408 VGND VGND VPWR VPWR sky130_fd_sc_hd__decap_3
XFILLER_27_279 VGND VGND VPWR VPWR sky130_fd_sc_hd__fill_1
X_7947_ _7946_/B _7946_/C _7946_/A VGND VGND VPWR VPWR _7948_/C sky130_fd_sc_hd__a21oi_2
XTAP_TAPCELL_ROW_38_797 VGND VPWR sky130_fd_sc_hd__tapvpwrvgnd_1
XFILLER_70_525 VGND VGND VPWR VPWR sky130_fd_sc_hd__decap_3
XFILLER_70_569 VGND VGND VPWR VPWR sky130_fd_sc_hd__fill_2
XFILLER_35_290 VGND VGND VPWR VPWR sky130_fd_sc_hd__decap_3
X_7878_ _6797_/Y _7881_/C _7243_/A VGND VGND VPWR VPWR _7878_/X sky130_fd_sc_hd__a21o_2
XFILLER_23_441 VGND VGND VPWR VPWR sky130_fd_sc_hd__decap_3
XFILLER_11_614 VGND VGND VPWR VPWR sky130_fd_sc_hd__fill_2
X_6829_ _7522_/A _7520_/A VGND VGND VPWR VPWR _7231_/A sky130_fd_sc_hd__xnor2_2
XFILLER_10_102 VGND VGND VPWR VPWR sky130_fd_sc_hd__fill_2
XFILLER_11_658 VGND VGND VPWR VPWR sky130_fd_sc_hd__decap_3
XFILLER_109_502 VGND VGND VPWR VPWR sky130_fd_sc_hd__fill_2
XFILLER_109_513 VGND VGND VPWR VPWR sky130_fd_sc_hd__decap_3
XFILLER_6_106 VGND VGND VPWR VPWR sky130_fd_sc_hd__decap_3
XFILLER_6_117 VGND VGND VPWR VPWR sky130_fd_sc_hd__decap_3
XFILLER_109_557 VGND VGND VPWR VPWR sky130_fd_sc_hd__decap_3
XFILLER_128_53 VGND VGND VPWR VPWR sky130_fd_sc_hd__decap_3
XFILLER_88_24 VGND VGND VPWR VPWR sky130_fd_sc_hd__fill_1
XFILLER_128_97 VGND VGND VPWR VPWR sky130_fd_sc_hd__decap_3
XFILLER_5_3 VGND VGND VPWR VPWR sky130_fd_sc_hd__decap_3
XFILLER_78_614 VGND VGND VPWR VPWR sky130_fd_sc_hd__fill_2
XFILLER_104_262 VGND VGND VPWR VPWR sky130_fd_sc_hd__decap_3
XFILLER_120_722 VGND VGND VPWR VPWR sky130_fd_sc_hd__decap_3
XFILLER_78_636 VGND VGND VPWR VPWR sky130_fd_sc_hd__decap_3
XFILLER_104_295 VGND VGND VPWR VPWR sky130_fd_sc_hd__fill_2
XFILLER_120_755 VGND VGND VPWR VPWR sky130_fd_sc_hd__fill_1
XFILLER_120_766 VGND VGND VPWR VPWR sky130_fd_sc_hd__decap_3
XFILLER_93_617 VGND VGND VPWR VPWR sky130_fd_sc_hd__decap_3
XFILLER_58_371 VGND VGND VPWR VPWR sky130_fd_sc_hd__decap_3
XFILLER_19_725 VGND VGND VPWR VPWR sky130_fd_sc_hd__decap_3
XFILLER_46_533 VGND VGND VPWR VPWR sky130_fd_sc_hd__decap_3
XFILLER_19_747 VGND VGND VPWR VPWR sky130_fd_sc_hd__decap_3
XFILLER_85_190 VGND VGND VPWR VPWR sky130_fd_sc_hd__fill_1
XFILLER_46_555 VGND VGND VPWR VPWR sky130_fd_sc_hd__decap_3
XFILLER_73_352 VGND VGND VPWR VPWR sky130_fd_sc_hd__decap_3
XFILLER_34_728 VGND VGND VPWR VPWR sky130_fd_sc_hd__decap_3
XFILLER_18_279 VGND VGND VPWR VPWR sky130_fd_sc_hd__decap_3
XFILLER_61_514 VGND VGND VPWR VPWR sky130_fd_sc_hd__decap_3
XFILLER_33_238 VGND VGND VPWR VPWR sky130_fd_sc_hd__decap_3
XFILLER_61_558 VGND VGND VPWR VPWR sky130_fd_sc_hd__fill_2
XFILLER_14_430 VGND VGND VPWR VPWR sky130_fd_sc_hd__decap_3
XFILLER_42_772 VGND VGND VPWR VPWR sky130_fd_sc_hd__decap_3
XFILLER_14_474 VGND VGND VPWR VPWR sky130_fd_sc_hd__fill_2
XFILLER_127_343 VGND VGND VPWR VPWR sky130_fd_sc_hd__decap_3
XFILLER_127_376 VGND VGND VPWR VPWR sky130_fd_sc_hd__decap_3
XFILLER_115_516 VGND VGND VPWR VPWR sky130_fd_sc_hd__decap_3
XFILLER_6_684 VGND VGND VPWR VPWR sky130_fd_sc_hd__decap_3
XTAP_TAPCELL_ROW_58_1068 VGND VPWR sky130_fd_sc_hd__tapvpwrvgnd_1
XFILLER_115_549 VGND VGND VPWR VPWR sky130_fd_sc_hd__decap_3
XFILLER_130_508 VGND VGND VPWR VPWR sky130_fd_sc_hd__decap_3
X_5160_ _5160_/A _5160_/B VGND VGND VPWR VPWR _5160_/X sky130_fd_sc_hd__or2_2
XFILLER_111_700 VGND VGND VPWR VPWR sky130_fd_sc_hd__decap_3
XTAP_TAPCELL_ROW_71_1235 VGND VPWR sky130_fd_sc_hd__tapvpwrvgnd_1
XFILLER_38_3 VGND VGND VPWR VPWR sky130_fd_sc_hd__decap_3
XTAP_TAPCELL_ROW_71_1246 VGND VPWR sky130_fd_sc_hd__tapvpwrvgnd_1
XFILLER_69_647 VGND VGND VPWR VPWR sky130_fd_sc_hd__fill_2
XFILLER_69_658 VGND VGND VPWR VPWR sky130_fd_sc_hd__decap_3
X_5091_ _5081_/Y _5089_/X _7219_/S VGND VGND VPWR VPWR _5092_/A sky130_fd_sc_hd__mux2_2
XFILLER_96_455 VGND VGND VPWR VPWR sky130_fd_sc_hd__decap_3
XFILLER_96_466 VGND VGND VPWR VPWR sky130_fd_sc_hd__fill_1
XFILLER_96_477 VGND VGND VPWR VPWR sky130_fd_sc_hd__fill_1
XFILLER_96_488 VGND VGND VPWR VPWR sky130_fd_sc_hd__decap_3
XFILLER_83_116 VGND VGND VPWR VPWR sky130_fd_sc_hd__decap_3
XFILLER_49_371 VGND VGND VPWR VPWR sky130_fd_sc_hd__decap_3
XFILLER_37_511 VGND VGND VPWR VPWR sky130_fd_sc_hd__decap_3
X_8850_ hold852/X _8850_/A1 _8862_/S VGND VGND VPWR VPWR _8851_/A sky130_fd_sc_hd__mux2_2
X_7801_ _8066_/B _8248_/B _7800_/Y _7569_/A _7448_/A VGND VGND VPWR VPWR _7801_/X
+ sky130_fd_sc_hd__a221o_2
XFILLER_64_363 VGND VGND VPWR VPWR sky130_fd_sc_hd__fill_1
X_8781_ _8777_/B _8781_/A2 _8778_/A _8175_/A VGND VGND VPWR VPWR _8783_/B sky130_fd_sc_hd__a31o_2
XFILLER_91_160 VGND VGND VPWR VPWR sky130_fd_sc_hd__decap_3
X_5993_ _6344_/A1 _9249_/Q _5987_/X _5991_/X _5992_/X VGND VGND VPWR VPWR _5993_/Y
+ sky130_fd_sc_hd__a2111oi_4
XFILLER_52_536 VGND VGND VPWR VPWR sky130_fd_sc_hd__decap_3
X_7732_ _8034_/A _8006_/A VGND VGND VPWR VPWR _7891_/A sky130_fd_sc_hd__nand2_2
X_4944_ _4941_/X _4942_/Y _4943_/X _8778_/A VGND VGND VPWR VPWR _4944_/X sky130_fd_sc_hd__o31a_2
XTAP_TAPCELL_ROW_35_756 VGND VPWR sky130_fd_sc_hd__tapvpwrvgnd_1
X_7663_ _7660_/X _7662_/X _7702_/A VGND VGND VPWR VPWR _7663_/X sky130_fd_sc_hd__a21o_2
X_4875_ _9178_/D _4875_/B VGND VGND VPWR VPWR _4876_/A sky130_fd_sc_hd__nand2_2
XTAP_TAPCELL_ROW_82_1386 VGND VPWR sky130_fd_sc_hd__tapvpwrvgnd_1
XFILLER_20_411 VGND VGND VPWR VPWR sky130_fd_sc_hd__decap_3
XFILLER_32_282 VGND VGND VPWR VPWR sky130_fd_sc_hd__decap_3
XTAP_TAPCELL_ROW_15_480 VGND VPWR sky130_fd_sc_hd__tapvpwrvgnd_1
XFILLER_20_433 VGND VGND VPWR VPWR sky130_fd_sc_hd__decap_3
X_6614_ _9048_/Q _4521_/X _6757_/C _5456_/B _9080_/Q VGND VGND VPWR VPWR _6614_/X
+ sky130_fd_sc_hd__a32o_2
X_7594_ _7584_/X _7589_/X _7592_/X _7593_/X VGND VGND VPWR VPWR _7621_/A sky130_fd_sc_hd__a31o_2
XFILLER_20_466 VGND VGND VPWR VPWR sky130_fd_sc_hd__fill_1
XFILLER_20_477 VGND VGND VPWR VPWR sky130_fd_sc_hd__decap_3
X_9333_ _9333_/CLK _9333_/D wire417/X VGND VGND VPWR VPWR _9333_/Q sky130_fd_sc_hd__dfrtp_2
X_6545_ _6550_/B _6963_/D VGND VGND VPWR VPWR _6547_/A sky130_fd_sc_hd__nor2_2
XFILLER_118_332 VGND VGND VPWR VPWR sky130_fd_sc_hd__decap_3
XFILLER_118_365 VGND VGND VPWR VPWR sky130_fd_sc_hd__decap_3
X_9264_ _9338_/CLK _9264_/D load_slew370/X VGND VGND VPWR VPWR _9264_/Q sky130_fd_sc_hd__dfrtp_2
X_6476_ _6422_/A _6422_/B _6475_/X VGND VGND VPWR VPWR _6494_/A sky130_fd_sc_hd__a21o_2
XFILLER_109_9 VGND VGND VPWR VPWR sky130_fd_sc_hd__decap_3
X_8215_ _8350_/A _8215_/B VGND VGND VPWR VPWR _8216_/B sky130_fd_sc_hd__or2_2
X_5427_ _5439_/S _5357_/X _7805_/A _5855_/A VGND VGND VPWR VPWR _5427_/X sky130_fd_sc_hd__o22a_2
X_9195_ _9228_/CLK _9195_/D load_slew416/X VGND VGND VPWR VPWR _9195_/Q sky130_fd_sc_hd__dfrtp_2
X_8146_ _8072_/A _8072_/B _8145_/X VGND VGND VPWR VPWR _8218_/B sky130_fd_sc_hd__a21o_2
XFILLER_102_711 VGND VGND VPWR VPWR sky130_fd_sc_hd__decap_3
X_5358_ _8137_/A _5439_/S _5357_/X VGND VGND VPWR VPWR _5358_/X sky130_fd_sc_hd__o21a_2
XFILLER_114_571 VGND VGND VPWR VPWR sky130_fd_sc_hd__decap_3
XFILLER_102_722 VGND VGND VPWR VPWR sky130_fd_sc_hd__decap_3
XFILLER_59_113 VGND VGND VPWR VPWR sky130_fd_sc_hd__decap_3
XFILLER_58_49 VGND VGND VPWR VPWR sky130_fd_sc_hd__decap_3
XFILLER_101_210 VGND VGND VPWR VPWR sky130_fd_sc_hd__decap_3
XFILLER_87_444 VGND VGND VPWR VPWR sky130_fd_sc_hd__decap_3
XFILLER_59_135 VGND VGND VPWR VPWR sky130_fd_sc_hd__decap_3
X_8077_ _7964_/A _7964_/B _8076_/X VGND VGND VPWR VPWR _8078_/B sky130_fd_sc_hd__a21o_2
X_5289_ _5707_/B VGND VGND VPWR VPWR _7799_/A sky130_fd_sc_hd__clkbuf_2
XFILLER_87_466 VGND VGND VPWR VPWR sky130_fd_sc_hd__fill_2
XFILLER_75_617 VGND VGND VPWR VPWR sky130_fd_sc_hd__decap_3
X_7028_ _7029_/A _7029_/B VGND VGND VPWR VPWR _7028_/Y sky130_fd_sc_hd__nand2_2
XFILLER_28_500 VGND VGND VPWR VPWR sky130_fd_sc_hd__decap_3
XFILLER_75_639 VGND VGND VPWR VPWR sky130_fd_sc_hd__decap_3
XFILLER_114_44 VGND VGND VPWR VPWR sky130_fd_sc_hd__decap_3
XFILLER_101_287 VGND VGND VPWR VPWR sky130_fd_sc_hd__fill_1
XFILLER_101_298 VGND VGND VPWR VPWR sky130_fd_sc_hd__decap_3
XFILLER_114_77 VGND VGND VPWR VPWR sky130_fd_sc_hd__decap_3
XFILLER_114_88 VGND VGND VPWR VPWR sky130_fd_sc_hd__fill_1
XFILLER_55_352 VGND VGND VPWR VPWR sky130_fd_sc_hd__decap_3
XFILLER_83_683 VGND VGND VPWR VPWR sky130_fd_sc_hd__decap_3
XFILLER_16_728 VGND VGND VPWR VPWR sky130_fd_sc_hd__decap_3
XFILLER_82_160 VGND VGND VPWR VPWR sky130_fd_sc_hd__decap_3
X_8979_ _8979_/A VGND VGND VPWR VPWR _9330_/D sky130_fd_sc_hd__buf_1
XFILLER_130_21 VGND VGND VPWR VPWR sky130_fd_sc_hd__decap_3
XFILLER_55_396 VGND VGND VPWR VPWR sky130_fd_sc_hd__decap_3
XFILLER_15_238 VGND VGND VPWR VPWR sky130_fd_sc_hd__decap_3
XFILLER_130_32 VGND VGND VPWR VPWR sky130_fd_sc_hd__decap_3
XFILLER_43_558 VGND VGND VPWR VPWR sky130_fd_sc_hd__fill_2
XFILLER_24_750 VGND VGND VPWR VPWR sky130_fd_sc_hd__decap_3
XFILLER_30_208 VGND VGND VPWR VPWR sky130_fd_sc_hd__decap_3
XFILLER_24_772 VGND VGND VPWR VPWR sky130_fd_sc_hd__decap_3
XFILLER_11_411 VGND VGND VPWR VPWR sky130_fd_sc_hd__decap_3
XFILLER_23_41 VGND VGND VPWR VPWR sky130_fd_sc_hd__decap_3
Xwire313 _8045_/S VGND VGND VPWR VPWR wire313/X sky130_fd_sc_hd__buf_4
XFILLER_11_455 VGND VGND VPWR VPWR sky130_fd_sc_hd__fill_1
XFILLER_128_118 VGND VGND VPWR VPWR sky130_fd_sc_hd__decap_3
XFILLER_7_426 VGND VGND VPWR VPWR sky130_fd_sc_hd__decap_3
XFILLER_11_477 VGND VGND VPWR VPWR sky130_fd_sc_hd__decap_3
XFILLER_23_85 VGND VGND VPWR VPWR sky130_fd_sc_hd__decap_3
XFILLER_99_12 VGND VGND VPWR VPWR sky130_fd_sc_hd__decap_3
XFILLER_7_459 VGND VGND VPWR VPWR sky130_fd_sc_hd__fill_2
XFILLER_109_387 VGND VGND VPWR VPWR sky130_fd_sc_hd__decap_3
XFILLER_3_610 VGND VGND VPWR VPWR sky130_fd_sc_hd__decap_3
XFILLER_124_324 VGND VGND VPWR VPWR sky130_fd_sc_hd__fill_2
XFILLER_3_632 VGND VGND VPWR VPWR sky130_fd_sc_hd__decap_3
XFILLER_3_665 VGND VGND VPWR VPWR sky130_fd_sc_hd__decap_3
XFILLER_112_519 VGND VGND VPWR VPWR sky130_fd_sc_hd__decap_3
Xload_slew307 _5957_/A VGND VGND VPWR VPWR _5221_/A sky130_fd_sc_hd__buf_2
XFILLER_3_676 VGND VGND VPWR VPWR sky130_fd_sc_hd__decap_3
Xload_slew318 _6098_/A VGND VGND VPWR VPWR _6886_/A sky130_fd_sc_hd__buf_2
Xload_slew329 _6821_/S VGND VGND VPWR VPWR _6482_/A sky130_fd_sc_hd__clkbuf_2
XFILLER_78_411 VGND VGND VPWR VPWR sky130_fd_sc_hd__decap_3
XFILLER_2_197 VGND VGND VPWR VPWR sky130_fd_sc_hd__decap_3
XFILLER_24_9 VGND VGND VPWR VPWR sky130_fd_sc_hd__decap_3
XFILLER_78_466 VGND VGND VPWR VPWR sky130_fd_sc_hd__decap_3
XFILLER_66_606 VGND VGND VPWR VPWR sky130_fd_sc_hd__decap_3
XFILLER_93_403 VGND VGND VPWR VPWR sky130_fd_sc_hd__decap_3
XFILLER_78_488 VGND VGND VPWR VPWR sky130_fd_sc_hd__decap_3
XFILLER_66_639 VGND VGND VPWR VPWR sky130_fd_sc_hd__decap_3
XFILLER_48_71 VGND VGND VPWR VPWR sky130_fd_sc_hd__decap_3
XFILLER_93_425 VGND VGND VPWR VPWR sky130_fd_sc_hd__decap_3
XFILLER_65_116 VGND VGND VPWR VPWR sky130_fd_sc_hd__decap_3
XFILLER_19_522 VGND VGND VPWR VPWR sky130_fd_sc_hd__decap_3
XFILLER_0_12 VGND VGND VPWR VPWR sky130_fd_sc_hd__decap_3
XFILLER_93_458 VGND VGND VPWR VPWR sky130_fd_sc_hd__decap_3
XFILLER_81_609 VGND VGND VPWR VPWR sky130_fd_sc_hd__decap_3
XTAP_TAPCELL_ROW_109_1754 VGND VPWR sky130_fd_sc_hd__tapvpwrvgnd_1
XFILLER_19_555 VGND VGND VPWR VPWR sky130_fd_sc_hd__decap_3
XPHY_EDGE_ROW_100_Left_231 VGND VGND VPWR VPWR sky130_fd_sc_hd__decap_3
XFILLER_74_683 VGND VGND VPWR VPWR sky130_fd_sc_hd__fill_1
XFILLER_46_374 VGND VGND VPWR VPWR sky130_fd_sc_hd__decap_3
XFILLER_34_514 VGND VGND VPWR VPWR sky130_fd_sc_hd__decap_3
XFILLER_0_89 VGND VGND VPWR VPWR sky130_fd_sc_hd__decap_3
XFILLER_34_536 VGND VGND VPWR VPWR sky130_fd_sc_hd__decap_3
XFILLER_61_333 VGND VGND VPWR VPWR sky130_fd_sc_hd__decap_3
XTAP_TAPCELL_ROW_122_1932 VGND VPWR sky130_fd_sc_hd__tapvpwrvgnd_1
XFILLER_61_355 VGND VGND VPWR VPWR sky130_fd_sc_hd__decap_3
XFILLER_15_750 VGND VGND VPWR VPWR sky130_fd_sc_hd__decap_3
XTAP_TAPCELL_ROW_32_715 VGND VPWR sky130_fd_sc_hd__tapvpwrvgnd_1
XFILLER_9_21 VGND VGND VPWR VPWR sky130_fd_sc_hd__decap_3
XFILLER_61_388 VGND VGND VPWR VPWR sky130_fd_sc_hd__decap_3
XFILLER_9_54 VGND VGND VPWR VPWR sky130_fd_sc_hd__fill_2
XFILLER_30_742 VGND VGND VPWR VPWR sky130_fd_sc_hd__fill_1
XFILLER_14_293 VGND VGND VPWR VPWR sky130_fd_sc_hd__decap_3
X_4660_ _9079_/Q _4660_/A1 _4672_/S VGND VGND VPWR VPWR _4660_/X sky130_fd_sc_hd__mux2_2
XFILLER_30_775 VGND VGND VPWR VPWR sky130_fd_sc_hd__fill_2
XTAP_TAPCELL_ROW_12_450 VGND VPWR sky130_fd_sc_hd__tapvpwrvgnd_1
X_4591_ _4591_/A VGND VGND VPWR VPWR _9046_/D sky130_fd_sc_hd__buf_1
XFILLER_128_663 VGND VGND VPWR VPWR sky130_fd_sc_hd__decap_3
XFILLER_127_140 VGND VGND VPWR VPWR sky130_fd_sc_hd__decap_3
X_6330_ _6181_/B _6180_/A _6329_/X VGND VGND VPWR VPWR _6351_/B sky130_fd_sc_hd__a21o_2
Xhold905 _4556_/X VGND VGND VPWR VPWR _4557_/A sky130_fd_sc_hd__dlygate4sd3_1
Xhold916 _9240_/Q VGND VGND VPWR VPWR hold916/X sky130_fd_sc_hd__dlygate4sd3_1
XFILLER_128_696 VGND VGND VPWR VPWR sky130_fd_sc_hd__decap_3
Xhold927 _4581_/X VGND VGND VPWR VPWR _4582_/A sky130_fd_sc_hd__dlygate4sd3_1
XFILLER_127_184 VGND VGND VPWR VPWR sky130_fd_sc_hd__decap_3
Xhold938 _8860_/X VGND VGND VPWR VPWR _8861_/A sky130_fd_sc_hd__dlygate4sd3_1
X_6261_ _6261_/A _6261_/B VGND VGND VPWR VPWR _6262_/B sky130_fd_sc_hd__nand2_2
Xhold949 _9084_/Q VGND VGND VPWR VPWR hold949/X sky130_fd_sc_hd__dlygate4sd3_1
XFILLER_89_709 VGND VGND VPWR VPWR sky130_fd_sc_hd__decap_3
XFILLER_115_346 VGND VGND VPWR VPWR sky130_fd_sc_hd__decap_3
X_8000_ _7742_/Y _7994_/X _7996_/X _7856_/B _7999_/Y VGND VGND VPWR VPWR _8000_/X
+ sky130_fd_sc_hd__a221o_2
X_5212_ _5048_/B _5167_/Y _5152_/A _5213_/S VGND VGND VPWR VPWR _5212_/X sky130_fd_sc_hd__o211a_2
X_6192_ _6193_/C _6193_/B _6193_/A VGND VGND VPWR VPWR _6218_/A sky130_fd_sc_hd__a21o_4
XFILLER_97_720 VGND VGND VPWR VPWR sky130_fd_sc_hd__decap_3
XFILLER_130_327 VGND VGND VPWR VPWR sky130_fd_sc_hd__decap_3
XFILLER_130_349 VGND VGND VPWR VPWR sky130_fd_sc_hd__decap_3
X_5143_ _5348_/S _5143_/B _5006_/B VGND VGND VPWR VPWR _5143_/X sky130_fd_sc_hd__or3b_4
XFILLER_96_241 VGND VGND VPWR VPWR sky130_fd_sc_hd__decap_3
XFILLER_111_541 VGND VGND VPWR VPWR sky130_fd_sc_hd__decap_3
XFILLER_57_606 VGND VGND VPWR VPWR sky130_fd_sc_hd__decap_3
XFILLER_69_477 VGND VGND VPWR VPWR sky130_fd_sc_hd__decap_3
XFILLER_29_308 VGND VGND VPWR VPWR sky130_fd_sc_hd__decap_3
XFILLER_111_574 VGND VGND VPWR VPWR sky130_fd_sc_hd__fill_2
X_5074_ _9197_/Q _7095_/A _5167_/B VGND VGND VPWR VPWR _5078_/B sky130_fd_sc_hd__a21o_2
XFILLER_84_414 VGND VGND VPWR VPWR sky130_fd_sc_hd__decap_3
XFILLER_69_488 VGND VGND VPWR VPWR sky130_fd_sc_hd__decap_3
X_8902_ hold886/X _8902_/A1 _8904_/S VGND VGND VPWR VPWR _8903_/A sky130_fd_sc_hd__mux2_2
XFILLER_49_190 VGND VGND VPWR VPWR sky130_fd_sc_hd__decap_3
XFILLER_84_469 VGND VGND VPWR VPWR sky130_fd_sc_hd__decap_3
XFILLER_65_650 VGND VGND VPWR VPWR sky130_fd_sc_hd__decap_3
XFILLER_71_108 VGND VGND VPWR VPWR sky130_fd_sc_hd__decap_3
XFILLER_37_363 VGND VGND VPWR VPWR sky130_fd_sc_hd__fill_1
X_8833_ hold867/X _8833_/A1 _8841_/S VGND VGND VPWR VPWR _8834_/A sky130_fd_sc_hd__mux2_2
XTAP_TAPCELL_ROW_84_1415 VGND VPWR sky130_fd_sc_hd__tapvpwrvgnd_1
XFILLER_37_374 VGND VGND VPWR VPWR sky130_fd_sc_hd__decap_3
XFILLER_52_322 VGND VGND VPWR VPWR sky130_fd_sc_hd__decap_3
XFILLER_44_29 VGND VGND VPWR VPWR sky130_fd_sc_hd__decap_3
XFILLER_52_344 VGND VGND VPWR VPWR sky130_fd_sc_hd__decap_3
X_8764_ _8770_/B _8770_/C _8763_/X VGND VGND VPWR VPWR _8765_/A sky130_fd_sc_hd__o21a_2
XFILLER_13_709 VGND VGND VPWR VPWR sky130_fd_sc_hd__decap_3
X_5976_ _6992_/B VGND VGND VPWR VPWR _7065_/B sky130_fd_sc_hd__buf_8
XFILLER_40_506 VGND VGND VPWR VPWR sky130_fd_sc_hd__decap_3
XFILLER_40_517 VGND VGND VPWR VPWR sky130_fd_sc_hd__decap_3
X_7715_ _7867_/A _7715_/B VGND VGND VPWR VPWR _7716_/B sky130_fd_sc_hd__xnor2_2
X_4927_ _5624_/C VGND VGND VPWR VPWR _5875_/B sky130_fd_sc_hd__buf_6
X_8695_ _9229_/Q _8695_/B VGND VGND VPWR VPWR _8695_/X sky130_fd_sc_hd__or2_2
XFILLER_21_720 VGND VGND VPWR VPWR sky130_fd_sc_hd__decap_3
XFILLER_21_753 VGND VGND VPWR VPWR sky130_fd_sc_hd__decap_3
X_7646_ _9213_/Q _7365_/A _7484_/A _7641_/X _7645_/X VGND VGND VPWR VPWR _7647_/B
+ sky130_fd_sc_hd__o32a_2
X_4858_ _4858_/A VGND VGND VPWR VPWR _9173_/D sky130_fd_sc_hd__buf_1
XFILLER_20_274 VGND VGND VPWR VPWR sky130_fd_sc_hd__decap_3
X_7577_ _7576_/X _7454_/A _7440_/X VGND VGND VPWR VPWR _7577_/X sky130_fd_sc_hd__a21o_2
X_4789_ _4789_/A VGND VGND VPWR VPWR _9140_/D sky130_fd_sc_hd__buf_1
XFILLER_20_296 VGND VGND VPWR VPWR sky130_fd_sc_hd__decap_3
X_9316_ _9331_/CLK _9316_/D fanout389/X VGND VGND VPWR VPWR _9316_/Q sky130_fd_sc_hd__dfrtp_2
XFILLER_109_33 VGND VGND VPWR VPWR sky130_fd_sc_hd__decap_3
X_6528_ _6528_/A _6528_/B VGND VGND VPWR VPWR _6529_/B sky130_fd_sc_hd__nand2_2
XFILLER_119_696 VGND VGND VPWR VPWR sky130_fd_sc_hd__decap_3
XTAP_TAPCELL_ROW_95_1566 VGND VPWR sky130_fd_sc_hd__tapvpwrvgnd_1
XFILLER_107_6 VGND VGND VPWR VPWR sky130_fd_sc_hd__decap_3
X_9247_ clkload4/A _9247_/D load_slew374/X VGND VGND VPWR VPWR _9247_/Q sky130_fd_sc_hd__dfrtp_2
X_6459_ _6459_/A _6459_/B VGND VGND VPWR VPWR _6459_/Y sky130_fd_sc_hd__xnor2_2
XFILLER_106_368 VGND VGND VPWR VPWR sky130_fd_sc_hd__fill_1
XFILLER_0_613 VGND VGND VPWR VPWR sky130_fd_sc_hd__decap_3
X_9178_ _9227_/CLK _9178_/D load_slew416/X VGND VGND VPWR VPWR _9178_/Q sky130_fd_sc_hd__dfrtp_2
XFILLER_0_635 VGND VGND VPWR VPWR sky130_fd_sc_hd__decap_3
XFILLER_125_21 VGND VGND VPWR VPWR sky130_fd_sc_hd__decap_3
XFILLER_121_349 VGND VGND VPWR VPWR sky130_fd_sc_hd__decap_3
X_8129_ _8129_/A VGND VGND VPWR VPWR _8218_/A sky130_fd_sc_hd__clkbuf_1
XFILLER_0_657 VGND VGND VPWR VPWR sky130_fd_sc_hd__decap_3
XFILLER_125_54 VGND VGND VPWR VPWR sky130_fd_sc_hd__fill_2
XFILLER_102_552 VGND VGND VPWR VPWR sky130_fd_sc_hd__decap_3
XFILLER_88_775 VGND VGND VPWR VPWR sky130_fd_sc_hd__fill_2
XFILLER_0_679 VGND VGND VPWR VPWR sky130_fd_sc_hd__decap_3
XFILLER_75_403 VGND VGND VPWR VPWR sky130_fd_sc_hd__decap_3
XFILLER_125_87 VGND VGND VPWR VPWR sky130_fd_sc_hd__decap_3
XFILLER_48_639 VGND VGND VPWR VPWR sky130_fd_sc_hd__decap_3
XFILLER_75_447 VGND VGND VPWR VPWR sky130_fd_sc_hd__fill_1
XFILLER_75_469 VGND VGND VPWR VPWR sky130_fd_sc_hd__fill_2
XFILLER_63_609 VGND VGND VPWR VPWR sky130_fd_sc_hd__decap_3
XFILLER_56_661 VGND VGND VPWR VPWR sky130_fd_sc_hd__decap_3
XFILLER_90_439 VGND VGND VPWR VPWR sky130_fd_sc_hd__decap_3
XFILLER_56_694 VGND VGND VPWR VPWR sky130_fd_sc_hd__decap_3
XFILLER_43_333 VGND VGND VPWR VPWR sky130_fd_sc_hd__decap_3
XFILLER_71_686 VGND VGND VPWR VPWR sky130_fd_sc_hd__fill_1
XTAP_TAPCELL_ROW_104_1684 VGND VPWR sky130_fd_sc_hd__tapvpwrvgnd_1
XFILLER_24_580 VGND VGND VPWR VPWR sky130_fd_sc_hd__decap_3
XFILLER_12_731 VGND VGND VPWR VPWR sky130_fd_sc_hd__decap_3
XFILLER_8_713 VGND VGND VPWR VPWR sky130_fd_sc_hd__decap_3
XFILLER_11_241 VGND VGND VPWR VPWR sky130_fd_sc_hd__decap_3
XFILLER_12_775 VGND VGND VPWR VPWR sky130_fd_sc_hd__fill_2
Xwire110 _5094_/X VGND VGND VPWR VPWR wire110/X sky130_fd_sc_hd__buf_6
XFILLER_8_746 VGND VGND VPWR VPWR sky130_fd_sc_hd__decap_3
XFILLER_7_223 VGND VGND VPWR VPWR sky130_fd_sc_hd__fill_1
Xwire143 _6626_/A VGND VGND VPWR VPWR _6346_/A sky130_fd_sc_hd__buf_2
XFILLER_8_757 VGND VGND VPWR VPWR sky130_fd_sc_hd__decap_3
XFILLER_7_245 VGND VGND VPWR VPWR sky130_fd_sc_hd__decap_3
XFILLER_11_296 VGND VGND VPWR VPWR sky130_fd_sc_hd__decap_3
XFILLER_50_50 VGND VGND VPWR VPWR sky130_fd_sc_hd__decap_3
XFILLER_125_600 VGND VGND VPWR VPWR sky130_fd_sc_hd__decap_3
XFILLER_7_278 VGND VGND VPWR VPWR sky130_fd_sc_hd__fill_2
XFILLER_124_121 VGND VGND VPWR VPWR sky130_fd_sc_hd__decap_3
XTAP_TAPCELL_ROW_55_1027 VGND VPWR sky130_fd_sc_hd__tapvpwrvgnd_1
XFILLER_3_462 VGND VGND VPWR VPWR sky130_fd_sc_hd__decap_3
XFILLER_124_165 VGND VGND VPWR VPWR sky130_fd_sc_hd__decap_3
XFILLER_79_720 VGND VGND VPWR VPWR sky130_fd_sc_hd__decap_3
XFILLER_105_390 VGND VGND VPWR VPWR sky130_fd_sc_hd__fill_2
XFILLER_79_753 VGND VGND VPWR VPWR sky130_fd_sc_hd__decap_3
XFILLER_59_70 VGND VGND VPWR VPWR sky130_fd_sc_hd__decap_3
XFILLER_78_241 VGND VGND VPWR VPWR sky130_fd_sc_hd__decap_3
XFILLER_94_701 VGND VGND VPWR VPWR sky130_fd_sc_hd__decap_3
XFILLER_66_403 VGND VGND VPWR VPWR sky130_fd_sc_hd__fill_1
XFILLER_39_617 VGND VGND VPWR VPWR sky130_fd_sc_hd__decap_3
XFILLER_22_6 VGND VGND VPWR VPWR sky130_fd_sc_hd__decap_3
XFILLER_38_105 VGND VGND VPWR VPWR sky130_fd_sc_hd__decap_3
XFILLER_93_222 VGND VGND VPWR VPWR sky130_fd_sc_hd__fill_2
XFILLER_66_436 VGND VGND VPWR VPWR sky130_fd_sc_hd__decap_3
XFILLER_66_469 VGND VGND VPWR VPWR sky130_fd_sc_hd__decap_3
XFILLER_54_609 VGND VGND VPWR VPWR sky130_fd_sc_hd__decap_3
XFILLER_53_119 VGND VGND VPWR VPWR sky130_fd_sc_hd__decap_3
XFILLER_34_300 VGND VGND VPWR VPWR sky130_fd_sc_hd__fill_2
XFILLER_19_385 VGND VGND VPWR VPWR sky130_fd_sc_hd__decap_3
X_5830_ _5830_/A _5830_/B _5830_/C VGND VGND VPWR VPWR _5984_/C sky130_fd_sc_hd__and3_2
XFILLER_62_664 VGND VGND VPWR VPWR sky130_fd_sc_hd__decap_3
XFILLER_61_141 VGND VGND VPWR VPWR sky130_fd_sc_hd__decap_3
XTAP_TAPCELL_ROW_66_1167 VGND VPWR sky130_fd_sc_hd__tapvpwrvgnd_1
XTAP_TAPCELL_ROW_66_1178 VGND VPWR sky130_fd_sc_hd__tapvpwrvgnd_1
XFILLER_34_377 VGND VGND VPWR VPWR sky130_fd_sc_hd__decap_3
XTAP_TAPCELL_ROW_45_884 VGND VPWR sky130_fd_sc_hd__tapvpwrvgnd_1
XFILLER_22_528 VGND VGND VPWR VPWR sky130_fd_sc_hd__fill_1
X_5761_ _5760_/A _5760_/B _5760_/C VGND VGND VPWR VPWR _5761_/Y sky130_fd_sc_hd__a21oi_2
XTAP_TAPCELL_ROW_45_895 VGND VPWR sky130_fd_sc_hd__tapvpwrvgnd_1
X_7500_ _7375_/A _7375_/B _7496_/B _7380_/B VGND VGND VPWR VPWR _7500_/X sky130_fd_sc_hd__a31o_2
X_4712_ hold872/X _4712_/A1 _4714_/S VGND VGND VPWR VPWR _4713_/A sky130_fd_sc_hd__mux2_2
X_8480_ _8514_/A VGND VGND VPWR VPWR _8480_/Y sky130_fd_sc_hd__inv_2
X_5692_ _5692_/A1 _5613_/Y _5617_/Y _5626_/Y _5627_/Y VGND VGND VPWR VPWR _5692_/Y
+ sky130_fd_sc_hd__a41oi_4
XFILLER_30_561 VGND VGND VPWR VPWR sky130_fd_sc_hd__decap_3
X_7431_ _7337_/Y _7429_/X _7430_/X VGND VGND VPWR VPWR _7431_/X sky130_fd_sc_hd__o21a_4
X_4643_ _4643_/A VGND VGND VPWR VPWR _9071_/D sky130_fd_sc_hd__buf_1
X_7362_ _8248_/B _7481_/S VGND VGND VPWR VPWR _7365_/A sky130_fd_sc_hd__nor2_2
X_4574_ _4574_/A VGND VGND VPWR VPWR _9038_/D sky130_fd_sc_hd__buf_1
X_9101_ _9171_/CLK _9101_/D load_slew393/X VGND VGND VPWR VPWR _9101_/Q sky130_fd_sc_hd__dfrtp_2
XFILLER_115_110 VGND VGND VPWR VPWR sky130_fd_sc_hd__fill_2
X_6313_ _5019_/X _5272_/X _6313_/B1 _6196_/B VGND VGND VPWR VPWR _6579_/B sky130_fd_sc_hd__a211oi_2
X_7293_ _7293_/A _7293_/B VGND VGND VPWR VPWR _7299_/A sky130_fd_sc_hd__xnor2_2
XFILLER_116_666 VGND VGND VPWR VPWR sky130_fd_sc_hd__decap_3
Xhold757 input2/X VGND VGND VPWR VPWR hold757/X sky130_fd_sc_hd__dlygate4sd3_1
Xhold768 _5101_/Y VGND VGND VPWR VPWR hold768/X sky130_fd_sc_hd__dlygate4sd3_1
X_9032_ _9348_/CLK _9032_/D load_slew404/X VGND VGND VPWR VPWR _9032_/Q sky130_fd_sc_hd__dfrtp_2
X_6244_ _9207_/Q _6680_/B _6244_/C VGND VGND VPWR VPWR _6246_/B sky130_fd_sc_hd__and3_2
Xhold779 _8808_/X VGND VGND VPWR VPWR _8809_/A sky130_fd_sc_hd__dlygate4sd3_1
XPHY_EDGE_ROW_123_Right_123 VGND VGND VPWR VPWR sky130_fd_sc_hd__decap_3
XFILLER_116_699 VGND VGND VPWR VPWR sky130_fd_sc_hd__fill_1
XFILLER_130_113 VGND VGND VPWR VPWR sky130_fd_sc_hd__decap_3
X_6175_ _6174_/A _6013_/B _6011_/A VGND VGND VPWR VPWR _6175_/X sky130_fd_sc_hd__a21o_2
XFILLER_97_561 VGND VGND VPWR VPWR sky130_fd_sc_hd__decap_3
XFILLER_85_701 VGND VGND VPWR VPWR sky130_fd_sc_hd__decap_3
XTAP_TAPCELL_ROW_90_1496 VGND VPWR sky130_fd_sc_hd__tapvpwrvgnd_1
XFILLER_69_263 VGND VGND VPWR VPWR sky130_fd_sc_hd__fill_1
X_5126_ _5126_/A VGND VGND VPWR VPWR _5126_/X sky130_fd_sc_hd__buf_2
XFILLER_84_211 VGND VGND VPWR VPWR sky130_fd_sc_hd__decap_3
XFILLER_111_371 VGND VGND VPWR VPWR sky130_fd_sc_hd__decap_3
XFILLER_29_127 VGND VGND VPWR VPWR sky130_fd_sc_hd__decap_3
XFILLER_85_756 VGND VGND VPWR VPWR sky130_fd_sc_hd__fill_2
XFILLER_111_393 VGND VGND VPWR VPWR sky130_fd_sc_hd__decap_3
XFILLER_57_458 VGND VGND VPWR VPWR sky130_fd_sc_hd__decap_3
XFILLER_45_609 VGND VGND VPWR VPWR sky130_fd_sc_hd__decap_3
XFILLER_55_28 VGND VGND VPWR VPWR sky130_fd_sc_hd__decap_3
XFILLER_38_661 VGND VGND VPWR VPWR sky130_fd_sc_hd__decap_3
XFILLER_84_288 VGND VGND VPWR VPWR sky130_fd_sc_hd__fill_2
XFILLER_25_300 VGND VGND VPWR VPWR sky130_fd_sc_hd__fill_2
XFILLER_84_299 VGND VGND VPWR VPWR sky130_fd_sc_hd__decap_3
XFILLER_65_480 VGND VGND VPWR VPWR sky130_fd_sc_hd__decap_3
XFILLER_53_631 VGND VGND VPWR VPWR sky130_fd_sc_hd__fill_1
XFILLER_37_182 VGND VGND VPWR VPWR sky130_fd_sc_hd__decap_3
XFILLER_111_12 VGND VGND VPWR VPWR sky130_fd_sc_hd__decap_3
X_8816_ _9253_/Q _6857_/B _8820_/S VGND VGND VPWR VPWR _8816_/X sky130_fd_sc_hd__mux2_2
XFILLER_52_141 VGND VGND VPWR VPWR sky130_fd_sc_hd__fill_2
XFILLER_111_45 VGND VGND VPWR VPWR sky130_fd_sc_hd__decap_3
XFILLER_13_517 VGND VGND VPWR VPWR sky130_fd_sc_hd__decap_3
XFILLER_53_686 VGND VGND VPWR VPWR sky130_fd_sc_hd__fill_2
XFILLER_52_163 VGND VGND VPWR VPWR sky130_fd_sc_hd__decap_3
XFILLER_25_377 VGND VGND VPWR VPWR sky130_fd_sc_hd__fill_1
XFILLER_25_388 VGND VGND VPWR VPWR sky130_fd_sc_hd__decap_3
X_8747_ _8210_/B _8741_/A _7561_/A _8774_/C1 VGND VGND VPWR VPWR _8747_/X sky130_fd_sc_hd__o211a_2
XFILLER_111_78 VGND VGND VPWR VPWR sky130_fd_sc_hd__decap_3
X_5959_ _5795_/B _5956_/Y _5958_/X _6395_/A VGND VGND VPWR VPWR _5960_/B sky130_fd_sc_hd__o2bb2a_2
XFILLER_80_494 VGND VGND VPWR VPWR sky130_fd_sc_hd__decap_3
X_8678_ _8678_/A _8678_/B VGND VGND VPWR VPWR _8715_/A sky130_fd_sc_hd__xnor2_2
XTAP_TAPCELL_ROW_23_589 VGND VPWR sky130_fd_sc_hd__tapvpwrvgnd_1
X_7629_ _7458_/A _7458_/B _7458_/C VGND VGND VPWR VPWR _7836_/C sky130_fd_sc_hd__a21boi_2
XFILLER_21_594 VGND VGND VPWR VPWR sky130_fd_sc_hd__decap_3
XFILLER_107_600 VGND VGND VPWR VPWR sky130_fd_sc_hd__decap_3
XFILLER_5_727 VGND VGND VPWR VPWR sky130_fd_sc_hd__fill_1
XFILLER_5_738 VGND VGND VPWR VPWR sky130_fd_sc_hd__decap_3
XFILLER_119_493 VGND VGND VPWR VPWR sky130_fd_sc_hd__decap_3
XFILLER_105_3 VGND VGND VPWR VPWR sky130_fd_sc_hd__decap_3
XFILLER_107_666 VGND VGND VPWR VPWR sky130_fd_sc_hd__decap_3
XFILLER_4_259 VGND VGND VPWR VPWR sky130_fd_sc_hd__decap_3
XFILLER_20_53 VGND VGND VPWR VPWR sky130_fd_sc_hd__fill_1
XFILLER_121_102 VGND VGND VPWR VPWR sky130_fd_sc_hd__decap_3
XFILLER_122_636 VGND VGND VPWR VPWR sky130_fd_sc_hd__decap_3
XFILLER_121_113 VGND VGND VPWR VPWR sky130_fd_sc_hd__decap_3
XFILLER_96_24 VGND VGND VPWR VPWR sky130_fd_sc_hd__decap_3
XFILLER_0_421 VGND VGND VPWR VPWR sky130_fd_sc_hd__decap_3
XFILLER_122_658 VGND VGND VPWR VPWR sky130_fd_sc_hd__fill_1
XFILLER_122_669 VGND VGND VPWR VPWR sky130_fd_sc_hd__decap_3
XFILLER_121_146 VGND VGND VPWR VPWR sky130_fd_sc_hd__decap_3
XFILLER_76_745 VGND VGND VPWR VPWR sky130_fd_sc_hd__decap_3
XFILLER_130_691 VGND VGND VPWR VPWR sky130_fd_sc_hd__decap_3
XFILLER_75_222 VGND VGND VPWR VPWR sky130_fd_sc_hd__fill_2
XFILLER_90_214 VGND VGND VPWR VPWR sky130_fd_sc_hd__decap_3
XTAP_TAPCELL_ROW_106_1713 VGND VPWR sky130_fd_sc_hd__tapvpwrvgnd_1
XFILLER_91_748 VGND VGND VPWR VPWR sky130_fd_sc_hd__decap_3
XFILLER_56_480 VGND VGND VPWR VPWR sky130_fd_sc_hd__decap_3
XFILLER_28_171 VGND VGND VPWR VPWR sky130_fd_sc_hd__decap_3
XFILLER_16_333 VGND VGND VPWR VPWR sky130_fd_sc_hd__decap_3
XFILLER_43_152 VGND VGND VPWR VPWR sky130_fd_sc_hd__decap_3
XTAP_TAPCELL_ROW_42_843 VGND VPWR sky130_fd_sc_hd__tapvpwrvgnd_1
XTAP_TAPCELL_ROW_42_854 VGND VPWR sky130_fd_sc_hd__tapvpwrvgnd_1
XFILLER_31_369 VGND VGND VPWR VPWR sky130_fd_sc_hd__fill_1
XFILLER_129_202 VGND VGND VPWR VPWR sky130_fd_sc_hd__decap_3
XFILLER_61_60 VGND VGND VPWR VPWR sky130_fd_sc_hd__fill_2
XFILLER_12_572 VGND VGND VPWR VPWR sky130_fd_sc_hd__decap_3
XFILLER_61_71 VGND VGND VPWR VPWR sky130_fd_sc_hd__fill_2
XFILLER_8_554 VGND VGND VPWR VPWR sky130_fd_sc_hd__decap_3
XANTENNA_4 _5262_/B VGND VGND VPWR VPWR sky130_fd_sc_hd__diode_2
XFILLER_6_44 VGND VGND VPWR VPWR sky130_fd_sc_hd__decap_3
XTAP_TAPCELL_ROW_117_1864 VGND VPWR sky130_fd_sc_hd__tapvpwrvgnd_1
XFILLER_125_430 VGND VGND VPWR VPWR sky130_fd_sc_hd__decap_3
XFILLER_98_303 VGND VGND VPWR VPWR sky130_fd_sc_hd__decap_3
XFILLER_4_760 VGND VGND VPWR VPWR sky130_fd_sc_hd__decap_3
XFILLER_125_496 VGND VGND VPWR VPWR sky130_fd_sc_hd__decap_3
XFILLER_98_347 VGND VGND VPWR VPWR sky130_fd_sc_hd__decap_3
XFILLER_3_281 VGND VGND VPWR VPWR sky130_fd_sc_hd__decap_3
XFILLER_3_292 VGND VGND VPWR VPWR sky130_fd_sc_hd__fill_1
XFILLER_79_550 VGND VGND VPWR VPWR sky130_fd_sc_hd__decap_3
XFILLER_79_561 VGND VGND VPWR VPWR sky130_fd_sc_hd__decap_3
XFILLER_20_3 VGND VGND VPWR VPWR sky130_fd_sc_hd__decap_3
XFILLER_79_594 VGND VGND VPWR VPWR sky130_fd_sc_hd__fill_2
XFILLER_94_542 VGND VGND VPWR VPWR sky130_fd_sc_hd__fill_1
XFILLER_94_553 VGND VGND VPWR VPWR sky130_fd_sc_hd__decap_3
XFILLER_39_469 VGND VGND VPWR VPWR sky130_fd_sc_hd__fill_2
XFILLER_27_609 VGND VGND VPWR VPWR sky130_fd_sc_hd__decap_3
X_7980_ _7981_/A _7981_/B VGND VGND VPWR VPWR _7980_/Y sky130_fd_sc_hd__nand2_2
XFILLER_82_704 VGND VGND VPWR VPWR sky130_fd_sc_hd__decap_3
X_6931_ _6934_/B _6944_/B VGND VGND VPWR VPWR _6931_/Y sky130_fd_sc_hd__nand2_2
XFILLER_82_748 VGND VGND VPWR VPWR sky130_fd_sc_hd__decap_3
XFILLER_54_439 VGND VGND VPWR VPWR sky130_fd_sc_hd__decap_3
XFILLER_66_299 VGND VGND VPWR VPWR sky130_fd_sc_hd__decap_3
XFILLER_47_480 VGND VGND VPWR VPWR sky130_fd_sc_hd__decap_3
XFILLER_35_620 VGND VGND VPWR VPWR sky130_fd_sc_hd__decap_3
X_6862_ _7729_/C1 _6859_/A _7153_/A input6/X VGND VGND VPWR VPWR _6862_/X sky130_fd_sc_hd__a22o_2
XFILLER_34_141 VGND VGND VPWR VPWR sky130_fd_sc_hd__decap_3
X_8601_ _8654_/S _8626_/B VGND VGND VPWR VPWR _8676_/B sky130_fd_sc_hd__xnor2_2
XFILLER_62_472 VGND VGND VPWR VPWR sky130_fd_sc_hd__decap_3
XFILLER_50_612 VGND VGND VPWR VPWR sky130_fd_sc_hd__decap_3
XFILLER_34_163 VGND VGND VPWR VPWR sky130_fd_sc_hd__fill_1
X_5813_ _5813_/A _5813_/B VGND VGND VPWR VPWR _5813_/Y sky130_fd_sc_hd__nand2_2
XFILLER_62_483 VGND VGND VPWR VPWR sky130_fd_sc_hd__fill_2
X_6793_ _6885_/A _6793_/B VGND VGND VPWR VPWR _6793_/Y sky130_fd_sc_hd__xnor2_2
XFILLER_22_336 VGND VGND VPWR VPWR sky130_fd_sc_hd__decap_3
XFILLER_22_347 VGND VGND VPWR VPWR sky130_fd_sc_hd__fill_2
X_8532_ _9224_/Q wire67/X VGND VGND VPWR VPWR _8532_/Y sky130_fd_sc_hd__nor2_2
X_5744_ wire122/X _6546_/A2 _5743_/Y VGND VGND VPWR VPWR _6957_/B sky130_fd_sc_hd__a21oi_2
X_8463_ _8463_/A _8463_/B VGND VGND VPWR VPWR _8463_/X sky130_fd_sc_hd__and2_2
X_5675_ _5674_/Y _5537_/X _5936_/A VGND VGND VPWR VPWR _5675_/X sky130_fd_sc_hd__mux2_2
XFILLER_30_380 VGND VGND VPWR VPWR sky130_fd_sc_hd__decap_3
XFILLER_108_408 VGND VGND VPWR VPWR sky130_fd_sc_hd__decap_3
XTAP_TAPCELL_ROW_20_548 VGND VPWR sky130_fd_sc_hd__tapvpwrvgnd_1
X_7414_ _7408_/Y _7412_/X _8050_/A VGND VGND VPWR VPWR _7421_/D sky130_fd_sc_hd__a21o_4
XTAP_TAPCELL_ROW_79_1347 VGND VPWR sky130_fd_sc_hd__tapvpwrvgnd_1
X_4626_ _4626_/A VGND VGND VPWR VPWR _9063_/D sky130_fd_sc_hd__buf_1
X_8394_ _8379_/A _8374_/B _8369_/X _8370_/Y VGND VGND VPWR VPWR _8394_/X sky130_fd_sc_hd__o211a_2
X_7345_ _7346_/A _7346_/B _7346_/C _7346_/D VGND VGND VPWR VPWR _7635_/A sky130_fd_sc_hd__a22o_2
X_4557_ _4557_/A VGND VGND VPWR VPWR _9030_/D sky130_fd_sc_hd__buf_1
XFILLER_104_603 VGND VGND VPWR VPWR sky130_fd_sc_hd__decap_3
XTAP_TAPCELL_ROW_92_1525 VGND VPWR sky130_fd_sc_hd__tapvpwrvgnd_1
XFILLER_2_719 VGND VGND VPWR VPWR sky130_fd_sc_hd__decap_3
XFILLER_116_463 VGND VGND VPWR VPWR sky130_fd_sc_hd__decap_3
Xmax_cap273 _6111_/X VGND VGND VPWR VPWR _6117_/B2 sky130_fd_sc_hd__buf_6
X_7276_ _7275_/Y _7273_/X _7024_/B VGND VGND VPWR VPWR _7280_/B sky130_fd_sc_hd__a21o_2
XFILLER_103_113 VGND VGND VPWR VPWR sky130_fd_sc_hd__decap_3
XFILLER_106_12 VGND VGND VPWR VPWR sky130_fd_sc_hd__decap_3
X_9015_ _9348_/Q _9015_/A1 _9015_/S VGND VGND VPWR VPWR _9015_/X sky130_fd_sc_hd__mux2_2
X_6227_ _9046_/Q _6757_/B _6607_/B VGND VGND VPWR VPWR _6227_/X sky130_fd_sc_hd__and3_2
XFILLER_58_701 VGND VGND VPWR VPWR sky130_fd_sc_hd__fill_1
X_6158_ _6158_/A _6158_/B VGND VGND VPWR VPWR _6163_/A sky130_fd_sc_hd__nand2_2
XFILLER_97_380 VGND VGND VPWR VPWR sky130_fd_sc_hd__fill_1
Xhold1210 _5530_/X VGND VGND VPWR VPWR _5531_/B sky130_fd_sc_hd__dlygate4sd3_1
XFILLER_85_531 VGND VGND VPWR VPWR sky130_fd_sc_hd__decap_3
XFILLER_57_222 VGND VGND VPWR VPWR sky130_fd_sc_hd__fill_2
Xhold1221 _5235_/X VGND VGND VPWR VPWR _5313_/A0 sky130_fd_sc_hd__dlygate4sd3_1
Xhold1232 _5562_/X VGND VGND VPWR VPWR _5651_/A2 sky130_fd_sc_hd__dlygate4sd3_1
XFILLER_58_767 VGND VGND VPWR VPWR sky130_fd_sc_hd__decap_3
X_5109_ _5109_/A VGND VGND VPWR VPWR _5135_/A sky130_fd_sc_hd__buf_1
Xhold1243 _9230_/Q VGND VGND VPWR VPWR _8711_/A sky130_fd_sc_hd__dlygate4sd3_1
XFILLER_85_564 VGND VGND VPWR VPWR sky130_fd_sc_hd__fill_2
X_6089_ _6091_/A _6089_/B VGND VGND VPWR VPWR _6089_/Y sky130_fd_sc_hd__nor2_2
Xhold1254 _9206_/Q VGND VGND VPWR VPWR _5815_/A0 sky130_fd_sc_hd__dlygate4sd3_1
XFILLER_85_575 VGND VGND VPWR VPWR sky130_fd_sc_hd__decap_3
XFILLER_72_203 VGND VGND VPWR VPWR sky130_fd_sc_hd__fill_1
XFILLER_72_225 VGND VGND VPWR VPWR sky130_fd_sc_hd__decap_3
XFILLER_122_44 VGND VGND VPWR VPWR sky130_fd_sc_hd__decap_3
XTAP_TAPCELL_ROW_28_659 VGND VPWR sky130_fd_sc_hd__tapvpwrvgnd_1
XFILLER_26_642 VGND VGND VPWR VPWR sky130_fd_sc_hd__fill_2
XFILLER_122_77 VGND VGND VPWR VPWR sky130_fd_sc_hd__decap_3
XTAP_TAPCELL_ROW_0_262 VGND VPWR sky130_fd_sc_hd__tapvpwrvgnd_1
XFILLER_122_88 VGND VGND VPWR VPWR sky130_fd_sc_hd__decap_3
XFILLER_26_675 VGND VGND VPWR VPWR sky130_fd_sc_hd__fill_2
XTAP_TAPCELL_ROW_0_273 VGND VPWR sky130_fd_sc_hd__tapvpwrvgnd_1
XTAP_TAPCELL_ROW_0_284 VGND VPWR sky130_fd_sc_hd__tapvpwrvgnd_1
XFILLER_13_303 VGND VGND VPWR VPWR sky130_fd_sc_hd__fill_2
XFILLER_26_697 VGND VGND VPWR VPWR sky130_fd_sc_hd__decap_3
XFILLER_13_314 VGND VGND VPWR VPWR sky130_fd_sc_hd__fill_2
XFILLER_53_494 VGND VGND VPWR VPWR sky130_fd_sc_hd__decap_3
XFILLER_80_280 VGND VGND VPWR VPWR sky130_fd_sc_hd__decap_3
XFILLER_25_196 VGND VGND VPWR VPWR sky130_fd_sc_hd__fill_2
XFILLER_15_75 VGND VGND VPWR VPWR sky130_fd_sc_hd__decap_3
XTAP_TAPCELL_ROW_101_1643 VGND VPWR sky130_fd_sc_hd__tapvpwrvgnd_1
XFILLER_13_369 VGND VGND VPWR VPWR sky130_fd_sc_hd__decap_3
XFILLER_9_329 VGND VGND VPWR VPWR sky130_fd_sc_hd__decap_3
XFILLER_40_166 VGND VGND VPWR VPWR sky130_fd_sc_hd__decap_3
XFILLER_127_706 VGND VGND VPWR VPWR sky130_fd_sc_hd__decap_3
XFILLER_21_391 VGND VGND VPWR VPWR sky130_fd_sc_hd__fill_1
XFILLER_31_41 VGND VGND VPWR VPWR sky130_fd_sc_hd__fill_1
Xrebuffer662 _6655_/Y VGND VGND VPWR VPWR _6781_/A sky130_fd_sc_hd__buf_2
XFILLER_5_524 VGND VGND VPWR VPWR sky130_fd_sc_hd__fill_2
XFILLER_31_63 VGND VGND VPWR VPWR sky130_fd_sc_hd__fill_2
XFILLER_126_227 VGND VGND VPWR VPWR sky130_fd_sc_hd__decap_3
Xrebuffer684 _6117_/X VGND VGND VPWR VPWR _6428_/A1 sky130_fd_sc_hd__buf_2
XFILLER_107_441 VGND VGND VPWR VPWR sky130_fd_sc_hd__fill_1
XFILLER_5_557 VGND VGND VPWR VPWR sky130_fd_sc_hd__decap_3
XTAP_TAPCELL_ROW_130_2039 VGND VPWR sky130_fd_sc_hd__tapvpwrvgnd_1
XFILLER_122_400 VGND VGND VPWR VPWR sky130_fd_sc_hd__decap_3
XFILLER_107_485 VGND VGND VPWR VPWR sky130_fd_sc_hd__fill_2
Xoutput30 _9184_/Q VGND VGND VPWR VPWR wire224/A sky130_fd_sc_hd__buf_1
XFILLER_1_741 VGND VGND VPWR VPWR sky130_fd_sc_hd__decap_3
XFILLER_95_306 VGND VGND VPWR VPWR sky130_fd_sc_hd__decap_3
XFILLER_0_240 VGND VGND VPWR VPWR sky130_fd_sc_hd__decap_3
XFILLER_122_477 VGND VGND VPWR VPWR sky130_fd_sc_hd__decap_3
XTAP_TAPCELL_ROW_8_384 VGND VPWR sky130_fd_sc_hd__tapvpwrvgnd_1
XFILLER_1_774 VGND VGND VPWR VPWR sky130_fd_sc_hd__decap_3
XFILLER_0_262 VGND VGND VPWR VPWR sky130_fd_sc_hd__decap_3
XTAP_TAPCELL_ROW_8_395 VGND VPWR sky130_fd_sc_hd__tapvpwrvgnd_1
XTAP_TAPCELL_ROW_112_1794 VGND VPWR sky130_fd_sc_hd__tapvpwrvgnd_1
XFILLER_110_639 VGND VGND VPWR VPWR sky130_fd_sc_hd__decap_3
XFILLER_49_745 VGND VGND VPWR VPWR sky130_fd_sc_hd__decap_3
XFILLER_0_284 VGND VGND VPWR VPWR sky130_fd_sc_hd__decap_3
XFILLER_48_233 VGND VGND VPWR VPWR sky130_fd_sc_hd__decap_3
XFILLER_76_553 VGND VGND VPWR VPWR sky130_fd_sc_hd__decap_3
XFILLER_49_767 VGND VGND VPWR VPWR sky130_fd_sc_hd__decap_3
XTAP_TAPCELL_ROW_47_913 VGND VPWR sky130_fd_sc_hd__tapvpwrvgnd_1
XFILLER_91_501 VGND VGND VPWR VPWR sky130_fd_sc_hd__decap_3
XFILLER_76_586 VGND VGND VPWR VPWR sky130_fd_sc_hd__fill_2
XFILLER_63_214 VGND VGND VPWR VPWR sky130_fd_sc_hd__fill_1
XFILLER_36_428 VGND VGND VPWR VPWR sky130_fd_sc_hd__fill_2
XFILLER_91_534 VGND VGND VPWR VPWR sky130_fd_sc_hd__decap_3
XFILLER_63_225 VGND VGND VPWR VPWR sky130_fd_sc_hd__decap_3
XFILLER_17_620 VGND VGND VPWR VPWR sky130_fd_sc_hd__decap_3
XFILLER_91_556 VGND VGND VPWR VPWR sky130_fd_sc_hd__decap_3
XFILLER_17_642 VGND VGND VPWR VPWR sky130_fd_sc_hd__decap_3
XFILLER_91_567 VGND VGND VPWR VPWR sky130_fd_sc_hd__decap_3
XFILLER_16_141 VGND VGND VPWR VPWR sky130_fd_sc_hd__decap_3
XFILLER_72_770 VGND VGND VPWR VPWR sky130_fd_sc_hd__decap_3
XFILLER_32_612 VGND VGND VPWR VPWR sky130_fd_sc_hd__fill_2
XTAP_TAPCELL_ROW_63_1126 VGND VPWR sky130_fd_sc_hd__tapvpwrvgnd_1
XTAP_TAPCELL_ROW_63_1137 VGND VPWR sky130_fd_sc_hd__tapvpwrvgnd_1
XFILLER_31_122 VGND VGND VPWR VPWR sky130_fd_sc_hd__fill_2
XFILLER_72_81 VGND VGND VPWR VPWR sky130_fd_sc_hd__decap_3
XFILLER_31_188 VGND VGND VPWR VPWR sky130_fd_sc_hd__decap_3
XFILLER_12_380 VGND VGND VPWR VPWR sky130_fd_sc_hd__decap_3
XFILLER_8_340 VGND VGND VPWR VPWR sky130_fd_sc_hd__decap_3
XFILLER_118_728 VGND VGND VPWR VPWR sky130_fd_sc_hd__decap_3
XFILLER_8_362 VGND VGND VPWR VPWR sky130_fd_sc_hd__fill_2
X_5460_ _5446_/A _5458_/X _5459_/X VGND VGND VPWR VPWR _5460_/X sky130_fd_sc_hd__a21o_2
XFILLER_68_3 VGND VGND VPWR VPWR sky130_fd_sc_hd__decap_3
XFILLER_117_238 VGND VGND VPWR VPWR sky130_fd_sc_hd__decap_3
XFILLER_8_395 VGND VGND VPWR VPWR sky130_fd_sc_hd__decap_3
X_5391_ _5019_/X _5272_/X _6313_/B1 _5279_/A VGND VGND VPWR VPWR _5391_/Y sky130_fd_sc_hd__a211oi_2
XFILLER_126_772 VGND VGND VPWR VPWR sky130_fd_sc_hd__decap_3
X_7130_ _7127_/Y _7128_/X _7374_/A _7374_/B VGND VGND VPWR VPWR _7388_/B sky130_fd_sc_hd__a211oi_4
XFILLER_98_100 VGND VGND VPWR VPWR sky130_fd_sc_hd__decap_3
XFILLER_113_411 VGND VGND VPWR VPWR sky130_fd_sc_hd__decap_3
XFILLER_99_645 VGND VGND VPWR VPWR sky130_fd_sc_hd__decap_3
Xfanout308 wire316/A VGND VGND VPWR VPWR _6460_/S sky130_fd_sc_hd__clkdlybuf4s25_1
XTAP_TAPCELL_ROW_74_1277 VGND VPWR sky130_fd_sc_hd__tapvpwrvgnd_1
XFILLER_98_144 VGND VGND VPWR VPWR sky130_fd_sc_hd__fill_1
X_7061_ _7357_/A _7357_/C _7358_/A1 VGND VGND VPWR VPWR _7063_/B sky130_fd_sc_hd__a21o_2
XFILLER_113_455 VGND VGND VPWR VPWR sky130_fd_sc_hd__decap_3
XFILLER_101_606 VGND VGND VPWR VPWR sky130_fd_sc_hd__fill_1
XFILLER_101_617 VGND VGND VPWR VPWR sky130_fd_sc_hd__decap_3
XFILLER_86_306 VGND VGND VPWR VPWR sky130_fd_sc_hd__fill_2
X_6012_ _5272_/X _5019_/X _6313_/B1 _6550_/B VGND VGND VPWR VPWR _6174_/B sky130_fd_sc_hd__a211o_4
XFILLER_98_188 VGND VGND VPWR VPWR sky130_fd_sc_hd__decap_3
.ends
